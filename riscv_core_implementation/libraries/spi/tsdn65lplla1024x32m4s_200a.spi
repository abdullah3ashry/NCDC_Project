**** Created by MC2: Version 2006.09.01.d on 2025/07/22, 15:52:49

* tsmcn65lpdpsram Version 120A.RC1 20070119

.GLOBAL VDD,VSS

* DP_SRAM_HVT_TSMC_CLN65LP_V1D1.HSPICE.LIB
* GENERATED TUE JAN 16 16:33:32 EST 2007
* BIT41
.SUBCKT SDL400W20S_BIT41 AWTI A_BWEB A_BWEBM A_CKD A_D A_DLRS A_DM
+	 A_WENB_3 A_WENB_2 A_WENB_1 A_WENB_0 BISTC BISTT B_BWEB
+	 B_BWEBM B_CKD B_D B_DLRS B_DM B_WENB_3 B_WENB_2 B_WENB_1
+	 B_WENB_0 A_GWDC A_GWDT A_Q B_GWDC B_GWDT B_Q A_GRDC A_GRDT
+	 B_GRDC B_GRDT
M1 XDINA_Z12 A_DHC VDD VDD pch
+ l=0.06U
+ w=0.42U
M2 VDD XGWDVA_Z5 XGWDVA_Z7 VDD
+ pch_hvt l=0.06U
+	 w=0.56U
M3 XDINA_Z12 XDINA_CLKC XDINA_Z4 VDD
+ pch l=0.06U
+	 w=0.21U
M4 VDD XGWDVA_Z5 XGWDVA_Z7 VDD
+ pch_hvt l=0.06U
+	 w=0.56U
M5 XDINA_Z4 XDINA_DC XDINA_Z9 VDD
+ pch l=0.1U
+ w=0.42U
M6 VDD XGWDVA_Z7 A_GWDC VDD pch_hvt
+ l=0.07U
+ w=1.4U
M7 VDD XGWDVA_Z7 A_GWDC VDD pch_hvt
+ l=0.07U
+ w=1.4U
M8 XDINA_Z9 A_CKD VDD VDD pch
+ l=0.06U
+ w=0.21U
M9 VDD XGWDVA_Z7 A_GWDC VDD pch_hvt
+ l=0.07U
+ w=1.4U
M10 VDD XDINA_Z4 A_DHC VDD pch
+ l=0.06U
+ w=0.42U
M11 VDD XGWDVA_Z7 A_GWDC VDD pch_hvt
+ l=0.07U
+ w=1.4U
M12 VDD XDINA_Z4 A_DHC VDD pch
+ l=0.06U
+ w=0.42U
M13 VDD XGWDVA_Z8 A_GWDT VDD pch_hvt
+ l=0.07U
+ w=1.4U
M14 VDD XDINA_Z8 A_BWH VDD pch
+ l=0.06U
+ w=0.42U
M15 A_MX XDOUTA_QCKT XDOUTA_Z1 VDD pch
+ l=0.06U
+ w=0.82U
M16 VDD XGWDVA_Z8 A_GWDT VDD pch_hvt
+ l=0.07U
+ w=1.4U
M17 A_BWH XDINA_Z8 VSS VSS nch
+ l=0.06U
+ w=0.41U
M18 VDD XDINA_Z8 A_BWH VDD pch
+ l=0.06U
+ w=0.42U
M19 VDD A_DHT XGWDVA_Z4 VDD pch_hvt
+ l=0.06U
+ w=0.41U
M20 VDD XGWDVA_Z8 A_GWDT VDD pch_hvt
+ l=0.07U
+ w=1.4U
M21 VSS A_BWH XDINA_Z14 VSS nch
+ l=0.06U
+ w=0.21U
M22 VDD XDOUTA_Z7 XDOUTA_Z1 VDD pch
+ l=0.06U
+ w=0.82U
M23 VDD A_WENB_0 XGWDVA_Z4 VDD pch_hvt
+ l=0.06U
+ w=0.41U
M24 VDD A_CKD XDINA_Z13 VDD pch
+ l=0.06U
+ w=0.21U
M25 VDD A_MX A_Q VDD pch
+ l=0.06U
+ w=0.75U
M26 XDINA_Z14 A_CKD XDINA_Z8 VSS nch
+ l=0.06U
+ w=0.21U
M27 VDD XGWDVA_Z8 A_GWDT VDD pch_hvt
+ l=0.07U
+ w=1.4U
M28 XDINA_Z13 XDINA_BWC XDINA_Z8 VDD
+ pch l=0.1U
+ w=0.42U
M29 VDD A_MX A_Q VDD pch
+ l=0.06U
+ w=0.75U
M30 VDD A_BWH XGWDVA_Z4 VDD pch_hvt
+ l=0.06U
+ w=0.41U
M31 XDINA_Z15 XDINA_BWC XDINA_Z8 VSS
+ nch l=0.1U
+ w=0.21U
M32 VDD XGWDVA_Z6 XGWDVA_Z8 VDD
+ pch_hvt l=0.06U
+	 w=0.56U
M33 XDINA_Z16 XDINA_CLKC XDINA_Z8 VDD
+ pch l=0.06U
+	 w=0.21U
M34 VDD A_MX A_Q VDD pch
+ l=0.06U
+ w=0.75U
M35 VDD XGWDVA_Z4 XGWDVA_Z6 VDD
+ pch_hvt l=0.06U
+	 w=0.41U
M36 XDINA_Z16 A_BWH VDD VDD pch
+ l=0.06U
+ w=0.42U
M37 VDD A_MX A_Q VDD pch
+ l=0.06U
+ w=0.75U
M38 VDD A_GRDC XGMXA_Z2 VDD pch
+ l=0.06U
+ w=0.41U
M39 VDD XGWDVA_Z4 XGWDVA_Z6 VDD
+ pch_hvt l=0.06U
+	 w=0.41U
M40 VDD XDINA_BWT XDINA_BWC VDD pch
+ l=0.1U
+ w=0.42U
M41 VDD A_BWH XDINA_Z17 VDD pch
+ l=0.06U
+ w=0.42U
M42 VDD A_BWH XDINA_Z17 VDD pch
+ l=0.06U
+ w=0.42U
M43 XDINA_Z19 XDINA_BWC VDD VDD pch
+ l=0.06U
+ w=0.42U
M44 VDD A_CKD XDINA_CLKC VDD pch
+ l=0.06U
+ w=0.21U
M45 XDINA_Z18 XDINA_BWT VDD VDD pch
+ l=0.06U
+ w=0.42U
M46 XDINA_Z18 XDINA_DT A_AWTD VDD pch
+ l=0.06U
+ w=0.42U
M47 A_AWTD XDINA_DC XDINA_Z19 VDD pch
+ l=0.06U
+ w=0.42U
M48 VDD A_DHC A_DHT VDD pch
+ l=0.06U
+ w=0.42U
M49 VDD A_DHC A_DHT VDD pch
+ l=0.06U
+ w=0.42U
M50 VDD XDINA_DT XDINA_DC VDD pch
+ l=0.1U
+ w=0.42U
M51 XDINA_Z26 A_BWEBM VDD VDD pch
+ l=0.1U
+ w=0.42U
M52 VDD XDINA_BWX XDINA_BWT VDD pch
+ l=0.1U
+ w=0.42U
M53 XDINA_Z26 BISTC XDINA_BWX VDD pch
+ l=0.1U
+ w=0.42U
M54 XDINA_BWX BISTT XDINA_Z25 VDD pch
+ l=0.1U
+ w=0.42U
M55 XDINA_Z25 A_BWEB VDD VDD pch
+ l=0.1U
+ w=0.42U
M56 XDINA_DX BISTC XDINA_Z22 VDD pch
+ l=0.1U
+ w=0.42U
M57 XDINA_Z21 BISTT XDINA_DX VDD pch
+ l=0.1U
+ w=0.42U
M58 VDD A_D XDINA_Z21 VDD pch
+ l=0.1U
+ w=0.42U
M59 VDD XDINA_DX XDINA_DT VDD pch
+ l=0.1U
+ w=0.42U
M60 XDINA_Z22 A_DM VDD VDD pch
+ l=0.1U
+ w=0.42U
M61 VDD A_DLRS XDOUTA_DLRSB VDD pch_hvt
+ l=0.06U
+ w=0.21U
M62 VDD XGWDVA_Z6 XGWDVA_Z8 VDD
+ pch_hvt l=0.06U
+	 w=0.56U
M63 VDD XGMXA_Z2 A_GRDC VDD pch_hvt
+ l=0.12U
+ w=0.21U
M64 VSS XDINA_CLKC XDINA_Z15 VSS nch
+ l=0.06U
+ w=0.21U
M65 XGMXA_GRDTB A_GRDT VSS VSS nch
+ l=0.06U
+ w=0.41U
M66 XGMXA_GRDTB A_GRDT VSS VSS nch
+ l=0.06U
+ w=0.41U
M67 XGMXA_Z3 XGMXA_Z2 VSS VSS nch
+ l=0.06U
+ w=0.41U
M68 XGMXA_DLRSB A_DLRS VSS VSS nch
+ l=0.06U
+ w=0.41U
M69 A_QLATCH XGMXA_Z1 VSS VSS nch
+ l=0.06U
+ w=0.41U
M70 A_QLATCH XGMXA_Z1 VSS VSS nch
+ l=0.06U
+ w=0.41U
M71 A_MX XGMXA_GRDTB A_MXN VSS nch
+ l=0.06U
+ w=0.6U
M72 A_MX XGMXA_GRDTB A_MXN VSS nch
+ l=0.06U
+ w=0.6U
M73 A_MX XGMXA_GRDTB A_MXN VSS nch
+ l=0.06U
+ w=0.6U
M74 A_MX XGMXA_GRDTB A_MXN VSS nch
+ l=0.06U
+ w=0.6U
M75 VDD A_GRDT XGMXA_GRDTB VDD pch
+ l=0.06U
+ w=1.1U
M76 VDD A_GRDT XGMXA_GRDTB VDD pch
+ l=0.06U
+ w=1.1U
M77 VDD XGMXA_DLRSB A_GRDT VDD pch
+ l=0.06U
+ w=1.14U
M78 VDD XGMXA_DLRSB A_GRDT VDD pch
+ l=0.06U
+ w=1.14U
M79 VDD XGMXA_DLRSB A_GRDT VDD pch
+ l=0.06U
+ w=1.14U
M80 A_GRDC XGMXA_DLRSB VDD VDD pch
+ l=0.06U
+ w=1.14U
M81 A_GRDC XGMXA_DLRSB VDD VDD pch
+ l=0.06U
+ w=1.14U
M82 A_GRDC XGMXA_DLRSB VDD VDD pch
+ l=0.06U
+ w=1.14U
M83 VDD XGMXA_Z2 XGMXA_Z3 VDD pch
+ l=0.06U
+ w=0.41U
M84 A_QLATCH XGMXA_Z3 VDD VDD pch
+ l=0.06U
+ w=0.82U
M85 A_QLATCH XGMXA_Z3 VDD VDD pch
+ l=0.06U
+ w=0.82U
M86 VDD A_DLRS XGMXA_DLRSB VDD pch
+ l=0.06U
+ w=0.82U
M87 A_MX A_GRDC A_MXP VDD pch
+ l=0.06U
+ w=0.75U
M88 A_MX A_GRDC A_MXP VDD pch
+ l=0.06U
+ w=0.75U
M89 A_MX A_GRDC A_MXP VDD pch
+ l=0.06U
+ w=0.75U
M90 A_MX A_GRDC A_MXP VDD pch
+ l=0.06U
+ w=0.75U
M91 VDD A_GRDT XGMXA_Z1 VDD pch
+ l=0.06U
+ w=0.41U
M92 VDD A_GRDT A_GRDC VDD pch
+ l=0.06U
+ w=0.41U
M93 A_GRDT A_GRDC VDD VDD pch
+ l=0.06U
+ w=0.41U
M94 VDD XGMXA_Z1 A_GRDT VDD pch_hvt
+ l=0.12U
+ w=0.21U
M95 XGMXA_Z1 A_GRDT VSS VSS nch
+ l=0.06U
+ w=0.21U
M96 XDINA_Z28 A_BWEBM VSS VSS nch
+ l=0.1U
+ w=0.21U
M97 XDINA_BWT XDINA_BWX VSS VSS nch
+ l=0.1U
+ w=0.21U
M98 XDINA_Z28 BISTT XDINA_BWX VSS nch
+ l=0.1U
+ w=0.21U
M99 XDINA_Z23 BISTC XDINA_DX VSS nch
+ l=0.1U
+ w=0.21U
M100 XDINA_Z27 BISTC XDINA_BWX VSS nch
+ l=0.1U
+ w=0.21U
M101 XDINA_Z27 A_BWEB VSS VSS nch
+ l=0.1U
+ w=0.21U
M102 XDINA_Z24 BISTT XDINA_DX VSS nch
+ l=0.1U
+ w=0.21U
M103 XDINA_Z23 A_D VSS VSS nch
+ l=0.1U
+ w=0.21U
M104 XDINA_DT XDINA_DX VSS VSS nch
+ l=0.1U
+ w=0.21U
M105 XDINA_Z24 A_DM VSS VSS nch
+ l=0.1U
+ w=0.21U
M106 XDINA_BWC XDINA_BWT VSS VSS nch
+ l=0.1U
+ w=0.21U
M107 XDINA_Z17 A_BWH VSS VSS nch
+ l=0.06U
+ w=0.41U
M108 A_DHT A_DHC VSS VSS nch
+ l=0.06U
+ w=0.41U
M109 XDINA_DC XDINA_DT VSS VSS nch
+ l=0.1U
+ w=0.21U
M110 XDINA_Z20 XDINA_BWC VSS VSS nch
+ l=0.06U
+	 w=0.21U
M111 XDINA_CLKC A_CKD VSS VSS nch
+ l=0.06U
+ w=0.21U
M112 A_AWTD XDINA_BWT XDINA_Z20 VSS nch
+ l=0.06U
+	 w=0.21U
M113 A_AWTD XDINA_DT XDINA_Z20 VSS nch
+ l=0.06U
+	 w=0.21U
M114 XDINA_Z20 XDINA_DC VSS VSS nch
+ l=0.06U
+	 w=0.21U
M115 XDINA_Z10 A_DHC VSS VSS nch
+ l=0.06U
+ w=0.21U
M116 A_DHC XDINA_Z4 VSS VSS nch
+ l=0.06U
+ w=0.41U
M117 XDINA_Z11 XDINA_DC XDINA_Z4 VSS
+ nch l=0.1U
+ w=0.21U
M118 XDINA_Z11 XDINA_CLKC VSS VSS nch
+ l=0.06U
+ w=0.21U
M119 XDINA_Z10 A_CKD XDINA_Z4 VSS nch
+ l=0.06U
+ w=0.21U
M120 VSS A_AWTD XDOUTA_Z4 VSS nch_hvt
+ l=0.06U
+ w=0.21U
M121 A_MXN XDOUTA_AWTC VSS VSS nch_hvt
+ l=0.06U
+ w=0.8U
M122 A_MXN XDOUTA_AWTC VSS VSS nch_hvt
+ l=0.06U
+ w=0.8U
M123 A_MXN XDOUTA_AWTC VSS VSS nch_hvt
+ l=0.06U
+ w=0.8U
M124 XDOUTA_Z6 XDOUTA_AWTC XDOUTA_Z7 VSS
+ nch_hvt l=0.06U
+	 w=0.21U
M125 XDOUTA_Z4 XDOUTA_AWTT XDOUTA_Z7 VSS
+ nch_hvt l=0.06U
+	 w=0.21U
M126 XDOUTA_Z6 A_QLATCH VSS VSS nch_hvt
+ l=0.06U
+ w=0.21U
M127 VDD XDOUTA_DLRSB XDOUTA_QCKC VDD pch_hvt
+ l=0.06U
+ w=0.41U
M128 VDD XDOUTA_QCKC XDOUTA_QCKT VDD pch_hvt
+ l=0.06U
+ w=0.41U
M129 VDD AWTI XDOUTA_AWTC VDD pch_hvt
+ l=0.06U
+ w=0.42U
M130 VDD XDOUTA_AWTC XDOUTA_QCKC VDD pch_hvt
+ l=0.06U
+ w=0.41U
M131 VDD XDOUTA_AWTC XDOUTA_AWTT VDD pch_hvt
+ l=0.06U
+ w=0.42U
M132 VDD XDOUTA_Z8 A_QLATCH VDD pch_hvt
+ l=0.12U
+ w=0.32U
M133 XDOUTA_Z3 XDOUTA_AWTC XDOUTA_Z7 VDD
+ pch_hvt l=0.06U
+	 w=0.42U
M134 VDD A_AWTD XDOUTA_Z3 VDD pch_hvt
+ l=0.06U
+ w=0.42U
M135 VDD XDOUTA_AWTT A_MXP VDD pch_hvt
+ l=0.06U
+ w=1U
M136 VDD XDOUTA_AWTT A_MXP VDD pch_hvt
+ l=0.06U
+ w=1U
M137 VDD XDOUTA_AWTT A_MXP VDD pch_hvt
+ l=0.06U
+ w=1U
M138 XDOUTA_Z7 XDOUTA_AWTT XDOUTA_Z5 VDD
+ pch_hvt l=0.06U
+	 w=0.42U
M139 VDD A_QLATCH XDOUTA_Z8 VDD pch_hvt
+ l=0.08U
+ w=0.42U
M140 XDOUTA_Z5 A_QLATCH VDD VDD pch_hvt
+ l=0.06U
+ w=0.42U
M141 XDOUTA_XI31_NET9 XDOUTA_DLRSB XDOUTA_QCKC
+ VSS nch_hvt l=0.06U
+	 w=0.41U
M142 XDOUTA_QCKT XDOUTA_QCKC VSS VSS nch_hvt
+ l=0.06U
+ w=0.21U
M143 XDOUTA_AWTC AWTI VSS VSS nch_hvt
+ l=0.06U
+ w=0.21U
M144 VSS XDOUTA_AWTC XDOUTA_XI31_NET9 VSS
+ nch_hvt l=0.06U
+	 w=0.41U
M145 XDOUTA_AWTT XDOUTA_AWTC VSS VSS nch_hvt
+ l=0.06U
+ w=0.21U
M146 A_QLATCH XDOUTA_Z8 VSS VSS nch_hvt
+ l=0.16U
+ w=0.21U
M147 XDOUTA_Z8 A_QLATCH VSS VSS nch_hvt
+ l=0.08U
+ w=0.21U
M148 XGWDVA_Z1 A_WENB_0 XGWDVA_Z2 VSS
+ nch_hvt l=0.06U
+	 w=0.41U
M149 XGWDVA_Z5 XGWDVA_Z3 VSS VSS
+ nch_hvt l=0.06U
+	 w=0.41U
M150 XGWDVA_Z4 A_DHT XGWDVA_Z2 VSS nch_hvt
+ l=0.06U
+ w=0.41U
M151 VSS A_BWH XGWDVA_Z1 VSS nch_hvt
+ l=0.06U
+ w=0.41U
M152 XGWDVA_Z3 A_DHC XGWDVA_Z2 VSS nch_hvt
+ l=0.06U
+ w=0.41U
M153 VDD A_WENB_0 XGWDVA_Z3 VDD pch_hvt
+ l=0.06U
+ w=0.41U
M154 VDD XGWDVA_Z3 XGWDVA_Z5 VDD
+ pch_hvt l=0.06U
+	 w=0.41U
M155 VDD XGWDVA_Z3 XGWDVA_Z5 VDD
+ pch_hvt l=0.06U
+	 w=0.41U
M156 VDD A_BWH XGWDVA_Z3 VDD pch_hvt
+ l=0.06U
+ w=0.41U
M157 VDD A_DHC XGWDVA_Z3 VDD pch_hvt
+ l=0.06U
+ w=0.41U
M158 XGWDVA_Z7 XGWDVA_Z5 VSS VSS
+ nch_hvt l=0.06U
+	 w=0.56U
M159 XGWDVA_Z7 XGWDVA_Z5 VSS VSS
+ nch_hvt l=0.06U
+	 w=0.56U
M160 XGWDVA_Z8 XGWDVA_Z6 VSS VSS
+ nch_hvt l=0.06U
+	 w=0.56U
M161 XGWDVA_Z8 XGWDVA_Z6 VSS VSS
+ nch_hvt l=0.06U
+	 w=0.56U
M162 A_GWDC XGWDVA_Z7 VSS VSS nch_hvt
+ l=0.06U
+ w=0.56U
M163 A_GWDC XGWDVA_Z7 VSS VSS nch_hvt
+ l=0.06U
+ w=0.56U
M164 A_GWDC XGWDVA_Z7 VSS VSS nch_hvt
+ l=0.06U
+ w=0.56U
M165 A_GWDC XGWDVA_Z7 VSS VSS nch_hvt
+ l=0.06U
+ w=0.56U
M166 A_GWDT XGWDVA_Z8 VSS VSS nch_hvt
+ l=0.06U
+ w=0.56U
M167 A_GWDT XGWDVA_Z8 VSS VSS nch_hvt
+ l=0.06U
+ w=0.56U
M168 A_GWDT XGWDVA_Z8 VSS VSS nch_hvt
+ l=0.06U
+ w=0.56U
M169 A_GWDT XGWDVA_Z8 VSS VSS nch_hvt
+ l=0.06U
+ w=0.56U
M170 VDD B_MX B_Q VDD pch
+ l=0.06U
+ w=0.75U
M171 VDD B_GRDC XGMXB_Z2 VDD pch
+ l=0.06U
+ w=0.41U
M172 VDD XGWDVB_Z4 XGWDVB_Z6 VDD
+ pch_hvt l=0.06U
+	 w=0.41U
M173 XDINB_Z16 B_BWH VDD VDD pch
+ l=0.06U
+ w=0.42U
M174 VDD B_DLRS XDOUTB_DLRSB VDD pch_hvt
+ l=0.06U
+ w=0.21U
M175 VDD XGWDVB_Z6 XGWDVB_Z8 VDD
+ pch_hvt l=0.06U
+	 w=0.56U
M176 XDINB_Z15 XDINB_CLKC VSS VSS nch
+ l=0.06U
+ w=0.21U
M177 VDD XGMXB_Z2 B_GRDC VDD pch_hvt
+ l=0.12U
+ w=0.21U
M178 VDD B_MX B_Q VDD pch
+ l=0.06U
+ w=0.75U
M179 XDINB_Z16 XDINB_CLKC XDINB_Z8 VDD
+ pch l=0.06U
+	 w=0.21U
M180 VDD XGWDVB_Z4 XGWDVB_Z6 VDD
+ pch_hvt l=0.06U
+	 w=0.41U
M181 VDD B_MX B_Q VDD pch
+ l=0.06U
+ w=0.75U
M182 VDD XGWDVB_Z6 XGWDVB_Z8 VDD
+ pch_hvt l=0.06U
+	 w=0.56U
M183 XDINB_Z15 XDINB_BWC XDINB_Z8 VSS
+ nch l=0.1U
+ w=0.21U
M184 VDD B_BWH XGWDVB_Z4 VDD pch_hvt
+ l=0.06U
+ w=0.41U
M185 XDINB_Z13 XDINB_BWC XDINB_Z8 VDD
+ pch l=0.1U
+ w=0.42U
M186 XDINB_Z14 B_CKD XDINB_Z8 VSS nch
+ l=0.06U
+ w=0.21U
M187 VDD XGWDVB_Z8 B_GWDT VDD pch_hvt
+ l=0.07U
+ w=1.4U
M188 VDD B_MX B_Q VDD pch
+ l=0.06U
+ w=0.75U
M189 VDD B_WENB_0 XGWDVB_Z4 VDD pch_hvt
+ l=0.06U
+ w=0.41U
M190 VDD XGWDVB_Z8 B_GWDT VDD pch_hvt
+ l=0.07U
+ w=1.4U
M191 VDD B_CKD XDINB_Z13 VDD pch
+ l=0.06U
+ w=0.21U
M192 VDD XDOUTB_Z7 XDOUTB_Z1 VDD pch
+ l=0.06U
+ w=0.82U
M193 VSS B_BWH XDINB_Z14 VSS nch
+ l=0.06U
+ w=0.21U
M194 VDD B_DHT XGWDVB_Z4 VDD pch_hvt
+ l=0.06U
+ w=0.41U
M195 B_MX XDOUTB_QCKT XDOUTB_Z1 VDD pch
+ l=0.06U
+ w=0.82U
M196 VDD XGWDVB_Z8 B_GWDT VDD pch_hvt
+ l=0.07U
+ w=1.4U
M197 VDD XDINB_Z8 B_BWH VDD pch
+ l=0.06U
+ w=0.42U
M198 B_BWH XDINB_Z8 VSS VSS nch
+ l=0.06U
+ w=0.41U
M199 VDD XGWDVB_Z8 B_GWDT VDD pch_hvt
+ l=0.07U
+ w=1.4U
M200 VDD XDINB_Z8 B_BWH VDD pch
+ l=0.06U
+ w=0.42U
M201 VDD XGWDVB_Z7 B_GWDC VDD pch_hvt
+ l=0.07U
+ w=1.4U
M202 VDD XDINB_Z4 B_DHC VDD pch
+ l=0.06U
+ w=0.42U
M203 VDD XGWDVB_Z7 B_GWDC VDD pch_hvt
+ l=0.07U
+ w=1.4U
M204 VDD XDINB_Z4 B_DHC VDD pch
+ l=0.06U
+ w=0.42U
M205 VDD XGWDVB_Z7 B_GWDC VDD pch_hvt
+ l=0.07U
+ w=1.4U
M206 XDINB_Z9 B_CKD VDD VDD pch
+ l=0.06U
+ w=0.21U
M207 VDD XGWDVB_Z7 B_GWDC VDD pch_hvt
+ l=0.07U
+ w=1.4U
M208 XDINB_Z4 XDINB_DC XDINB_Z9 VDD
+ pch l=0.1U
+ w=0.42U
M209 VDD XGWDVB_Z5 XGWDVB_Z7 VDD
+ pch_hvt l=0.06U
+	 w=0.56U
M210 XDINB_Z12 XDINB_CLKC XDINB_Z4 VDD
+ pch l=0.06U
+	 w=0.21U
M211 XDINB_Z12 B_DHC VDD VDD pch
+ l=0.06U
+ w=0.42U
M212 VDD XGWDVB_Z5 XGWDVB_Z7 VDD
+ pch_hvt l=0.06U
+	 w=0.56U
M213 VDD XDINB_BWT XDINB_BWC VDD pch
+ l=0.1U
+ w=0.42U
M214 VDD B_BWH XDINB_Z17 VDD pch
+ l=0.06U
+ w=0.42U
M215 VDD B_BWH XDINB_Z17 VDD pch
+ l=0.06U
+ w=0.42U
M216 XDINB_Z19 XDINB_BWC VDD VDD pch
+ l=0.06U
+ w=0.42U
M217 VDD B_CKD XDINB_CLKC VDD pch
+ l=0.06U
+ w=0.21U
M218 XDINB_Z18 XDINB_BWT VDD VDD pch
+ l=0.06U
+ w=0.42U
M219 XDINB_Z18 XDINB_DT B_AWTD VDD pch
+ l=0.06U
+ w=0.42U
M220 B_AWTD XDINB_DC XDINB_Z19 VDD pch
+ l=0.06U
+ w=0.42U
M221 VDD B_DHC B_DHT VDD pch
+ l=0.06U
+ w=0.42U
M222 VDD B_DHC B_DHT VDD pch
+ l=0.06U
+ w=0.42U
M223 VDD XDINB_DT XDINB_DC VDD pch
+ l=0.1U
+ w=0.42U
M224 XDINB_Z26 B_BWEBM VDD VDD pch
+ l=0.1U
+ w=0.42U
M225 VDD XDINB_BWX XDINB_BWT VDD pch
+ l=0.1U
+ w=0.42U
M226 XDINB_Z26 BISTC XDINB_BWX VDD pch
+ l=0.1U
+ w=0.42U
M227 XDINB_BWX BISTT XDINB_Z25 VDD pch
+ l=0.1U
+ w=0.42U
M228 XDINB_Z25 B_BWEB VDD VDD pch
+ l=0.1U
+ w=0.42U
M229 XDINB_DX BISTC XDINB_Z22 VDD pch
+ l=0.1U
+ w=0.42U
M230 XDINB_Z21 BISTT XDINB_DX VDD pch
+ l=0.1U
+ w=0.42U
M231 VDD B_D XDINB_Z21 VDD pch
+ l=0.1U
+ w=0.42U
M232 VDD XDINB_DX XDINB_DT VDD pch
+ l=0.1U
+ w=0.42U
M233 XDINB_Z22 B_DM VDD VDD pch
+ l=0.1U
+ w=0.42U
M234 XDINB_Z28 B_BWEBM VSS VSS nch
+ l=0.1U
+ w=0.21U
M235 XDINB_BWT XDINB_BWX VSS VSS nch
+ l=0.1U
+ w=0.21U
M236 XDINB_Z28 BISTT XDINB_BWX VSS nch
+ l=0.1U
+ w=0.21U
M237 XDINB_Z23 BISTC XDINB_DX VSS nch
+ l=0.1U
+ w=0.21U
M238 XDINB_Z27 BISTC XDINB_BWX VSS nch
+ l=0.1U
+ w=0.21U
M239 XDINB_Z27 B_BWEB VSS VSS nch
+ l=0.1U
+ w=0.21U
M240 XDINB_Z24 BISTT XDINB_DX VSS nch
+ l=0.1U
+ w=0.21U
M241 XDINB_Z23 B_D VSS VSS nch
+ l=0.1U
+ w=0.21U
M242 XDINB_DT XDINB_DX VSS VSS nch
+ l=0.1U
+ w=0.21U
M243 XDINB_Z24 B_DM VSS VSS nch
+ l=0.1U
+ w=0.21U
M244 XDINB_BWC XDINB_BWT VSS VSS nch
+ l=0.1U
+ w=0.21U
M245 XDINB_Z17 B_BWH VSS VSS nch
+ l=0.06U
+ w=0.41U
M246 B_DHT B_DHC VSS VSS nch
+ l=0.06U
+ w=0.41U
M247 XDINB_DC XDINB_DT VSS VSS nch
+ l=0.1U
+ w=0.21U
M248 XDINB_Z20 XDINB_BWC VSS VSS nch
+ l=0.06U
+	 w=0.21U
M249 XDINB_CLKC B_CKD VSS VSS nch
+ l=0.06U
+ w=0.21U
M250 B_AWTD XDINB_BWT XDINB_Z20 VSS nch
+ l=0.06U
+	 w=0.21U
M251 B_AWTD XDINB_DT XDINB_Z20 VSS nch
+ l=0.06U
+	 w=0.21U
M252 XDINB_Z20 XDINB_DC VSS VSS nch
+ l=0.06U
+	 w=0.21U
M253 XDINB_Z10 B_DHC VSS VSS nch
+ l=0.06U
+ w=0.21U
M254 B_DHC XDINB_Z4 VSS VSS nch
+ l=0.06U
+ w=0.41U
M255 XDINB_Z11 XDINB_DC XDINB_Z4 VSS
+ nch l=0.1U
+ w=0.21U
M256 XDINB_Z11 XDINB_CLKC VSS VSS nch
+ l=0.06U
+ w=0.21U
M257 XDINB_Z10 B_CKD XDINB_Z4 VSS nch
+ l=0.06U
+ w=0.21U
M258 VSS B_AWTD XDOUTB_Z4 VSS nch_hvt
+ l=0.06U
+ w=0.21U
M259 B_MXN XDOUTB_AWTC VSS VSS nch_hvt
+ l=0.06U
+ w=0.8U
M260 B_MXN XDOUTB_AWTC VSS VSS nch_hvt
+ l=0.06U
+ w=0.8U
M261 B_MXN XDOUTB_AWTC VSS VSS nch_hvt
+ l=0.06U
+ w=0.8U
M262 XDOUTB_Z6 XDOUTB_AWTC XDOUTB_Z7 VSS
+ nch_hvt l=0.06U
+	 w=0.21U
M263 XDOUTB_Z4 XDOUTB_AWTT XDOUTB_Z7 VSS
+ nch_hvt l=0.06U
+	 w=0.21U
M264 XDOUTB_Z6 B_QLATCH VSS VSS nch_hvt
+ l=0.06U
+ w=0.21U
M265 VDD XDOUTB_DLRSB XDOUTB_QCKC VDD pch_hvt
+ l=0.06U
+ w=0.41U
M266 VDD XDOUTB_QCKC XDOUTB_QCKT VDD pch_hvt
+ l=0.06U
+ w=0.41U
M267 VDD AWTI XDOUTB_AWTC VDD pch_hvt
+ l=0.06U
+ w=0.42U
M268 VDD XDOUTB_AWTC XDOUTB_QCKC VDD pch_hvt
+ l=0.06U
+ w=0.41U
M269 VDD XDOUTB_AWTC XDOUTB_AWTT VDD pch_hvt
+ l=0.06U
+ w=0.42U
M270 VDD XDOUTB_Z8 B_QLATCH VDD pch_hvt
+ l=0.12U
+ w=0.32U
M271 XDOUTB_Z3 XDOUTB_AWTC XDOUTB_Z7 VDD
+ pch_hvt l=0.06U
+	 w=0.42U
M272 VDD B_AWTD XDOUTB_Z3 VDD pch_hvt
+ l=0.06U
+ w=0.42U
M273 VDD XDOUTB_AWTT B_MXP VDD pch_hvt
+ l=0.06U
+ w=1U
M274 VDD XDOUTB_AWTT B_MXP VDD pch_hvt
+ l=0.06U
+ w=1U
M275 VDD XDOUTB_AWTT B_MXP VDD pch_hvt
+ l=0.06U
+ w=1U
M276 XDOUTB_Z7 XDOUTB_AWTT XDOUTB_Z5 VDD
+ pch_hvt l=0.06U
+	 w=0.42U
M277 VDD B_QLATCH XDOUTB_Z8 VDD pch_hvt
+ l=0.08U
+ w=0.42U
M278 XDOUTB_Z5 B_QLATCH VDD VDD pch_hvt
+ l=0.06U
+ w=0.42U
M279 XDOUTB_XI31_NET9 XDOUTB_DLRSB XDOUTB_QCKC
+ VSS nch_hvt l=0.06U
+	 w=0.41U
M280 XDOUTB_QCKT XDOUTB_QCKC VSS VSS nch_hvt
+ l=0.06U
+ w=0.21U
M281 XDOUTB_AWTC AWTI VSS VSS nch_hvt
+ l=0.06U
+ w=0.21U
M282 VSS XDOUTB_AWTC XDOUTB_XI31_NET9 VSS
+ nch_hvt l=0.06U
+	 w=0.41U
M283 XDOUTB_AWTT XDOUTB_AWTC VSS VSS nch_hvt
+ l=0.06U
+ w=0.21U
M284 B_QLATCH XDOUTB_Z8 VSS VSS nch_hvt
+ l=0.16U
+ w=0.21U
M285 XDOUTB_Z8 B_QLATCH VSS VSS nch_hvt
+ l=0.08U
+ w=0.21U
M286 XGMXB_GRDTB B_GRDT VSS VSS nch
+ l=0.06U
+ w=0.41U
M287 XGMXB_GRDTB B_GRDT VSS VSS nch
+ l=0.06U
+ w=0.41U
M288 XGMXB_Z3 XGMXB_Z2 VSS VSS nch
+ l=0.06U
+ w=0.41U
M289 XGMXB_DLRSB B_DLRS VSS VSS nch
+ l=0.06U
+ w=0.41U
M290 B_QLATCH XGMXB_Z1 VSS VSS nch
+ l=0.06U
+ w=0.41U
M291 B_QLATCH XGMXB_Z1 VSS VSS nch
+ l=0.06U
+ w=0.41U
M292 B_MX XGMXB_GRDTB B_MXN VSS nch
+ l=0.06U
+ w=0.6U
M293 B_MX XGMXB_GRDTB B_MXN VSS nch
+ l=0.06U
+ w=0.6U
M294 B_MX XGMXB_GRDTB B_MXN VSS nch
+ l=0.06U
+ w=0.6U
M295 B_MX XGMXB_GRDTB B_MXN VSS nch
+ l=0.06U
+ w=0.6U
M296 VDD B_GRDT XGMXB_GRDTB VDD pch
+ l=0.06U
+ w=1.1U
M297 VDD B_GRDT XGMXB_GRDTB VDD pch
+ l=0.06U
+ w=1.1U
M298 VDD XGMXB_DLRSB B_GRDT VDD pch
+ l=0.06U
+ w=1.14U
M299 VDD XGMXB_DLRSB B_GRDT VDD pch
+ l=0.06U
+ w=1.14U
M300 VDD XGMXB_DLRSB B_GRDT VDD pch
+ l=0.06U
+ w=1.14U
M301 B_GRDC XGMXB_DLRSB VDD VDD pch
+ l=0.06U
+ w=1.14U
M302 B_GRDC XGMXB_DLRSB VDD VDD pch
+ l=0.06U
+ w=1.14U
M303 B_GRDC XGMXB_DLRSB VDD VDD pch
+ l=0.06U
+ w=1.14U
M304 VDD XGMXB_Z2 XGMXB_Z3 VDD pch
+ l=0.06U
+ w=0.41U
M305 B_QLATCH XGMXB_Z3 VDD VDD pch
+ l=0.06U
+ w=0.82U
M306 B_QLATCH XGMXB_Z3 VDD VDD pch
+ l=0.06U
+ w=0.82U
M307 VDD B_DLRS XGMXB_DLRSB VDD pch
+ l=0.06U
+ w=0.82U
M308 B_MX B_GRDC B_MXP VDD pch
+ l=0.06U
+ w=0.75U
M309 B_MX B_GRDC B_MXP VDD pch
+ l=0.06U
+ w=0.75U
M310 B_MX B_GRDC B_MXP VDD pch
+ l=0.06U
+ w=0.75U
M311 B_MX B_GRDC B_MXP VDD pch
+ l=0.06U
+ w=0.75U
M312 VDD B_GRDT XGMXB_Z1 VDD pch
+ l=0.06U
+ w=0.41U
M313 VDD B_GRDT B_GRDC VDD pch
+ l=0.06U
+ w=0.41U
M314 B_GRDT B_GRDC VDD VDD pch
+ l=0.06U
+ w=0.41U
M315 VDD XGMXB_Z1 B_GRDT VDD pch_hvt
+ l=0.12U
+ w=0.21U
M316 XGMXB_Z1 B_GRDT VSS VSS nch
+ l=0.06U
+ w=0.21U
M317 XDOUTB_DLRSB B_DLRS VSS VSS nch_hvt
+ l=0.06U
+ w=0.21U
M318 XDOUTA_DLRSB A_DLRS VSS VSS nch_hvt
+ l=0.06U
+ w=0.21U
M319 XGWDVB_Z6 XGWDVB_Z4 VSS VSS
+ nch_hvt l=0.06U
+	 w=0.41U
M320 XGWDVA_Z6 XGWDVA_Z4 VSS VSS
+ nch_hvt l=0.06U
+	 w=0.41U
M321 B_MX XDOUTB_QCKC XDOUTB_Z2 VSS nch
+ l=0.06U
+ w=0.42U
M322 XDOUTB_Z2 XDOUTB_Z7 VSS VSS nch
+ l=0.06U
+ w=0.42U
M323 B_Q B_MX VSS VSS nch
+ l=0.06U
+ w=0.375U
M324 B_Q B_MX VSS VSS nch
+ l=0.06U
+ w=0.375U
M325 B_Q B_MX VSS VSS nch
+ l=0.06U
+ w=0.375U
M326 B_Q B_MX VSS VSS nch
+ l=0.06U
+ w=0.375U
M327 A_MX XDOUTA_QCKC XDOUTA_Z2 VSS nch
+ l=0.06U
+ w=0.42U
M328 XDOUTA_Z2 XDOUTA_Z7 VSS VSS nch
+ l=0.06U
+ w=0.42U
M329 A_Q A_MX VSS VSS nch
+ l=0.06U
+ w=0.375U
M330 A_Q A_MX VSS VSS nch
+ l=0.06U
+ w=0.375U
M331 A_Q A_MX VSS VSS nch
+ l=0.06U
+ w=0.375U
M332 A_Q A_MX VSS VSS nch
+ l=0.06U
+ w=0.375U
M333 XGMXA_Z2 A_GRDC VSS VSS nch
+ l=0.06U
+ w=0.21U
M334 XGMXB_Z2 B_GRDC VSS VSS nch
+ l=0.06U
+ w=0.21U
M335 XGWDVB_Z1 B_WENB_0 XGWDVB_Z2 VSS
+ nch_hvt l=0.06U
+	 w=0.41U
M336 XGWDVB_Z5 XGWDVB_Z3 VSS VSS
+ nch_hvt l=0.06U
+	 w=0.41U
M337 XGWDVB_Z4 B_DHT XGWDVB_Z2 VSS nch_hvt
+ l=0.06U
+ w=0.41U
M338 VSS B_BWH XGWDVB_Z1 VSS nch_hvt
+ l=0.06U
+ w=0.41U
M339 XGWDVB_Z3 B_DHC XGWDVB_Z2 VSS nch_hvt
+ l=0.06U
+ w=0.41U
M340 VDD B_WENB_0 XGWDVB_Z3 VDD pch_hvt
+ l=0.06U
+ w=0.41U
M341 VDD XGWDVB_Z3 XGWDVB_Z5 VDD
+ pch_hvt l=0.06U
+	 w=0.41U
M342 VDD XGWDVB_Z3 XGWDVB_Z5 VDD
+ pch_hvt l=0.06U
+	 w=0.41U
M343 VDD B_BWH XGWDVB_Z3 VDD pch_hvt
+ l=0.06U
+ w=0.41U
M344 VDD B_DHC XGWDVB_Z3 VDD pch_hvt
+ l=0.06U
+ w=0.41U
M345 XGWDVB_Z7 XGWDVB_Z5 VSS VSS
+ nch_hvt l=0.06U
+	 w=0.56U
M346 XGWDVB_Z7 XGWDVB_Z5 VSS VSS
+ nch_hvt l=0.06U
+	 w=0.56U
M347 XGWDVB_Z8 XGWDVB_Z6 VSS VSS
+ nch_hvt l=0.06U
+	 w=0.56U
M348 XGWDVB_Z8 XGWDVB_Z6 VSS VSS
+ nch_hvt l=0.06U
+	 w=0.56U
M349 B_GWDC XGWDVB_Z7 VSS VSS nch_hvt
+ l=0.06U
+ w=0.56U
M350 B_GWDC XGWDVB_Z7 VSS VSS nch_hvt
+ l=0.06U
+ w=0.56U
M351 B_GWDC XGWDVB_Z7 VSS VSS nch_hvt
+ l=0.06U
+ w=0.56U
M352 B_GWDC XGWDVB_Z7 VSS VSS nch_hvt
+ l=0.06U
+ w=0.56U
M353 B_GWDT XGWDVB_Z8 VSS VSS nch_hvt
+ l=0.06U
+ w=0.56U
M354 B_GWDT XGWDVB_Z8 VSS VSS nch_hvt
+ l=0.06U
+ w=0.56U
M355 B_GWDT XGWDVB_Z8 VSS VSS nch_hvt
+ l=0.06U
+ w=0.56U
M356 B_GWDT XGWDVB_Z8 VSS VSS nch_hvt
+ l=0.06U
+ w=0.56U
.ENDS
* BIT81
.SUBCKT SDL400W20S_BIT81 AWTI A_BWEB A_BWEBM A_CKD A_D A_DLRS A_DM
+	 A_WENB_3 A_WENB_2 A_WENB_1 A_WENB_0 BISTC BISTT B_BWEB
+	 B_BWEBM B_CKD B_D B_DLRS B_DM B_WENB_3 B_WENB_2 B_WENB_1
+	 B_WENB_0 A_GWDC A_GWDT A_Q B_GWDC B_GWDT B_Q A_GRDC A_GRDT
+	 B_GRDC B_GRDT
M357 XDINA_Z12 A_DHC VDD VDD pch
+ l=0.06U
+ w=0.42U
M358 VDD XGWDVA_Z5 XGWDVA_Z7 VDD
+ pch_hvt l=0.06U
+	 w=0.56U
M359 XDINA_Z12 XDINA_CLKC XDINA_Z4 VDD
+ pch l=0.06U
+	 w=0.21U
M360 VDD XGWDVA_Z5 XGWDVA_Z7 VDD
+ pch_hvt l=0.06U
+	 w=0.56U
M361 XDINA_Z4 XDINA_DC XDINA_Z9 VDD
+ pch l=0.1U
+ w=0.42U
M362 VDD XGWDVA_Z7 A_GWDC VDD pch_hvt
+ l=0.07U
+ w=1.4U
M363 VDD XGWDVA_Z7 A_GWDC VDD pch_hvt
+ l=0.07U
+ w=1.4U
M364 XDINA_Z9 A_CKD VDD VDD pch
+ l=0.06U
+ w=0.21U
M365 VDD XGWDVA_Z7 A_GWDC VDD pch_hvt
+ l=0.07U
+ w=1.4U
M366 VDD XDINA_Z4 A_DHC VDD pch
+ l=0.06U
+ w=0.42U
M367 VDD XGWDVA_Z7 A_GWDC VDD pch_hvt
+ l=0.07U
+ w=1.4U
M368 VDD XDINA_Z4 A_DHC VDD pch
+ l=0.06U
+ w=0.42U
M369 VDD XGWDVA_Z8 A_GWDT VDD pch_hvt
+ l=0.07U
+ w=1.4U
M370 VDD XDINA_Z8 A_BWH VDD pch
+ l=0.06U
+ w=0.42U
M371 A_MX XDOUTA_QCKT XDOUTA_Z1 VDD pch
+ l=0.06U
+ w=0.82U
M372 VDD XGWDVA_Z8 A_GWDT VDD pch_hvt
+ l=0.07U
+ w=1.4U
M373 A_BWH XDINA_Z8 VSS VSS nch
+ l=0.06U
+ w=0.41U
M374 VDD XDINA_Z8 A_BWH VDD pch
+ l=0.06U
+ w=0.42U
M375 VDD A_DHT XGWDVA_Z4 VDD pch_hvt
+ l=0.06U
+ w=0.41U
M376 VDD XGWDVA_Z8 A_GWDT VDD pch_hvt
+ l=0.07U
+ w=1.4U
M377 VSS A_BWH XDINA_Z14 VSS nch
+ l=0.06U
+ w=0.21U
M378 VDD XDOUTA_Z7 XDOUTA_Z1 VDD pch
+ l=0.06U
+ w=0.82U
M379 VDD A_WENB_0 XGWDVA_Z4 VDD pch_hvt
+ l=0.06U
+ w=0.41U
M380 VDD A_CKD XDINA_Z13 VDD pch
+ l=0.06U
+ w=0.21U
M381 VDD A_MX A_Q VDD pch
+ l=0.06U
+ w=0.75U
M382 XDINA_Z8 A_CKD XDINA_Z14 VSS nch
+ l=0.06U
+ w=0.21U
M383 VDD XGWDVA_Z8 A_GWDT VDD pch_hvt
+ l=0.07U
+ w=1.4U
M384 XDINA_Z13 XDINA_BWC XDINA_Z8 VDD
+ pch l=0.1U
+ w=0.42U
M385 VDD A_MX A_Q VDD pch
+ l=0.06U
+ w=0.75U
M386 VDD A_BWH XGWDVA_Z4 VDD pch_hvt
+ l=0.06U
+ w=0.41U
M387 XDINA_Z15 XDINA_BWC XDINA_Z8 VSS
+ nch l=0.1U
+ w=0.21U
M388 VDD XGWDVA_Z6 XGWDVA_Z8 VDD
+ pch_hvt l=0.06U
+	 w=0.56U
M389 XDINA_Z16 XDINA_CLKC XDINA_Z8 VDD
+ pch l=0.06U
+	 w=0.21U
M390 VDD A_MX A_Q VDD pch
+ l=0.06U
+ w=0.75U
M391 VDD XGWDVA_Z4 XGWDVA_Z6 VDD
+ pch_hvt l=0.06U
+	 w=0.41U
M392 XDINA_Z16 A_BWH VDD VDD pch
+ l=0.06U
+ w=0.42U
M393 VDD A_MX A_Q VDD pch
+ l=0.06U
+ w=0.75U
M394 VDD A_GRDC XGMXA_Z2 VDD pch
+ l=0.06U
+ w=0.41U
M395 VDD XGWDVA_Z4 XGWDVA_Z6 VDD
+ pch_hvt l=0.06U
+	 w=0.41U
M396 VDD XDINA_BWT XDINA_BWC VDD pch
+ l=0.1U
+ w=0.42U
M397 VDD A_BWH XDINA_Z17 VDD pch
+ l=0.06U
+ w=0.42U
M398 VDD A_BWH XDINA_Z17 VDD pch
+ l=0.06U
+ w=0.42U
M399 XDINA_Z19 XDINA_BWC VDD VDD pch
+ l=0.06U
+ w=0.42U
M400 VDD A_CKD XDINA_CLKC VDD pch
+ l=0.06U
+ w=0.21U
M401 XDINA_Z18 XDINA_BWT VDD VDD pch
+ l=0.06U
+ w=0.42U
M402 XDINA_Z18 XDINA_DT A_AWTD VDD pch
+ l=0.06U
+ w=0.42U
M403 A_AWTD XDINA_DC XDINA_Z19 VDD pch
+ l=0.06U
+ w=0.42U
M404 VDD A_DHC A_DHT VDD pch
+ l=0.06U
+ w=0.42U
M405 VDD A_DHC A_DHT VDD pch
+ l=0.06U
+ w=0.42U
M406 VDD XDINA_DT XDINA_DC VDD pch
+ l=0.1U
+ w=0.42U
M407 XDINA_Z26 A_BWEBM VDD VDD pch
+ l=0.1U
+ w=0.42U
M408 VDD XDINA_BWX XDINA_BWT VDD pch
+ l=0.1U
+ w=0.42U
M409 XDINA_Z26 BISTC XDINA_BWX VDD pch
+ l=0.1U
+ w=0.42U
M410 XDINA_BWX BISTT XDINA_Z25 VDD pch
+ l=0.1U
+ w=0.42U
M411 XDINA_Z25 A_BWEB VDD VDD pch
+ l=0.1U
+ w=0.42U
M412 XDINA_DX BISTC XDINA_Z22 VDD pch
+ l=0.1U
+ w=0.42U
M413 XDINA_Z21 BISTT XDINA_DX VDD pch
+ l=0.1U
+ w=0.42U
M414 VDD A_D XDINA_Z21 VDD pch
+ l=0.1U
+ w=0.42U
M415 VDD XDINA_DX XDINA_DT VDD pch
+ l=0.1U
+ w=0.42U
M416 XDINA_Z22 A_DM VDD VDD pch
+ l=0.1U
+ w=0.42U
M417 VDD A_DLRS XDOUTA_DLRSB VDD pch_hvt
+ l=0.06U
+ w=0.21U
M418 VDD XGWDVA_Z6 XGWDVA_Z8 VDD
+ pch_hvt l=0.06U
+	 w=0.56U
M419 VDD XGMXA_Z2 A_GRDC VDD pch_hvt
+ l=0.12U
+ w=0.21U
M420 XDINA_Z15 XDINA_CLKC VSS VSS nch
+ l=0.06U
+ w=0.21U
M421 XGMXA_GRDTB A_GRDT VSS VSS nch
+ l=0.06U
+ w=0.41U
M422 XGMXA_GRDTB A_GRDT VSS VSS nch
+ l=0.06U
+ w=0.41U
M423 XGMXA_Z3 XGMXA_Z2 VSS VSS nch
+ l=0.06U
+ w=0.41U
M424 XGMXA_DLRSB A_DLRS VSS VSS nch
+ l=0.06U
+ w=0.41U
M425 A_QLATCH XGMXA_Z1 VSS VSS nch
+ l=0.06U
+ w=0.41U
M426 A_QLATCH XGMXA_Z1 VSS VSS nch
+ l=0.06U
+ w=0.41U
M427 A_MX XGMXA_GRDTB A_MXN VSS nch
+ l=0.06U
+ w=0.6U
M428 A_MX XGMXA_GRDTB A_MXN VSS nch
+ l=0.06U
+ w=0.6U
M429 A_MX XGMXA_GRDTB A_MXN VSS nch
+ l=0.06U
+ w=0.6U
M430 A_MX XGMXA_GRDTB A_MXN VSS nch
+ l=0.06U
+ w=0.6U
M431 VDD A_GRDT XGMXA_GRDTB VDD pch
+ l=0.06U
+ w=1.1U
M432 VDD A_GRDT XGMXA_GRDTB VDD pch
+ l=0.06U
+ w=1.1U
M433 VDD XGMXA_DLRSB A_GRDT VDD pch
+ l=0.06U
+ w=1.14U
M434 VDD XGMXA_DLRSB A_GRDT VDD pch
+ l=0.06U
+ w=1.14U
M435 VDD XGMXA_DLRSB A_GRDT VDD pch
+ l=0.06U
+ w=1.14U
M436 A_GRDC XGMXA_DLRSB VDD VDD pch
+ l=0.06U
+ w=1.14U
M437 A_GRDC XGMXA_DLRSB VDD VDD pch
+ l=0.06U
+ w=1.14U
M438 A_GRDC XGMXA_DLRSB VDD VDD pch
+ l=0.06U
+ w=1.14U
M439 VDD XGMXA_Z2 XGMXA_Z3 VDD pch
+ l=0.06U
+ w=0.41U
M440 A_QLATCH XGMXA_Z3 VDD VDD pch
+ l=0.06U
+ w=0.82U
M441 A_QLATCH XGMXA_Z3 VDD VDD pch
+ l=0.06U
+ w=0.82U
M442 VDD A_DLRS XGMXA_DLRSB VDD pch
+ l=0.06U
+ w=0.82U
M443 A_MX A_GRDC A_MXP VDD pch
+ l=0.06U
+ w=0.75U
M444 A_MX A_GRDC A_MXP VDD pch
+ l=0.06U
+ w=0.75U
M445 A_MX A_GRDC A_MXP VDD pch
+ l=0.06U
+ w=0.75U
M446 A_MX A_GRDC A_MXP VDD pch
+ l=0.06U
+ w=0.75U
M447 VDD A_GRDT XGMXA_Z1 VDD pch
+ l=0.06U
+ w=0.41U
M448 VDD A_GRDT A_GRDC VDD pch
+ l=0.06U
+ w=0.41U
M449 A_GRDT A_GRDC VDD VDD pch
+ l=0.06U
+ w=0.41U
M450 VDD XGMXA_Z1 A_GRDT VDD pch_hvt
+ l=0.12U
+ w=0.21U
M451 XGMXA_Z1 A_GRDT VSS VSS nch
+ l=0.06U
+ w=0.21U
M452 XDINA_Z28 A_BWEBM VSS VSS nch
+ l=0.1U
+ w=0.21U
M453 XDINA_BWT XDINA_BWX VSS VSS nch
+ l=0.1U
+ w=0.21U
M454 XDINA_Z28 BISTT XDINA_BWX VSS nch
+ l=0.1U
+ w=0.21U
M455 XDINA_Z23 BISTC XDINA_DX VSS nch
+ l=0.1U
+ w=0.21U
M456 XDINA_Z27 BISTC XDINA_BWX VSS nch
+ l=0.1U
+ w=0.21U
M457 XDINA_Z27 A_BWEB VSS VSS nch
+ l=0.1U
+ w=0.21U
M458 XDINA_Z24 BISTT XDINA_DX VSS nch
+ l=0.1U
+ w=0.21U
M459 XDINA_Z23 A_D VSS VSS nch
+ l=0.1U
+ w=0.21U
M460 XDINA_DT XDINA_DX VSS VSS nch
+ l=0.1U
+ w=0.21U
M461 XDINA_Z24 A_DM VSS VSS nch
+ l=0.1U
+ w=0.21U
M462 XDINA_BWC XDINA_BWT VSS VSS nch
+ l=0.1U
+ w=0.21U
M463 XDINA_Z17 A_BWH VSS VSS nch
+ l=0.06U
+ w=0.41U
M464 A_DHT A_DHC VSS VSS nch
+ l=0.06U
+ w=0.41U
M465 XDINA_DC XDINA_DT VSS VSS nch
+ l=0.1U
+ w=0.21U
M466 XDINA_Z20 XDINA_BWC VSS VSS nch
+ l=0.06U
+	 w=0.21U
M467 XDINA_CLKC A_CKD VSS VSS nch
+ l=0.06U
+ w=0.21U
M468 A_AWTD XDINA_BWT XDINA_Z20 VSS nch
+ l=0.06U
+	 w=0.21U
M469 A_AWTD XDINA_DT XDINA_Z20 VSS nch
+ l=0.06U
+	 w=0.21U
M470 XDINA_Z20 XDINA_DC VSS VSS nch
+ l=0.06U
+	 w=0.21U
M471 XDINA_Z10 A_DHC VSS VSS nch
+ l=0.06U
+ w=0.21U
M472 A_DHC XDINA_Z4 VSS VSS nch
+ l=0.06U
+ w=0.41U
M473 XDINA_Z11 XDINA_DC XDINA_Z4 VSS
+ nch l=0.1U
+ w=0.21U
M474 XDINA_Z11 XDINA_CLKC VSS VSS nch
+ l=0.06U
+ w=0.21U
M475 XDINA_Z10 A_CKD XDINA_Z4 VSS nch
+ l=0.06U
+ w=0.21U
M476 VSS A_AWTD XDOUTA_Z4 VSS nch_hvt
+ l=0.06U
+ w=0.21U
M477 A_MXN XDOUTA_AWTC VSS VSS nch_hvt
+ l=0.06U
+ w=0.8U
M478 A_MXN XDOUTA_AWTC VSS VSS nch_hvt
+ l=0.06U
+ w=0.8U
M479 A_MXN XDOUTA_AWTC VSS VSS nch_hvt
+ l=0.06U
+ w=0.8U
M480 XDOUTA_Z6 XDOUTA_AWTC XDOUTA_Z7 VSS
+ nch_hvt l=0.06U
+	 w=0.21U
M481 XDOUTA_Z4 XDOUTA_AWTT XDOUTA_Z7 VSS
+ nch_hvt l=0.06U
+	 w=0.21U
M482 XDOUTA_Z6 A_QLATCH VSS VSS nch_hvt
+ l=0.06U
+ w=0.21U
M483 VDD XDOUTA_DLRSB XDOUTA_QCKC VDD pch_hvt
+ l=0.06U
+ w=0.41U
M484 VDD XDOUTA_QCKC XDOUTA_QCKT VDD pch_hvt
+ l=0.06U
+ w=0.41U
M485 VDD AWTI XDOUTA_AWTC VDD pch_hvt
+ l=0.06U
+ w=0.42U
M486 VDD XDOUTA_AWTC XDOUTA_QCKC VDD pch_hvt
+ l=0.06U
+ w=0.41U
M487 VDD XDOUTA_AWTC XDOUTA_AWTT VDD pch_hvt
+ l=0.06U
+ w=0.42U
M488 VDD XDOUTA_Z8 A_QLATCH VDD pch_hvt
+ l=0.12U
+ w=0.32U
M489 XDOUTA_Z3 XDOUTA_AWTC XDOUTA_Z7 VDD
+ pch_hvt l=0.06U
+	 w=0.42U
M490 VDD A_AWTD XDOUTA_Z3 VDD pch_hvt
+ l=0.06U
+ w=0.42U
M491 VDD XDOUTA_AWTT A_MXP VDD pch_hvt
+ l=0.06U
+ w=1U
M492 VDD XDOUTA_AWTT A_MXP VDD pch_hvt
+ l=0.06U
+ w=1U
M493 VDD XDOUTA_AWTT A_MXP VDD pch_hvt
+ l=0.06U
+ w=1U
M494 XDOUTA_Z7 XDOUTA_AWTT XDOUTA_Z5 VDD
+ pch_hvt l=0.06U
+	 w=0.42U
M495 VDD A_QLATCH XDOUTA_Z8 VDD pch_hvt
+ l=0.08U
+ w=0.42U
M496 XDOUTA_Z5 A_QLATCH VDD VDD pch_hvt
+ l=0.06U
+ w=0.42U
M497 XDOUTA_XI31_NET9 XDOUTA_DLRSB XDOUTA_QCKC
+ VSS nch_hvt l=0.06U
+	 w=0.41U
M498 XDOUTA_QCKT XDOUTA_QCKC VSS VSS nch_hvt
+ l=0.06U
+ w=0.21U
M499 XDOUTA_AWTC AWTI VSS VSS nch_hvt
+ l=0.06U
+ w=0.21U
M500 VSS XDOUTA_AWTC XDOUTA_XI31_NET9 VSS
+ nch_hvt l=0.06U
+	 w=0.41U
M501 XDOUTA_AWTT XDOUTA_AWTC VSS VSS nch_hvt
+ l=0.06U
+ w=0.21U
M502 A_QLATCH XDOUTA_Z8 VSS VSS nch_hvt
+ l=0.16U
+ w=0.21U
M503 XDOUTA_Z8 A_QLATCH VSS VSS nch_hvt
+ l=0.08U
+ w=0.21U
M504 XGWDVA_Z1 A_WENB_0 XGWDVA_Z2 VSS
+ nch_hvt l=0.06U
+	 w=0.41U
M505 XGWDVA_Z5 XGWDVA_Z3 VSS VSS
+ nch_hvt l=0.06U
+	 w=0.41U
M506 XGWDVA_Z4 A_DHT XGWDVA_Z2 VSS nch_hvt
+ l=0.06U
+ w=0.41U
M507 VSS A_BWH XGWDVA_Z1 VSS nch_hvt
+ l=0.06U
+ w=0.41U
M508 XGWDVA_Z3 A_DHC XGWDVA_Z2 VSS nch_hvt
+ l=0.06U
+ w=0.41U
M509 VDD A_WENB_0 XGWDVA_Z3 VDD pch_hvt
+ l=0.06U
+ w=0.41U
M510 VDD XGWDVA_Z3 XGWDVA_Z5 VDD
+ pch_hvt l=0.06U
+	 w=0.41U
M511 VDD XGWDVA_Z3 XGWDVA_Z5 VDD
+ pch_hvt l=0.06U
+	 w=0.41U
M512 VDD A_BWH XGWDVA_Z3 VDD pch_hvt
+ l=0.06U
+ w=0.41U
M513 VDD A_DHC XGWDVA_Z3 VDD pch_hvt
+ l=0.06U
+ w=0.41U
M514 XGWDVA_Z7 XGWDVA_Z5 VSS VSS
+ nch_hvt l=0.06U
+	 w=0.56U
M515 XGWDVA_Z7 XGWDVA_Z5 VSS VSS
+ nch_hvt l=0.06U
+	 w=0.56U
M516 XGWDVA_Z8 XGWDVA_Z6 VSS VSS
+ nch_hvt l=0.06U
+	 w=0.56U
M517 XGWDVA_Z8 XGWDVA_Z6 VSS VSS
+ nch_hvt l=0.06U
+	 w=0.56U
M518 A_GWDC XGWDVA_Z7 VSS VSS nch_hvt
+ l=0.06U
+ w=0.56U
M519 A_GWDC XGWDVA_Z7 VSS VSS nch_hvt
+ l=0.06U
+ w=0.56U
M520 A_GWDC XGWDVA_Z7 VSS VSS nch_hvt
+ l=0.06U
+ w=0.56U
M521 A_GWDC XGWDVA_Z7 VSS VSS nch_hvt
+ l=0.06U
+ w=0.56U
M522 A_GWDT XGWDVA_Z8 VSS VSS nch_hvt
+ l=0.06U
+ w=0.56U
M523 A_GWDT XGWDVA_Z8 VSS VSS nch_hvt
+ l=0.06U
+ w=0.56U
M524 A_GWDT XGWDVA_Z8 VSS VSS nch_hvt
+ l=0.06U
+ w=0.56U
M525 A_GWDT XGWDVA_Z8 VSS VSS nch_hvt
+ l=0.06U
+ w=0.56U
M526 VDD B_MX B_Q VDD pch
+ l=0.06U
+ w=0.75U
M527 VDD B_GRDC XGMXB_Z2 VDD pch
+ l=0.06U
+ w=0.41U
M528 VDD XGWDVB_Z4 XGWDVB_Z6 VDD
+ pch_hvt l=0.06U
+	 w=0.41U
M529 XDINB_Z16 B_BWH VDD VDD pch
+ l=0.06U
+ w=0.42U
M530 VDD B_DLRS XDOUTB_DLRSB VDD pch_hvt
+ l=0.06U
+ w=0.21U
M531 VDD XGWDVB_Z6 XGWDVB_Z8 VDD
+ pch_hvt l=0.06U
+	 w=0.56U
M532 VSS XDINB_CLKC XDINB_Z15 VSS nch
+ l=0.06U
+ w=0.21U
M533 VDD XGMXB_Z2 B_GRDC VDD pch_hvt
+ l=0.12U
+ w=0.21U
M534 VDD B_MX B_Q VDD pch
+ l=0.06U
+ w=0.75U
M535 XDINB_Z16 XDINB_CLKC XDINB_Z8 VDD
+ pch l=0.06U
+	 w=0.21U
M536 VDD XGWDVB_Z4 XGWDVB_Z6 VDD
+ pch_hvt l=0.06U
+	 w=0.41U
M537 VDD B_MX B_Q VDD pch
+ l=0.06U
+ w=0.75U
M538 VDD XGWDVB_Z6 XGWDVB_Z8 VDD
+ pch_hvt l=0.06U
+	 w=0.56U
M539 XDINB_Z15 XDINB_BWC XDINB_Z8 VSS
+ nch l=0.1U
+ w=0.21U
M540 VDD B_BWH XGWDVB_Z4 VDD pch_hvt
+ l=0.06U
+ w=0.41U
M541 XDINB_Z13 XDINB_BWC XDINB_Z8 VDD
+ pch l=0.1U
+ w=0.42U
M542 XDINB_Z8 B_CKD XDINB_Z14 VSS nch
+ l=0.06U
+ w=0.21U
M543 VDD XGWDVB_Z8 B_GWDT VDD pch_hvt
+ l=0.07U
+ w=1.4U
M544 VDD B_MX B_Q VDD pch
+ l=0.06U
+ w=0.75U
M545 VDD B_WENB_0 XGWDVB_Z4 VDD pch_hvt
+ l=0.06U
+ w=0.41U
M546 VDD XGWDVB_Z8 B_GWDT VDD pch_hvt
+ l=0.07U
+ w=1.4U
M547 VDD B_CKD XDINB_Z13 VDD pch
+ l=0.06U
+ w=0.21U
M548 VDD XDOUTB_Z7 XDOUTB_Z1 VDD pch
+ l=0.06U
+ w=0.82U
M549 VSS B_BWH XDINB_Z14 VSS nch
+ l=0.06U
+ w=0.21U
M550 VDD B_DHT XGWDVB_Z4 VDD pch_hvt
+ l=0.06U
+ w=0.41U
M551 B_MX XDOUTB_QCKT XDOUTB_Z1 VDD pch
+ l=0.06U
+ w=0.82U
M552 VDD XGWDVB_Z8 B_GWDT VDD pch_hvt
+ l=0.07U
+ w=1.4U
M553 VDD XDINB_Z8 B_BWH VDD pch
+ l=0.06U
+ w=0.42U
M554 B_BWH XDINB_Z8 VSS VSS nch
+ l=0.06U
+ w=0.41U
M555 VDD XGWDVB_Z8 B_GWDT VDD pch_hvt
+ l=0.07U
+ w=1.4U
M556 VDD XDINB_Z8 B_BWH VDD pch
+ l=0.06U
+ w=0.42U
M557 VDD XGWDVB_Z7 B_GWDC VDD pch_hvt
+ l=0.07U
+ w=1.4U
M558 VDD XDINB_Z4 B_DHC VDD pch
+ l=0.06U
+ w=0.42U
M559 VDD XGWDVB_Z7 B_GWDC VDD pch_hvt
+ l=0.07U
+ w=1.4U
M560 VDD XDINB_Z4 B_DHC VDD pch
+ l=0.06U
+ w=0.42U
M561 VDD XGWDVB_Z7 B_GWDC VDD pch_hvt
+ l=0.07U
+ w=1.4U
M562 XDINB_Z9 B_CKD VDD VDD pch
+ l=0.06U
+ w=0.21U
M563 VDD XGWDVB_Z7 B_GWDC VDD pch_hvt
+ l=0.07U
+ w=1.4U
M564 XDINB_Z4 XDINB_DC XDINB_Z9 VDD
+ pch l=0.1U
+ w=0.42U
M565 VDD XGWDVB_Z5 XGWDVB_Z7 VDD
+ pch_hvt l=0.06U
+	 w=0.56U
M566 XDINB_Z12 XDINB_CLKC XDINB_Z4 VDD
+ pch l=0.06U
+	 w=0.21U
M567 XDINB_Z12 B_DHC VDD VDD pch
+ l=0.06U
+ w=0.42U
M568 VDD XGWDVB_Z5 XGWDVB_Z7 VDD
+ pch_hvt l=0.06U
+	 w=0.56U
M569 VDD XDINB_BWT XDINB_BWC VDD pch
+ l=0.1U
+ w=0.42U
M570 VDD B_BWH XDINB_Z17 VDD pch
+ l=0.06U
+ w=0.42U
M571 VDD B_BWH XDINB_Z17 VDD pch
+ l=0.06U
+ w=0.42U
M572 XDINB_Z19 XDINB_BWC VDD VDD pch
+ l=0.06U
+ w=0.42U
M573 VDD B_CKD XDINB_CLKC VDD pch
+ l=0.06U
+ w=0.21U
M574 XDINB_Z18 XDINB_BWT VDD VDD pch
+ l=0.06U
+ w=0.42U
M575 XDINB_Z18 XDINB_DT B_AWTD VDD pch
+ l=0.06U
+ w=0.42U
M576 B_AWTD XDINB_DC XDINB_Z19 VDD pch
+ l=0.06U
+ w=0.42U
M577 VDD B_DHC B_DHT VDD pch
+ l=0.06U
+ w=0.42U
M578 VDD B_DHC B_DHT VDD pch
+ l=0.06U
+ w=0.42U
M579 VDD XDINB_DT XDINB_DC VDD pch
+ l=0.1U
+ w=0.42U
M580 XDINB_Z26 B_BWEBM VDD VDD pch
+ l=0.1U
+ w=0.42U
M581 VDD XDINB_BWX XDINB_BWT VDD pch
+ l=0.1U
+ w=0.42U
M582 XDINB_Z26 BISTC XDINB_BWX VDD pch
+ l=0.1U
+ w=0.42U
M583 XDINB_BWX BISTT XDINB_Z25 VDD pch
+ l=0.1U
+ w=0.42U
M584 XDINB_Z25 B_BWEB VDD VDD pch
+ l=0.1U
+ w=0.42U
M585 XDINB_DX BISTC XDINB_Z22 VDD pch
+ l=0.1U
+ w=0.42U
M586 XDINB_Z21 BISTT XDINB_DX VDD pch
+ l=0.1U
+ w=0.42U
M587 VDD B_D XDINB_Z21 VDD pch
+ l=0.1U
+ w=0.42U
M588 VDD XDINB_DX XDINB_DT VDD pch
+ l=0.1U
+ w=0.42U
M589 XDINB_Z22 B_DM VDD VDD pch
+ l=0.1U
+ w=0.42U
M590 XDINB_Z28 B_BWEBM VSS VSS nch
+ l=0.1U
+ w=0.21U
M591 XDINB_BWT XDINB_BWX VSS VSS nch
+ l=0.1U
+ w=0.21U
M592 XDINB_Z28 BISTT XDINB_BWX VSS nch
+ l=0.1U
+ w=0.21U
M593 XDINB_Z23 BISTC XDINB_DX VSS nch
+ l=0.1U
+ w=0.21U
M594 XDINB_Z27 BISTC XDINB_BWX VSS nch
+ l=0.1U
+ w=0.21U
M595 XDINB_Z27 B_BWEB VSS VSS nch
+ l=0.1U
+ w=0.21U
M596 XDINB_Z24 BISTT XDINB_DX VSS nch
+ l=0.1U
+ w=0.21U
M597 XDINB_Z23 B_D VSS VSS nch
+ l=0.1U
+ w=0.21U
M598 XDINB_DT XDINB_DX VSS VSS nch
+ l=0.1U
+ w=0.21U
M599 XDINB_Z24 B_DM VSS VSS nch
+ l=0.1U
+ w=0.21U
M600 XDINB_BWC XDINB_BWT VSS VSS nch
+ l=0.1U
+ w=0.21U
M601 XDINB_Z17 B_BWH VSS VSS nch
+ l=0.06U
+ w=0.41U
M602 B_DHT B_DHC VSS VSS nch
+ l=0.06U
+ w=0.41U
M603 XDINB_DC XDINB_DT VSS VSS nch
+ l=0.1U
+ w=0.21U
M604 XDINB_Z20 XDINB_BWC VSS VSS nch
+ l=0.06U
+	 w=0.21U
M605 XDINB_CLKC B_CKD VSS VSS nch
+ l=0.06U
+ w=0.21U
M606 B_AWTD XDINB_BWT XDINB_Z20 VSS nch
+ l=0.06U
+	 w=0.21U
M607 B_AWTD XDINB_DT XDINB_Z20 VSS nch
+ l=0.06U
+	 w=0.21U
M608 XDINB_Z20 XDINB_DC VSS VSS nch
+ l=0.06U
+	 w=0.21U
M609 XDINB_Z10 B_DHC VSS VSS nch
+ l=0.06U
+ w=0.21U
M610 B_DHC XDINB_Z4 VSS VSS nch
+ l=0.06U
+ w=0.41U
M611 XDINB_Z11 XDINB_DC XDINB_Z4 VSS
+ nch l=0.1U
+ w=0.21U
M612 XDINB_Z11 XDINB_CLKC VSS VSS nch
+ l=0.06U
+ w=0.21U
M613 XDINB_Z10 B_CKD XDINB_Z4 VSS nch
+ l=0.06U
+ w=0.21U
M614 VSS B_AWTD XDOUTB_Z4 VSS nch_hvt
+ l=0.06U
+ w=0.21U
M615 B_MXN XDOUTB_AWTC VSS VSS nch_hvt
+ l=0.06U
+ w=0.8U
M616 B_MXN XDOUTB_AWTC VSS VSS nch_hvt
+ l=0.06U
+ w=0.8U
M617 B_MXN XDOUTB_AWTC VSS VSS nch_hvt
+ l=0.06U
+ w=0.8U
M618 XDOUTB_Z6 XDOUTB_AWTC XDOUTB_Z7 VSS
+ nch_hvt l=0.06U
+	 w=0.21U
M619 XDOUTB_Z4 XDOUTB_AWTT XDOUTB_Z7 VSS
+ nch_hvt l=0.06U
+	 w=0.21U
M620 XDOUTB_Z6 B_QLATCH VSS VSS nch_hvt
+ l=0.06U
+ w=0.21U
M621 VDD XDOUTB_DLRSB XDOUTB_QCKC VDD pch_hvt
+ l=0.06U
+ w=0.41U
M622 VDD XDOUTB_QCKC XDOUTB_QCKT VDD pch_hvt
+ l=0.06U
+ w=0.41U
M623 VDD AWTI XDOUTB_AWTC VDD pch_hvt
+ l=0.06U
+ w=0.42U
M624 VDD XDOUTB_AWTC XDOUTB_QCKC VDD pch_hvt
+ l=0.06U
+ w=0.41U
M625 VDD XDOUTB_AWTC XDOUTB_AWTT VDD pch_hvt
+ l=0.06U
+ w=0.42U
M626 VDD XDOUTB_Z8 B_QLATCH VDD pch_hvt
+ l=0.12U
+ w=0.32U
M627 XDOUTB_Z3 XDOUTB_AWTC XDOUTB_Z7 VDD
+ pch_hvt l=0.06U
+	 w=0.42U
M628 VDD B_AWTD XDOUTB_Z3 VDD pch_hvt
+ l=0.06U
+ w=0.42U
M629 VDD XDOUTB_AWTT B_MXP VDD pch_hvt
+ l=0.06U
+ w=1U
M630 VDD XDOUTB_AWTT B_MXP VDD pch_hvt
+ l=0.06U
+ w=1U
M631 VDD XDOUTB_AWTT B_MXP VDD pch_hvt
+ l=0.06U
+ w=1U
M632 XDOUTB_Z7 XDOUTB_AWTT XDOUTB_Z5 VDD
+ pch_hvt l=0.06U
+	 w=0.42U
M633 VDD B_QLATCH XDOUTB_Z8 VDD pch_hvt
+ l=0.08U
+ w=0.42U
M634 XDOUTB_Z5 B_QLATCH VDD VDD pch_hvt
+ l=0.06U
+ w=0.42U
M635 XGMXB_GRDTB B_GRDT VSS VSS nch
+ l=0.06U
+ w=0.41U
M636 XGMXB_GRDTB B_GRDT VSS VSS nch
+ l=0.06U
+ w=0.41U
M637 XGMXB_Z3 XGMXB_Z2 VSS VSS nch
+ l=0.06U
+ w=0.41U
M638 XGMXB_DLRSB B_DLRS VSS VSS nch
+ l=0.06U
+ w=0.41U
M639 B_QLATCH XGMXB_Z1 VSS VSS nch
+ l=0.06U
+ w=0.41U
M640 B_QLATCH XGMXB_Z1 VSS VSS nch
+ l=0.06U
+ w=0.41U
M641 B_MX XGMXB_GRDTB B_MXN VSS nch
+ l=0.06U
+ w=0.6U
M642 B_MX XGMXB_GRDTB B_MXN VSS nch
+ l=0.06U
+ w=0.6U
M643 B_MX XGMXB_GRDTB B_MXN VSS nch
+ l=0.06U
+ w=0.6U
M644 B_MX XGMXB_GRDTB B_MXN VSS nch
+ l=0.06U
+ w=0.6U
M645 XDOUTB_XI31_NET9 XDOUTB_DLRSB XDOUTB_QCKC
+ VSS nch_hvt l=0.06U
+	 w=0.41U
M646 XDOUTB_QCKT XDOUTB_QCKC VSS VSS nch_hvt
+ l=0.06U
+ w=0.21U
M647 XDOUTB_AWTC AWTI VSS VSS nch_hvt
+ l=0.06U
+ w=0.21U
M648 VSS XDOUTB_AWTC XDOUTB_XI31_NET9 VSS
+ nch_hvt l=0.06U
+	 w=0.41U
M649 XDOUTB_AWTT XDOUTB_AWTC VSS VSS nch_hvt
+ l=0.06U
+ w=0.21U
M650 B_QLATCH XDOUTB_Z8 VSS VSS nch_hvt
+ l=0.16U
+ w=0.21U
M651 XDOUTB_Z8 B_QLATCH VSS VSS nch_hvt
+ l=0.08U
+ w=0.21U
M652 VDD B_GRDT XGMXB_GRDTB VDD pch
+ l=0.06U
+ w=1.1U
M653 VDD B_GRDT XGMXB_GRDTB VDD pch
+ l=0.06U
+ w=1.1U
M654 VDD XGMXB_DLRSB B_GRDT VDD pch
+ l=0.06U
+ w=1.14U
M655 VDD XGMXB_DLRSB B_GRDT VDD pch
+ l=0.06U
+ w=1.14U
M656 VDD XGMXB_DLRSB B_GRDT VDD pch
+ l=0.06U
+ w=1.14U
M657 B_GRDC XGMXB_DLRSB VDD VDD pch
+ l=0.06U
+ w=1.14U
M658 B_GRDC XGMXB_DLRSB VDD VDD pch
+ l=0.06U
+ w=1.14U
M659 B_GRDC XGMXB_DLRSB VDD VDD pch
+ l=0.06U
+ w=1.14U
M660 VDD XGMXB_Z2 XGMXB_Z3 VDD pch
+ l=0.06U
+ w=0.41U
M661 B_QLATCH XGMXB_Z3 VDD VDD pch
+ l=0.06U
+ w=0.82U
M662 B_QLATCH XGMXB_Z3 VDD VDD pch
+ l=0.06U
+ w=0.82U
M663 VDD B_DLRS XGMXB_DLRSB VDD pch
+ l=0.06U
+ w=0.82U
M664 B_MX B_GRDC B_MXP VDD pch
+ l=0.06U
+ w=0.75U
M665 B_MX B_GRDC B_MXP VDD pch
+ l=0.06U
+ w=0.75U
M666 B_MX B_GRDC B_MXP VDD pch
+ l=0.06U
+ w=0.75U
M667 B_MX B_GRDC B_MXP VDD pch
+ l=0.06U
+ w=0.75U
M668 VDD B_GRDT XGMXB_Z1 VDD pch
+ l=0.06U
+ w=0.41U
M669 VDD B_GRDT B_GRDC VDD pch
+ l=0.06U
+ w=0.41U
M670 B_GRDT B_GRDC VDD VDD pch
+ l=0.06U
+ w=0.41U
M671 VDD XGMXB_Z1 B_GRDT VDD pch_hvt
+ l=0.12U
+ w=0.21U
M672 XGMXB_Z1 B_GRDT VSS VSS nch
+ l=0.06U
+ w=0.21U
M673 XGWDVB_Z1 B_WENB_0 XGWDVB_Z2 VSS
+ nch_hvt l=0.06U
+	 w=0.41U
M674 XGWDVB_Z5 XGWDVB_Z3 VSS VSS
+ nch_hvt l=0.06U
+	 w=0.41U
M675 XGWDVB_Z4 B_DHT XGWDVB_Z2 VSS nch_hvt
+ l=0.06U
+ w=0.41U
M676 VSS B_BWH XGWDVB_Z1 VSS nch_hvt
+ l=0.06U
+ w=0.41U
M677 XGWDVB_Z3 B_DHC XGWDVB_Z2 VSS nch_hvt
+ l=0.06U
+ w=0.41U
M678 VDD B_WENB_0 XGWDVB_Z3 VDD pch_hvt
+ l=0.06U
+ w=0.41U
M679 VDD XGWDVB_Z3 XGWDVB_Z5 VDD
+ pch_hvt l=0.06U
+	 w=0.41U
M680 VDD XGWDVB_Z3 XGWDVB_Z5 VDD
+ pch_hvt l=0.06U
+	 w=0.41U
M681 VDD B_BWH XGWDVB_Z3 VDD pch_hvt
+ l=0.06U
+ w=0.41U
M682 VDD B_DHC XGWDVB_Z3 VDD pch_hvt
+ l=0.06U
+ w=0.41U
M683 XGWDVB_Z7 XGWDVB_Z5 VSS VSS
+ nch_hvt l=0.06U
+	 w=0.56U
M684 XGWDVB_Z7 XGWDVB_Z5 VSS VSS
+ nch_hvt l=0.06U
+	 w=0.56U
M685 XGWDVB_Z8 XGWDVB_Z6 VSS VSS
+ nch_hvt l=0.06U
+	 w=0.56U
M686 XGWDVB_Z8 XGWDVB_Z6 VSS VSS
+ nch_hvt l=0.06U
+	 w=0.56U
M687 B_GWDC XGWDVB_Z7 VSS VSS nch_hvt
+ l=0.06U
+ w=0.56U
M688 B_GWDC XGWDVB_Z7 VSS VSS nch_hvt
+ l=0.06U
+ w=0.56U
M689 B_GWDC XGWDVB_Z7 VSS VSS nch_hvt
+ l=0.06U
+ w=0.56U
M690 B_GWDC XGWDVB_Z7 VSS VSS nch_hvt
+ l=0.06U
+ w=0.56U
M691 B_GWDT XGWDVB_Z8 VSS VSS nch_hvt
+ l=0.06U
+ w=0.56U
M692 B_GWDT XGWDVB_Z8 VSS VSS nch_hvt
+ l=0.06U
+ w=0.56U
M693 B_GWDT XGWDVB_Z8 VSS VSS nch_hvt
+ l=0.06U
+ w=0.56U
M694 B_GWDT XGWDVB_Z8 VSS VSS nch_hvt
+ l=0.06U
+ w=0.56U
M695 A_MX XDOUTA_QCKC XDOUTA_Z2 VSS nch
+ l=0.06U
+ w=0.42U
M696 VSS XDOUTA_Z7 XDOUTA_Z2 VSS nch
+ l=0.06U
+ w=0.42U
M697 A_Q A_MX VSS VSS nch
+ l=0.06U
+ w=0.375U
M698 A_Q A_MX VSS VSS nch
+ l=0.06U
+ w=0.375U
M699 A_Q A_MX VSS VSS nch
+ l=0.06U
+ w=0.375U
M700 A_Q A_MX VSS VSS nch
+ l=0.06U
+ w=0.375U
M701 B_MX XDOUTB_QCKC XDOUTB_Z2 VSS nch
+ l=0.06U
+ w=0.42U
M702 VSS XDOUTB_Z7 XDOUTB_Z2 VSS nch
+ l=0.06U
+ w=0.42U
M703 B_Q B_MX VSS VSS nch
+ l=0.06U
+ w=0.375U
M704 B_Q B_MX VSS VSS nch
+ l=0.06U
+ w=0.375U
M705 B_Q B_MX VSS VSS nch
+ l=0.06U
+ w=0.375U
M706 B_Q B_MX VSS VSS nch
+ l=0.06U
+ w=0.375U
M707 XDOUTA_DLRSB A_DLRS VSS VSS nch_hvt
+ l=0.06U
+ w=0.21U
M708 XDOUTB_DLRSB B_DLRS VSS VSS nch_hvt
+ l=0.06U
+ w=0.21U
M709 XGWDVA_Z6 XGWDVA_Z4 VSS VSS
+ nch_hvt l=0.06U
+	 w=0.41U
M710 XGWDVB_Z6 XGWDVB_Z4 VSS VSS
+ nch_hvt l=0.06U
+	 w=0.41U
M711 XGMXB_Z2 B_GRDC VSS VSS nch
+ l=0.06U
+ w=0.21U
M712 XGMXA_Z2 A_GRDC VSS VSS nch
+ l=0.06U
+ w=0.21U
.ENDS
* BIT82
.SUBCKT SDL400W20S_BIT82 AWTI A_BWEB A_BWEBM A_CKD A_D A_DLRS A_DM
+	 A_WENB_3 A_WENB_2 A_WENB_1 A_WENB_0 BISTC BISTT B_BWEB
+	 B_BWEBM B_CKD B_D B_DLRS B_DM B_WENB_3 B_WENB_2 B_WENB_1
+	 B_WENB_0 A_GWDC_1 A_GWDC_0 A_GWDT_1 A_GWDT_0 A_Q B_GWDC_1
+	 B_GWDC_0 B_GWDT_1 B_GWDT_0 B_Q A_GRDC_1 A_GRDC_0 A_GRDT_1
+	 A_GRDT_0 B_GRDC_1 B_GRDC_0 B_GRDT_1 B_GRDT_0
M713 VDD XGWDVA_0_Z5 XGWDVA_0_Z7 VDD
+ pch_hvt l=0.06U
+	 w=0.56U
M714 VDD XGWDVA_0_Z5 XGWDVA_0_Z7 VDD
+ pch_hvt l=0.06U
+	 w=0.56U
M715 VDD XGWDVA_0_Z7 A_GWDC_0 VDD
+ pch_hvt l=0.07U
+	 w=1.4U
M716 VDD XGWDVA_0_Z7 A_GWDC_0 VDD
+ pch_hvt l=0.07U
+ w=1.4U
M717 VDD XGWDVA_0_Z7 A_GWDC_0 VDD
+ pch_hvt l=0.07U
+ w=1.4U
M718 VDD XGWDVA_0_Z7 A_GWDC_0 VDD
+ pch_hvt l=0.07U
+ w=1.4U
M719 VDD XGWDVA_0_Z8 A_GWDT_0 VDD
+ pch_hvt l=0.07U
+ w=1.4U
M720 VDD XGWDVA_0_Z8 A_GWDT_0 VDD
+ pch_hvt l=0.07U
+ w=1.4U
M721 VDD A_DHT XGWDVA_0_Z4 VDD pch_hvt
+ l=0.06U
+ w=0.41U
M722 VDD XGWDVA_0_Z8 A_GWDT_0 VDD
+ pch_hvt l=0.07U
+ w=1.4U
M723 VDD A_WENB_0 XGWDVA_0_Z4 VDD pch_hvt
+ l=0.06U
+ w=0.41U
M724 VDD XGWDVA_0_Z8 A_GWDT_0 VDD
+ pch_hvt l=0.07U
+	 w=1.4U
M725 VDD A_BWH XGWDVA_0_Z4 VDD pch_hvt
+ l=0.06U
+ w=0.41U
M726 VDD XGWDVA_0_Z6 XGWDVA_0_Z8 VDD
+ pch_hvt l=0.06U
+	 w=0.56U
M727 VDD XGWDVA_0_Z4 XGWDVA_0_Z6 VDD
+ pch_hvt l=0.06U
+	 w=0.41U
M728 VDD A_GRDC_0 XGMXA_0_Z2 VDD
+ pch l=0.06U
+ w=0.41U
M729 VDD XGWDVA_0_Z4 XGWDVA_0_Z6 VDD
+ pch_hvt l=0.06U
+	 w=0.41U
M730 VDD XGWDVA_0_Z6 XGWDVA_0_Z8 VDD
+ pch_hvt l=0.06U
+	 w=0.56U
M731 VDD XGMXA_0_Z2 A_GRDC_0 VDD pch_hvt
+ l=0.12U
+	 w=0.21U
M732 XGMXA_0_GRDTB A_GRDT_0 VSS VSS nch
+ l=0.06U
+ w=0.41U
M733 XGMXA_0_GRDTB A_GRDT_0 VSS VSS
+ nch l=0.06U
+ w=0.41U
M734 XGMXA_0_Z3 XGMXA_0_Z2 VSS VSS
+ nch l=0.06U
+ w=0.41U
M735 XGMXA_0_DLRSB A_DLRS VSS VSS nch
+ l=0.06U
+ w=0.41U
M736 A_QLATCH XGMXA_0_Z1 VSS VSS nch
+ l=0.06U
+ w=0.41U
M737 A_QLATCH XGMXA_0_Z1 VSS VSS nch
+ l=0.06U
+ w=0.41U
M738 A_MX XGMXA_0_GRDTB A_MXN VSS nch
+ l=0.06U
+ w=0.6U
M739 A_MX XGMXA_0_GRDTB A_MXN VSS nch
+ l=0.06U
+ w=0.6U
M740 A_MX XGMXA_0_GRDTB A_MXN VSS nch
+ l=0.06U
+ w=0.6U
M741 A_MX XGMXA_0_GRDTB A_MXN VSS nch
+ l=0.06U
+ w=0.6U
M742 VDD A_GRDT_0 XGMXA_0_GRDTB VDD pch
+ l=0.06U
+ w=1.1U
M743 VDD A_GRDT_0 XGMXA_0_GRDTB VDD
+ pch l=0.06U
+ w=1.1U
M744 VDD XGMXA_0_DLRSB A_GRDT_0 VDD pch
+ l=0.06U
+ w=1.14U
M745 VDD XGMXA_0_DLRSB A_GRDT_0 VDD pch
+ l=0.06U
+ w=1.14U
M746 VDD XGMXA_0_DLRSB A_GRDT_0 VDD pch
+ l=0.06U
+ w=1.14U
M747 A_GRDC_0 XGMXA_0_DLRSB VDD VDD pch
+ l=0.06U
+ w=1.14U
M748 A_GRDC_0 XGMXA_0_DLRSB VDD VDD pch
+ l=0.06U
+ w=1.14U
M749 A_GRDC_0 XGMXA_0_DLRSB VDD VDD pch
+ l=0.06U
+ w=1.14U
M750 VDD XGMXA_0_Z2 XGMXA_0_Z3 VDD
+ pch l=0.06U
+ w=0.41U
M751 A_QLATCH XGMXA_0_Z3 VDD VDD pch
+ l=0.06U
+ w=0.82U
M752 A_QLATCH XGMXA_0_Z3 VDD VDD pch
+ l=0.06U
+ w=0.82U
M753 VDD A_DLRS XGMXA_0_DLRSB VDD pch
+ l=0.06U
+ w=0.82U
M754 A_MX A_GRDC_0 A_MXP VDD pch
+ l=0.06U
+ w=0.75U
M755 A_MX A_GRDC_0 A_MXP VDD pch
+ l=0.06U
+ w=0.75U
M756 A_MX A_GRDC_0 A_MXP VDD pch
+ l=0.06U
+ w=0.75U
M757 A_MX A_GRDC_0 A_MXP VDD pch
+ l=0.06U
+ w=0.75U
M758 VDD A_GRDT_0 XGMXA_0_Z1 VDD
+ pch l=0.06U
+ w=0.41U
M759 VDD A_GRDT_0 A_GRDC_0 VDD pch
+ l=0.06U
+ w=0.41U
M760 A_GRDT_0 A_GRDC_0 VDD VDD pch
+ l=0.06U
+ w=0.41U
M761 VDD XGMXA_0_Z1 A_GRDT_0 VDD pch_hvt
+ l=0.12U
+ w=0.21U
M762 XGMXA_0_Z1 A_GRDT_0 VSS VSS
+ nch l=0.06U
+ w=0.21U
M763 XGWDVA_0_Z1 A_WENB_0 XGWDVA_0_Z2 VSS
+ nch_hvt l=0.06U
+	 w=0.41U
M764 XGWDVA_0_Z5 XGWDVA_0_Z3 VSS VSS
+ nch_hvt l=0.06U
+	 w=0.41U
M765 XGWDVA_0_Z4 A_DHT XGWDVA_0_Z2 VSS nch_hvt
+ l=0.06U
+ w=0.41U
M766 VSS A_BWH XGWDVA_0_Z1 VSS nch_hvt
+ l=0.06U
+ w=0.41U
M767 XGWDVA_0_Z3 A_DHC XGWDVA_0_Z2 VSS nch_hvt
+ l=0.06U
+ w=0.41U
M768 VDD A_WENB_0 XGWDVA_0_Z3 VDD pch_hvt
+ l=0.06U
+ w=0.41U
M769 VDD XGWDVA_0_Z3 XGWDVA_0_Z5 VDD
+ pch_hvt l=0.06U
+	 w=0.41U
M770 VDD XGWDVA_0_Z3 XGWDVA_0_Z5 VDD
+ pch_hvt l=0.06U
+	 w=0.41U
M771 VDD A_BWH XGWDVA_0_Z3 VDD pch_hvt
+ l=0.06U
+ w=0.41U
M772 VDD A_DHC XGWDVA_0_Z3 VDD pch_hvt
+ l=0.06U
+ w=0.41U
M773 XGWDVA_0_Z7 XGWDVA_0_Z5 VSS VSS
+ nch_hvt l=0.06U
+	 w=0.56U
M774 XGWDVA_0_Z7 XGWDVA_0_Z5 VSS VSS
+ nch_hvt l=0.06U
+	 w=0.56U
M775 XGWDVA_0_Z8 XGWDVA_0_Z6 VSS VSS
+ nch_hvt l=0.06U
+	 w=0.56U
M776 XGWDVA_0_Z8 XGWDVA_0_Z6 VSS VSS
+ nch_hvt l=0.06U
+	 w=0.56U
M777 A_GWDC_0 XGWDVA_0_Z7 VSS VSS
+ nch_hvt l=0.06U
+ w=0.56U
M778 A_GWDC_0 XGWDVA_0_Z7 VSS VSS
+ nch_hvt l=0.06U
+	 w=0.56U
M779 A_GWDC_0 XGWDVA_0_Z7 VSS VSS
+ nch_hvt l=0.06U
+	 w=0.56U
M780 A_GWDC_0 XGWDVA_0_Z7 VSS VSS
+ nch_hvt l=0.06U
+	 w=0.56U
M781 A_GWDT_0 XGWDVA_0_Z8 VSS VSS
+ nch_hvt l=0.06U
+ w=0.56U
M782 A_GWDT_0 XGWDVA_0_Z8 VSS VSS
+ nch_hvt l=0.06U
+	 w=0.56U
M783 A_GWDT_0 XGWDVA_0_Z8 VSS VSS
+ nch_hvt l=0.06U
+	 w=0.56U
M784 A_GWDT_0 XGWDVA_0_Z8 VSS VSS
+ nch_hvt l=0.06U
+	 w=0.56U
M785 VDD B_GRDC_0 XGMXB_0_Z2 VDD
+ pch l=0.06U
+ w=0.41U
M786 VDD XGWDVB_0_Z4 XGWDVB_0_Z6 VDD
+ pch_hvt l=0.06U
+	 w=0.41U
M787 VDD XGWDVB_0_Z6 XGWDVB_0_Z8 VDD
+ pch_hvt l=0.06U
+	 w=0.56U
M788 VDD XGMXB_0_Z2 B_GRDC_0 VDD pch_hvt
+ l=0.12U
+	 w=0.21U
M789 VDD XGWDVB_0_Z4 XGWDVB_0_Z6 VDD
+ pch_hvt l=0.06U
+ w=0.41U
M790 VDD XGWDVB_0_Z6 XGWDVB_0_Z8 VDD
+ pch_hvt l=0.06U
+	 w=0.56U
M791 VDD B_BWH XGWDVB_0_Z4 VDD pch_hvt
+ l=0.06U
+ w=0.41U
M792 VDD XGWDVB_0_Z8 B_GWDT_0 VDD
+ pch_hvt l=0.07U
+	 w=1.4U
M793 VDD B_WENB_0 XGWDVB_0_Z4 VDD pch_hvt
+ l=0.06U
+ w=0.41U
M794 VDD XGWDVB_0_Z8 B_GWDT_0 VDD
+ pch_hvt l=0.07U
+ w=1.4U
M795 VDD B_DHT XGWDVB_0_Z4 VDD pch_hvt
+ l=0.06U
+ w=0.41U
M796 VDD XGWDVB_0_Z8 B_GWDT_0 VDD
+ pch_hvt l=0.07U
+ w=1.4U
M797 VDD XGWDVB_0_Z8 B_GWDT_0 VDD
+ pch_hvt l=0.07U
+ w=1.4U
M798 VDD XGWDVB_0_Z7 B_GWDC_0 VDD
+ pch_hvt l=0.07U
+ w=1.4U
M799 VDD XGWDVB_0_Z7 B_GWDC_0 VDD
+ pch_hvt l=0.07U
+ w=1.4U
M800 VDD XGWDVB_0_Z7 B_GWDC_0 VDD
+ pch_hvt l=0.07U
+ w=1.4U
M801 VDD XGWDVB_0_Z7 B_GWDC_0 VDD
+ pch_hvt l=0.07U
+	 w=1.4U
M802 VDD XGWDVB_0_Z5 XGWDVB_0_Z7 VDD
+ pch_hvt l=0.06U
+	 w=0.56U
M803 VDD XGWDVB_0_Z5 XGWDVB_0_Z7 VDD
+ pch_hvt l=0.06U
+	 w=0.56U
M804 XGMXB_0_GRDTB B_GRDT_0 VSS VSS nch
+ l=0.06U
+ w=0.41U
M805 XGMXB_0_GRDTB B_GRDT_0 VSS VSS
+ nch l=0.06U
+ w=0.41U
M806 XGMXB_0_Z3 XGMXB_0_Z2 VSS VSS
+ nch l=0.06U
+ w=0.41U
M807 XGMXB_0_DLRSB B_DLRS VSS VSS nch
+ l=0.06U
+ w=0.41U
M808 B_QLATCH XGMXB_0_Z1 VSS VSS nch
+ l=0.06U
+ w=0.41U
M809 B_QLATCH XGMXB_0_Z1 VSS VSS nch
+ l=0.06U
+ w=0.41U
M810 B_MX XGMXB_0_GRDTB B_MXN VSS nch
+ l=0.06U
+ w=0.6U
M811 B_MX XGMXB_0_GRDTB B_MXN VSS nch
+ l=0.06U
+ w=0.6U
M812 B_MX XGMXB_0_GRDTB B_MXN VSS nch
+ l=0.06U
+ w=0.6U
M813 B_MX XGMXB_0_GRDTB B_MXN VSS nch
+ l=0.06U
+ w=0.6U
M814 VDD B_GRDT_0 XGMXB_0_GRDTB VDD pch
+ l=0.06U
+ w=1.1U
M815 VDD B_GRDT_0 XGMXB_0_GRDTB VDD
+ pch l=0.06U
+ w=1.1U
M816 VDD XGMXB_0_DLRSB B_GRDT_0 VDD pch
+ l=0.06U
+ w=1.14U
M817 VDD XGMXB_0_DLRSB B_GRDT_0 VDD pch
+ l=0.06U
+ w=1.14U
M818 VDD XGMXB_0_DLRSB B_GRDT_0 VDD pch
+ l=0.06U
+ w=1.14U
M819 B_GRDC_0 XGMXB_0_DLRSB VDD VDD pch
+ l=0.06U
+ w=1.14U
M820 B_GRDC_0 XGMXB_0_DLRSB VDD VDD pch
+ l=0.06U
+ w=1.14U
M821 B_GRDC_0 XGMXB_0_DLRSB VDD VDD pch
+ l=0.06U
+ w=1.14U
M822 VDD XGMXB_0_Z2 XGMXB_0_Z3 VDD
+ pch l=0.06U
+ w=0.41U
M823 B_QLATCH XGMXB_0_Z3 VDD VDD pch
+ l=0.06U
+ w=0.82U
M824 B_QLATCH XGMXB_0_Z3 VDD VDD pch
+ l=0.06U
+ w=0.82U
M825 VDD B_DLRS XGMXB_0_DLRSB VDD pch
+ l=0.06U
+ w=0.82U
M826 B_MX B_GRDC_0 B_MXP VDD pch
+ l=0.06U
+ w=0.75U
M827 B_MX B_GRDC_0 B_MXP VDD pch
+ l=0.06U
+ w=0.75U
M828 B_MX B_GRDC_0 B_MXP VDD pch
+ l=0.06U
+ w=0.75U
M829 B_MX B_GRDC_0 B_MXP VDD pch
+ l=0.06U
+ w=0.75U
M830 VDD B_GRDT_0 XGMXB_0_Z1 VDD
+ pch l=0.06U
+ w=0.41U
M831 VDD B_GRDT_0 B_GRDC_0 VDD pch
+ l=0.06U
+ w=0.41U
M832 B_GRDT_0 B_GRDC_0 VDD VDD pch
+ l=0.06U
+ w=0.41U
M833 VDD XGMXB_0_Z1 B_GRDT_0 VDD pch_hvt
+ l=0.12U
+ w=0.21U
M834 XGMXB_0_Z1 B_GRDT_0 VSS VSS
+ nch l=0.06U
+ w=0.21U
M835 XGWDVB_0_Z1 B_WENB_0 XGWDVB_0_Z2 VSS
+ nch_hvt l=0.06U
+	 w=0.41U
M836 XGWDVB_0_Z5 XGWDVB_0_Z3 VSS VSS
+ nch_hvt l=0.06U
+	 w=0.41U
M837 XGWDVB_0_Z4 B_DHT XGWDVB_0_Z2 VSS nch_hvt
+ l=0.06U
+ w=0.41U
M838 VSS B_BWH XGWDVB_0_Z1 VSS nch_hvt
+ l=0.06U
+ w=0.41U
M839 XGWDVB_0_Z3 B_DHC XGWDVB_0_Z2 VSS nch_hvt
+ l=0.06U
+ w=0.41U
M840 VDD B_WENB_0 XGWDVB_0_Z3 VDD pch_hvt
+ l=0.06U
+ w=0.41U
M841 VDD XGWDVB_0_Z3 XGWDVB_0_Z5 VDD
+ pch_hvt l=0.06U
+	 w=0.41U
M842 VDD XGWDVB_0_Z3 XGWDVB_0_Z5 VDD
+ pch_hvt l=0.06U
+	 w=0.41U
M843 VDD B_BWH XGWDVB_0_Z3 VDD pch_hvt
+ l=0.06U
+ w=0.41U
M844 VDD B_DHC XGWDVB_0_Z3 VDD pch_hvt
+ l=0.06U
+ w=0.41U
M845 XGWDVB_0_Z7 XGWDVB_0_Z5 VSS VSS
+ nch_hvt l=0.06U
+	 w=0.56U
M846 XGWDVB_0_Z7 XGWDVB_0_Z5 VSS VSS
+ nch_hvt l=0.06U
+	 w=0.56U
M847 XGWDVB_0_Z8 XGWDVB_0_Z6 VSS VSS
+ nch_hvt l=0.06U
+	 w=0.56U
M848 XGWDVB_0_Z8 XGWDVB_0_Z6 VSS VSS
+ nch_hvt l=0.06U
+	 w=0.56U
M849 B_GWDC_0 XGWDVB_0_Z7 VSS VSS
+ nch_hvt l=0.06U
+ w=0.56U
M850 B_GWDC_0 XGWDVB_0_Z7 VSS VSS
+ nch_hvt l=0.06U
+	 w=0.56U
M851 B_GWDC_0 XGWDVB_0_Z7 VSS VSS
+ nch_hvt l=0.06U
+	 w=0.56U
M852 B_GWDC_0 XGWDVB_0_Z7 VSS VSS
+ nch_hvt l=0.06U
+	 w=0.56U
M853 B_GWDT_0 XGWDVB_0_Z8 VSS VSS
+ nch_hvt l=0.06U
+ w=0.56U
M854 B_GWDT_0 XGWDVB_0_Z8 VSS VSS
+ nch_hvt l=0.06U
+	 w=0.56U
M855 B_GWDT_0 XGWDVB_0_Z8 VSS VSS
+ nch_hvt l=0.06U
+	 w=0.56U
M856 B_GWDT_0 XGWDVB_0_Z8 VSS VSS
+ nch_hvt l=0.06U
+	 w=0.56U
M857 XDINA_Z12 A_DHC VDD VDD pch
+ l=0.06U
+ w=0.42U
M858 XDINA_Z12 XDINA_CLKC XDINA_Z4 VDD
+ pch l=0.06U
+	 w=0.21U
M859 XDINA_Z4 XDINA_DC XDINA_Z9 VDD
+ pch l=0.1U
+ w=0.42U
M860 XDINA_Z9 A_CKD VDD VDD pch
+ l=0.06U
+ w=0.21U
M861 VDD XDINA_Z4 A_DHC VDD pch
+ l=0.06U
+ w=0.42U
M862 VDD XDINA_Z4 A_DHC VDD pch
+ l=0.06U
+ w=0.42U
M863 VDD XDINA_Z8 A_BWH VDD pch
+ l=0.06U
+ w=0.42U
M864 A_MX XDOUTA_QCKT XDOUTA_Z1 VDD pch
+ l=0.06U
+ w=0.82U
M865 A_BWH XDINA_Z8 VSS VSS nch
+ l=0.06U
+ w=0.41U
M866 VDD XDINA_Z8 A_BWH VDD pch
+ l=0.06U
+ w=0.42U
M867 VSS A_BWH XDINA_Z14 VSS nch
+ l=0.06U
+ w=0.21U
M868 VDD XDOUTA_Z7 XDOUTA_Z1 VDD pch
+ l=0.06U
+ w=0.82U
M869 VDD A_CKD XDINA_Z13 VDD pch
+ l=0.06U
+ w=0.21U
M870 VDD A_MX A_Q VDD pch
+ l=0.06U
+ w=0.75U
M871 XDINA_Z8 A_CKD XDINA_Z14 VSS nch
+ l=0.06U
+ w=0.21U
M872 XDINA_Z13 XDINA_BWC XDINA_Z8 VDD
+ pch l=0.1U
+ w=0.42U
M873 VDD A_MX A_Q VDD pch
+ l=0.06U
+ w=0.75U
M874 XDINA_Z15 XDINA_BWC XDINA_Z8 VSS
+ nch l=0.1U
+ w=0.21U
M875 XDINA_Z16 XDINA_CLKC XDINA_Z8 VDD
+ pch l=0.06U
+	 w=0.21U
M876 VDD A_MX A_Q VDD pch
+ l=0.06U
+ w=0.75U
M877 XDINA_Z16 A_BWH VDD VDD pch
+ l=0.06U
+ w=0.42U
M878 VDD A_MX A_Q VDD pch
+ l=0.06U
+ w=0.75U
M879 VDD XDINA_BWT XDINA_BWC VDD pch
+ l=0.1U
+ w=0.42U
M880 VDD A_BWH XDINA_Z17 VDD pch
+ l=0.06U
+ w=0.42U
M881 VDD A_BWH XDINA_Z17 VDD pch
+ l=0.06U
+ w=0.42U
M882 XDINA_Z19 XDINA_BWC VDD VDD pch
+ l=0.06U
+ w=0.42U
M883 VDD A_CKD XDINA_CLKC VDD pch
+ l=0.06U
+ w=0.21U
M884 XDINA_Z18 XDINA_BWT VDD VDD pch
+ l=0.06U
+ w=0.42U
M885 XDINA_Z18 XDINA_DT A_AWTD VDD pch
+ l=0.06U
+ w=0.42U
M886 A_AWTD XDINA_DC XDINA_Z19 VDD pch
+ l=0.06U
+ w=0.42U
M887 VDD A_DHC A_DHT VDD pch
+ l=0.06U
+ w=0.42U
M888 VDD A_DHC A_DHT VDD pch
+ l=0.06U
+ w=0.42U
M889 VDD XDINA_DT XDINA_DC VDD pch
+ l=0.1U
+ w=0.42U
M890 XDINA_Z26 A_BWEBM VDD VDD pch
+ l=0.1U
+ w=0.42U
M891 VDD XDINA_BWX XDINA_BWT VDD pch
+ l=0.1U
+ w=0.42U
M892 XDINA_Z26 BISTC XDINA_BWX VDD pch
+ l=0.1U
+ w=0.42U
M893 XDINA_BWX BISTT XDINA_Z25 VDD pch
+ l=0.1U
+ w=0.42U
M894 XDINA_Z25 A_BWEB VDD VDD pch
+ l=0.1U
+ w=0.42U
M895 XDINA_DX BISTC XDINA_Z22 VDD pch
+ l=0.1U
+ w=0.42U
M896 XDINA_Z21 BISTT XDINA_DX VDD pch
+ l=0.1U
+ w=0.42U
M897 VDD A_D XDINA_Z21 VDD pch
+ l=0.1U
+ w=0.42U
M898 VDD XDINA_DX XDINA_DT VDD pch
+ l=0.1U
+ w=0.42U
M899 XDINA_Z22 A_DM VDD VDD pch
+ l=0.1U
+ w=0.42U
M900 VDD A_DLRS XDOUTA_DLRSB VDD pch_hvt
+ l=0.06U
+ w=0.21U
M901 VSS XDINA_CLKC XDINA_Z15 VSS nch
+ l=0.06U
+ w=0.21U
M902 XDINA_Z28 A_BWEBM VSS VSS nch
+ l=0.1U
+ w=0.21U
M903 XDINA_BWT XDINA_BWX VSS VSS nch
+ l=0.1U
+ w=0.21U
M904 XDINA_Z28 BISTT XDINA_BWX VSS nch
+ l=0.1U
+ w=0.21U
M905 XDINA_Z23 BISTC XDINA_DX VSS nch
+ l=0.1U
+ w=0.21U
M906 XDINA_Z27 BISTC XDINA_BWX VSS nch
+ l=0.1U
+ w=0.21U
M907 XDINA_Z27 A_BWEB VSS VSS nch
+ l=0.1U
+ w=0.21U
M908 XDINA_Z24 BISTT XDINA_DX VSS nch
+ l=0.1U
+ w=0.21U
M909 XDINA_Z23 A_D VSS VSS nch
+ l=0.1U
+ w=0.21U
M910 XDINA_DT XDINA_DX VSS VSS nch
+ l=0.1U
+ w=0.21U
M911 XDINA_Z24 A_DM VSS VSS nch
+ l=0.1U
+ w=0.21U
M912 XDINA_BWC XDINA_BWT VSS VSS nch
+ l=0.1U
+ w=0.21U
M913 XDINA_Z17 A_BWH VSS VSS nch
+ l=0.06U
+ w=0.41U
M914 A_DHT A_DHC VSS VSS nch
+ l=0.06U
+ w=0.41U
M915 XDINA_DC XDINA_DT VSS VSS nch
+ l=0.1U
+ w=0.21U
M916 XDINA_Z20 XDINA_BWC VSS VSS nch
+ l=0.06U
+	 w=0.21U
M917 XDINA_CLKC A_CKD VSS VSS nch
+ l=0.06U
+ w=0.21U
M918 A_AWTD XDINA_BWT XDINA_Z20 VSS nch
+ l=0.06U
+	 w=0.21U
M919 A_AWTD XDINA_DT XDINA_Z20 VSS nch
+ l=0.06U
+	 w=0.21U
M920 XDINA_Z20 XDINA_DC VSS VSS nch
+ l=0.06U
+	 w=0.21U
M921 XDINA_Z10 A_DHC VSS VSS nch
+ l=0.06U
+ w=0.21U
M922 A_DHC XDINA_Z4 VSS VSS nch
+ l=0.06U
+ w=0.41U
M923 XDINA_Z11 XDINA_DC XDINA_Z4 VSS
+ nch l=0.1U
+ w=0.21U
M924 XDINA_Z11 XDINA_CLKC VSS VSS nch
+ l=0.06U
+ w=0.21U
M925 XDINA_Z10 A_CKD XDINA_Z4 VSS nch
+ l=0.06U
+ w=0.21U
M926 VSS A_AWTD XDOUTA_Z4 VSS nch_hvt
+ l=0.06U
+ w=0.21U
M927 A_MXN XDOUTA_AWTC VSS VSS nch_hvt
+ l=0.06U
+ w=0.8U
M928 A_MXN XDOUTA_AWTC VSS VSS nch_hvt
+ l=0.06U
+ w=0.8U
M929 A_MXN XDOUTA_AWTC VSS VSS nch_hvt
+ l=0.06U
+ w=0.8U
M930 XDOUTA_Z6 XDOUTA_AWTC XDOUTA_Z7 VSS
+ nch_hvt l=0.06U
+	 w=0.21U
M931 XDOUTA_Z4 XDOUTA_AWTT XDOUTA_Z7 VSS
+ nch_hvt l=0.06U
+	 w=0.21U
M932 XDOUTA_Z6 A_QLATCH VSS VSS nch_hvt
+ l=0.06U
+ w=0.21U
M933 VDD XDOUTA_DLRSB XDOUTA_QCKC VDD pch_hvt
+ l=0.06U
+ w=0.41U
M934 VDD XDOUTA_QCKC XDOUTA_QCKT VDD pch_hvt
+ l=0.06U
+ w=0.41U
M935 VDD AWTI XDOUTA_AWTC VDD pch_hvt
+ l=0.06U
+ w=0.42U
M936 VDD XDOUTA_AWTC XDOUTA_QCKC VDD pch_hvt
+ l=0.06U
+ w=0.41U
M937 VDD XDOUTA_AWTC XDOUTA_AWTT VDD pch_hvt
+ l=0.06U
+ w=0.42U
M938 VDD XDOUTA_Z8 A_QLATCH VDD pch_hvt
+ l=0.12U
+ w=0.32U
M939 XDOUTA_Z3 XDOUTA_AWTC XDOUTA_Z7 VDD
+ pch_hvt l=0.06U
+	 w=0.42U
M940 VDD A_AWTD XDOUTA_Z3 VDD pch_hvt
+ l=0.06U
+ w=0.42U
M941 VDD XDOUTA_AWTT A_MXP VDD pch_hvt
+ l=0.06U
+ w=1U
M942 VDD XDOUTA_AWTT A_MXP VDD pch_hvt
+ l=0.06U
+ w=1U
M943 VDD XDOUTA_AWTT A_MXP VDD pch_hvt
+ l=0.06U
+ w=1U
M944 XDOUTA_Z7 XDOUTA_AWTT XDOUTA_Z5 VDD
+ pch_hvt l=0.06U
+	 w=0.42U
M945 VDD A_QLATCH XDOUTA_Z8 VDD pch_hvt
+ l=0.08U
+ w=0.42U
M946 XDOUTA_Z5 A_QLATCH VDD VDD pch_hvt
+ l=0.06U
+ w=0.42U
M947 XDOUTA_XI31_NET9 XDOUTA_DLRSB XDOUTA_QCKC
+ VSS nch_hvt l=0.06U
+	 w=0.41U
M948 XDOUTA_QCKT XDOUTA_QCKC VSS VSS nch_hvt
+ l=0.06U
+ w=0.21U
M949 XDOUTA_AWTC AWTI VSS VSS nch_hvt
+ l=0.06U
+ w=0.21U
M950 VSS XDOUTA_AWTC XDOUTA_XI31_NET9 VSS
+ nch_hvt l=0.06U
+	 w=0.41U
M951 XDOUTA_AWTT XDOUTA_AWTC VSS VSS nch_hvt
+ l=0.06U
+ w=0.21U
M952 A_QLATCH XDOUTA_Z8 VSS VSS nch_hvt
+ l=0.16U
+ w=0.21U
M953 XDOUTA_Z8 A_QLATCH VSS VSS nch_hvt
+ l=0.08U
+ w=0.21U
M954 VDD B_MX B_Q VDD pch
+ l=0.06U
+ w=0.75U
M955 XDINB_Z16 B_BWH VDD VDD pch
+ l=0.06U
+ w=0.42U
M956 VDD B_DLRS XDOUTB_DLRSB VDD pch_hvt
+ l=0.06U
+ w=0.21U
M957 XDINB_Z15 XDINB_CLKC VSS VSS nch
+ l=0.06U
+ w=0.21U
M958 VDD B_MX B_Q VDD pch
+ l=0.06U
+ w=0.75U
M959 XDINB_Z16 XDINB_CLKC XDINB_Z8 VDD
+ pch l=0.06U
+	 w=0.21U
M960 VDD B_MX B_Q VDD pch
+ l=0.06U
+ w=0.75U
M961 XDINB_Z15 XDINB_BWC XDINB_Z8 VSS
+ nch l=0.1U
+ w=0.21U
M962 XDINB_Z13 XDINB_BWC XDINB_Z8 VDD
+ pch l=0.1U
+ w=0.42U
M963 XDINB_Z8 B_CKD XDINB_Z14 VSS nch
+ l=0.06U
+ w=0.21U
M964 VDD B_MX B_Q VDD pch
+ l=0.06U
+ w=0.75U
M965 VDD B_CKD XDINB_Z13 VDD pch
+ l=0.06U
+ w=0.21U
M966 VDD XDOUTB_Z7 XDOUTB_Z1 VDD pch
+ l=0.06U
+ w=0.82U
M967 VSS B_BWH XDINB_Z14 VSS nch
+ l=0.06U
+ w=0.21U
M968 B_MX XDOUTB_QCKT XDOUTB_Z1 VDD pch
+ l=0.06U
+ w=0.82U
M969 VDD XDINB_Z8 B_BWH VDD pch
+ l=0.06U
+ w=0.42U
M970 B_BWH XDINB_Z8 VSS VSS nch
+ l=0.06U
+ w=0.41U
M971 VDD XDINB_Z8 B_BWH VDD pch
+ l=0.06U
+ w=0.42U
M972 VDD XDINB_Z4 B_DHC VDD pch
+ l=0.06U
+ w=0.42U
M973 VDD XDINB_Z4 B_DHC VDD pch
+ l=0.06U
+ w=0.42U
M974 XDINB_Z9 B_CKD VDD VDD pch
+ l=0.06U
+ w=0.21U
M975 XDINB_Z4 XDINB_DC XDINB_Z9 VDD
+ pch l=0.1U
+ w=0.42U
M976 XDINB_Z12 XDINB_CLKC XDINB_Z4 VDD
+ pch l=0.06U
+	 w=0.21U
M977 XDINB_Z12 B_DHC VDD VDD pch
+ l=0.06U
+ w=0.42U
M978 VDD XDINB_BWT XDINB_BWC VDD pch
+ l=0.1U
+ w=0.42U
M979 VDD B_BWH XDINB_Z17 VDD pch
+ l=0.06U
+ w=0.42U
M980 VDD B_BWH XDINB_Z17 VDD pch
+ l=0.06U
+ w=0.42U
M981 XDINB_Z19 XDINB_BWC VDD VDD pch
+ l=0.06U
+ w=0.42U
M982 VDD B_CKD XDINB_CLKC VDD pch
+ l=0.06U
+ w=0.21U
M983 XDINB_Z18 XDINB_BWT VDD VDD pch
+ l=0.06U
+ w=0.42U
M984 XDINB_Z18 XDINB_DT B_AWTD VDD pch
+ l=0.06U
+ w=0.42U
M985 B_AWTD XDINB_DC XDINB_Z19 VDD pch
+ l=0.06U
+ w=0.42U
M986 VDD B_DHC B_DHT VDD pch
+ l=0.06U
+ w=0.42U
M987 VDD B_DHC B_DHT VDD pch
+ l=0.06U
+ w=0.42U
M988 VDD XDINB_DT XDINB_DC VDD pch
+ l=0.1U
+ w=0.42U
M989 XDINB_Z26 B_BWEBM VDD VDD pch
+ l=0.1U
+ w=0.42U
M990 VDD XDINB_BWX XDINB_BWT VDD pch
+ l=0.1U
+ w=0.42U
M991 XDINB_Z26 BISTC XDINB_BWX VDD pch
+ l=0.1U
+ w=0.42U
M992 XDINB_BWX BISTT XDINB_Z25 VDD pch
+ l=0.1U
+ w=0.42U
M993 XDINB_Z25 B_BWEB VDD VDD pch
+ l=0.1U
+ w=0.42U
M994 XDINB_DX BISTC XDINB_Z22 VDD pch
+ l=0.1U
+ w=0.42U
M995 XDINB_Z21 BISTT XDINB_DX VDD pch
+ l=0.1U
+ w=0.42U
M996 VDD B_D XDINB_Z21 VDD pch
+ l=0.1U
+ w=0.42U
M997 VDD XDINB_DX XDINB_DT VDD pch
+ l=0.1U
+ w=0.42U
M998 XDINB_Z22 B_DM VDD VDD pch
+ l=0.1U
+ w=0.42U
M999 XDINB_Z28 B_BWEBM VSS VSS nch
+ l=0.1U
+ w=0.21U
M1000 XDINB_BWT XDINB_BWX VSS VSS nch
+ l=0.1U
+ w=0.21U
M1001 XDINB_Z28 BISTT XDINB_BWX VSS nch
+ l=0.1U
+ w=0.21U
M1002 XDINB_Z23 BISTC XDINB_DX VSS nch
+ l=0.1U
+ w=0.21U
M1003 XDINB_Z27 BISTC XDINB_BWX VSS nch
+ l=0.1U
+ w=0.21U
M1004 XDINB_Z27 B_BWEB VSS VSS nch
+ l=0.1U
+ w=0.21U
M1005 XDINB_Z24 BISTT XDINB_DX VSS nch
+ l=0.1U
+ w=0.21U
M1006 XDINB_Z23 B_D VSS VSS nch
+ l=0.1U
+ w=0.21U
M1007 XDINB_DT XDINB_DX VSS VSS nch
+ l=0.1U
+ w=0.21U
M1008 XDINB_Z24 B_DM VSS VSS nch
+ l=0.1U
+ w=0.21U
M1009 XDINB_BWC XDINB_BWT VSS VSS nch
+ l=0.1U
+ w=0.21U
M1010 XDINB_Z17 B_BWH VSS VSS nch
+ l=0.06U
+ w=0.41U
M1011 B_DHT B_DHC VSS VSS nch
+ l=0.06U
+ w=0.41U
M1012 XDINB_DC XDINB_DT VSS VSS nch
+ l=0.1U
+ w=0.21U
M1013 XDINB_Z20 XDINB_BWC VSS VSS nch
+ l=0.06U
+	 w=0.21U
M1014 XDINB_CLKC B_CKD VSS VSS nch
+ l=0.06U
+ w=0.21U
M1015 B_AWTD XDINB_BWT XDINB_Z20 VSS nch
+ l=0.06U
+	 w=0.21U
M1016 B_AWTD XDINB_DT XDINB_Z20 VSS nch
+ l=0.06U
+	 w=0.21U
M1017 XDINB_Z20 XDINB_DC VSS VSS nch
+ l=0.06U
+	 w=0.21U
M1018 XDINB_Z10 B_DHC VSS VSS nch
+ l=0.06U
+ w=0.21U
M1019 B_DHC XDINB_Z4 VSS VSS nch
+ l=0.06U
+ w=0.41U
M1020 XDINB_Z11 XDINB_DC XDINB_Z4 VSS
+ nch l=0.1U
+ w=0.21U
M1021 XDINB_Z11 XDINB_CLKC VSS VSS nch
+ l=0.06U
+ w=0.21U
M1022 XDINB_Z10 B_CKD XDINB_Z4 VSS nch
+ l=0.06U
+ w=0.21U
M1023 VSS B_AWTD XDOUTB_Z4 VSS nch_hvt
+ l=0.06U
+ w=0.21U
M1024 B_MXN XDOUTB_AWTC VSS VSS nch_hvt
+ l=0.06U
+ w=0.8U
M1025 B_MXN XDOUTB_AWTC VSS VSS nch_hvt
+ l=0.06U
+ w=0.8U
M1026 B_MXN XDOUTB_AWTC VSS VSS nch_hvt
+ l=0.06U
+ w=0.8U
M1027 XDOUTB_Z6 XDOUTB_AWTC XDOUTB_Z7 VSS
+ nch_hvt l=0.06U
+	 w=0.21U
M1028 XDOUTB_Z4 XDOUTB_AWTT XDOUTB_Z7 VSS
+ nch_hvt l=0.06U
+	 w=0.21U
M1029 XDOUTB_Z6 B_QLATCH VSS VSS nch_hvt
+ l=0.06U
+ w=0.21U
M1030 VDD XDOUTB_DLRSB XDOUTB_QCKC VDD pch_hvt
+ l=0.06U
+ w=0.41U
M1031 VDD XDOUTB_QCKC XDOUTB_QCKT VDD pch_hvt
+ l=0.06U
+ w=0.41U
M1032 VDD AWTI XDOUTB_AWTC VDD pch_hvt
+ l=0.06U
+ w=0.42U
M1033 VDD XDOUTB_AWTC XDOUTB_QCKC VDD pch_hvt
+ l=0.06U
+ w=0.41U
M1034 VDD XDOUTB_AWTC XDOUTB_AWTT VDD pch_hvt
+ l=0.06U
+ w=0.42U
M1035 VDD XDOUTB_Z8 B_QLATCH VDD pch_hvt
+ l=0.12U
+ w=0.32U
M1036 XDOUTB_Z3 XDOUTB_AWTC XDOUTB_Z7 VDD
+ pch_hvt l=0.06U
+	 w=0.42U
M1037 VDD B_AWTD XDOUTB_Z3 VDD pch_hvt
+ l=0.06U
+ w=0.42U
M1038 VDD XDOUTB_AWTT B_MXP VDD pch_hvt
+ l=0.06U
+ w=1U
M1039 VDD XDOUTB_AWTT B_MXP VDD pch_hvt
+ l=0.06U
+ w=1U
M1040 VDD XDOUTB_AWTT B_MXP VDD pch_hvt
+ l=0.06U
+ w=1U
M1041 XDOUTB_Z7 XDOUTB_AWTT XDOUTB_Z5 VDD
+ pch_hvt l=0.06U
+	 w=0.42U
M1042 VDD B_QLATCH XDOUTB_Z8 VDD pch_hvt
+ l=0.08U
+ w=0.42U
M1043 XDOUTB_Z5 B_QLATCH VDD VDD pch_hvt
+ l=0.06U
+ w=0.42U
M1044 XDOUTB_XI31_NET9 XDOUTB_DLRSB XDOUTB_QCKC
+ VSS nch_hvt l=0.06U
+	 w=0.41U
M1045 XDOUTB_QCKT XDOUTB_QCKC VSS VSS nch_hvt
+ l=0.06U
+ w=0.21U
M1046 XDOUTB_AWTC AWTI VSS VSS nch_hvt
+ l=0.06U
+ w=0.21U
M1047 VSS XDOUTB_AWTC XDOUTB_XI31_NET9 VSS
+ nch_hvt l=0.06U
+	 w=0.41U
M1048 XDOUTB_AWTT XDOUTB_AWTC VSS VSS nch_hvt
+ l=0.06U
+ w=0.21U
M1049 B_QLATCH XDOUTB_Z8 VSS VSS nch_hvt
+ l=0.16U
+ w=0.21U
M1050 XDOUTB_Z8 B_QLATCH VSS VSS nch_hvt
+ l=0.08U
+ w=0.21U
M1051 VDD XGWDVA_1_Z5 XGWDVA_1_Z7 VDD
+ pch_hvt l=0.06U
+	 w=0.56U
M1052 VDD XGWDVA_1_Z5 XGWDVA_1_Z7 VDD
+ pch_hvt l=0.06U
+	 w=0.56U
M1053 VDD XGWDVA_1_Z7 A_GWDC_1 VDD
+ pch_hvt l=0.07U
+	 w=1.4U
M1054 VDD XGWDVA_1_Z7 A_GWDC_1 VDD
+ pch_hvt l=0.07U
+ w=1.4U
M1055 VDD XGWDVA_1_Z7 A_GWDC_1 VDD
+ pch_hvt l=0.07U
+ w=1.4U
M1056 VDD XGWDVA_1_Z7 A_GWDC_1 VDD
+ pch_hvt l=0.07U
+ w=1.4U
M1057 VDD XGWDVA_1_Z8 A_GWDT_1 VDD
+ pch_hvt l=0.07U
+ w=1.4U
M1058 VDD XGWDVA_1_Z8 A_GWDT_1 VDD
+ pch_hvt l=0.07U
+ w=1.4U
M1059 VDD A_DHT XGWDVA_1_Z4 VDD pch_hvt
+ l=0.06U
+ w=0.41U
M1060 VDD XGWDVA_1_Z8 A_GWDT_1 VDD
+ pch_hvt l=0.07U
+ w=1.4U
M1061 VDD A_WENB_1 XGWDVA_1_Z4 VDD pch_hvt
+ l=0.06U
+ w=0.41U
M1062 VDD XGWDVA_1_Z8 A_GWDT_1 VDD
+ pch_hvt l=0.07U
+	 w=1.4U
M1063 VDD A_BWH XGWDVA_1_Z4 VDD pch_hvt
+ l=0.06U
+ w=0.41U
M1064 VDD XGWDVA_1_Z6 XGWDVA_1_Z8 VDD
+ pch_hvt l=0.06U
+	 w=0.56U
M1065 VDD XGWDVA_1_Z4 XGWDVA_1_Z6 VDD
+ pch_hvt l=0.06U
+ w=0.41U
M1066 VDD A_GRDC_1 XGMXA_1_Z2 VDD
+ pch l=0.06U
+ w=0.41U
M1067 VDD XGWDVA_1_Z4 XGWDVA_1_Z6 VDD
+ pch_hvt l=0.06U
+	 w=0.41U
M1068 VDD XGWDVA_1_Z6 XGWDVA_1_Z8 VDD
+ pch_hvt l=0.06U
+	 w=0.56U
M1069 VDD XGMXA_1_Z2 A_GRDC_1 VDD pch_hvt
+ l=0.12U
+	 w=0.21U
M1070 XGMXA_1_GRDTB A_GRDT_1 VSS VSS nch
+ l=0.06U
+ w=0.41U
M1071 XGMXA_1_GRDTB A_GRDT_1 VSS VSS
+ nch l=0.06U
+ w=0.41U
M1072 XGMXA_1_Z3 XGMXA_1_Z2 VSS VSS
+ nch l=0.06U
+ w=0.41U
M1073 XGMXA_1_DLRSB A_DLRS VSS VSS nch
+ l=0.06U
+ w=0.41U
M1074 A_QLATCH XGMXA_1_Z1 VSS VSS nch
+ l=0.06U
+ w=0.41U
M1075 A_QLATCH XGMXA_1_Z1 VSS VSS nch
+ l=0.06U
+ w=0.41U
M1076 A_MX XGMXA_1_GRDTB A_MXN VSS nch
+ l=0.06U
+ w=0.6U
M1077 A_MX XGMXA_1_GRDTB A_MXN VSS nch
+ l=0.06U
+ w=0.6U
M1078 A_MX XGMXA_1_GRDTB A_MXN VSS nch
+ l=0.06U
+ w=0.6U
M1079 A_MX XGMXA_1_GRDTB A_MXN VSS nch
+ l=0.06U
+ w=0.6U
M1080 VDD A_GRDT_1 XGMXA_1_GRDTB VDD pch
+ l=0.06U
+ w=1.1U
M1081 VDD A_GRDT_1 XGMXA_1_GRDTB VDD
+ pch l=0.06U
+ w=1.1U
M1082 VDD XGMXA_1_DLRSB A_GRDT_1 VDD pch
+ l=0.06U
+ w=1.14U
M1083 VDD XGMXA_1_DLRSB A_GRDT_1 VDD pch
+ l=0.06U
+ w=1.14U
M1084 VDD XGMXA_1_DLRSB A_GRDT_1 VDD pch
+ l=0.06U
+ w=1.14U
M1085 A_GRDC_1 XGMXA_1_DLRSB VDD VDD pch
+ l=0.06U
+ w=1.14U
M1086 A_GRDC_1 XGMXA_1_DLRSB VDD VDD pch
+ l=0.06U
+ w=1.14U
M1087 A_GRDC_1 XGMXA_1_DLRSB VDD VDD pch
+ l=0.06U
+ w=1.14U
M1088 VDD XGMXA_1_Z2 XGMXA_1_Z3 VDD
+ pch l=0.06U
+ w=0.41U
M1089 A_QLATCH XGMXA_1_Z3 VDD VDD pch
+ l=0.06U
+ w=0.82U
M1090 A_QLATCH XGMXA_1_Z3 VDD VDD pch
+ l=0.06U
+ w=0.82U
M1091 VDD A_DLRS XGMXA_1_DLRSB VDD pch
+ l=0.06U
+ w=0.82U
M1092 A_MX A_GRDC_1 A_MXP VDD pch
+ l=0.06U
+ w=0.75U
M1093 A_MX A_GRDC_1 A_MXP VDD pch
+ l=0.06U
+ w=0.75U
M1094 A_MX A_GRDC_1 A_MXP VDD pch
+ l=0.06U
+ w=0.75U
M1095 A_MX A_GRDC_1 A_MXP VDD pch
+ l=0.06U
+ w=0.75U
M1096 VDD A_GRDT_1 XGMXA_1_Z1 VDD
+ pch l=0.06U
+ w=0.41U
M1097 VDD A_GRDT_1 A_GRDC_1 VDD pch
+ l=0.06U
+ w=0.41U
M1098 A_GRDT_1 A_GRDC_1 VDD VDD pch
+ l=0.06U
+ w=0.41U
M1099 VDD XGMXA_1_Z1 A_GRDT_1 VDD pch_hvt
+ l=0.12U
+ w=0.21U
M1100 XGMXA_1_Z1 A_GRDT_1 VSS VSS
+ nch l=0.06U
+ w=0.21U
M1101 XGWDVA_1_Z1 A_WENB_1 XGWDVA_1_Z2 VSS
+ nch_hvt l=0.06U
+	 w=0.41U
M1102 XGWDVA_1_Z5 XGWDVA_1_Z3 VSS VSS
+ nch_hvt l=0.06U
+	 w=0.41U
M1103 XGWDVA_1_Z4 A_DHT XGWDVA_1_Z2 VSS nch_hvt
+ l=0.06U
+ w=0.41U
M1104 VSS A_BWH XGWDVA_1_Z1 VSS nch_hvt
+ l=0.06U
+ w=0.41U
M1105 XGWDVA_1_Z3 A_DHC XGWDVA_1_Z2 VSS nch_hvt
+ l=0.06U
+ w=0.41U
M1106 VDD A_WENB_1 XGWDVA_1_Z3 VDD pch_hvt
+ l=0.06U
+ w=0.41U
M1107 VDD XGWDVA_1_Z3 XGWDVA_1_Z5 VDD
+ pch_hvt l=0.06U
+	 w=0.41U
M1108 VDD XGWDVA_1_Z3 XGWDVA_1_Z5 VDD
+ pch_hvt l=0.06U
+	 w=0.41U
M1109 VDD A_BWH XGWDVA_1_Z3 VDD pch_hvt
+ l=0.06U
+ w=0.41U
M1110 VDD A_DHC XGWDVA_1_Z3 VDD pch_hvt
+ l=0.06U
+ w=0.41U
M1111 XGWDVA_1_Z7 XGWDVA_1_Z5 VSS VSS
+ nch_hvt l=0.06U
+	 w=0.56U
M1112 XGWDVA_1_Z7 XGWDVA_1_Z5 VSS VSS
+ nch_hvt l=0.06U
+	 w=0.56U
M1113 XGWDVA_1_Z8 XGWDVA_1_Z6 VSS VSS
+ nch_hvt l=0.06U
+	 w=0.56U
M1114 XGWDVA_1_Z8 XGWDVA_1_Z6 VSS VSS
+ nch_hvt l=0.06U
+	 w=0.56U
M1115 A_GWDC_1 XGWDVA_1_Z7 VSS VSS
+ nch_hvt l=0.06U
+ w=0.56U
M1116 A_GWDC_1 XGWDVA_1_Z7 VSS VSS
+ nch_hvt l=0.06U
+	 w=0.56U
M1117 A_GWDC_1 XGWDVA_1_Z7 VSS VSS
+ nch_hvt l=0.06U
+	 w=0.56U
M1118 A_GWDC_1 XGWDVA_1_Z7 VSS VSS
+ nch_hvt l=0.06U
+	 w=0.56U
M1119 A_GWDT_1 XGWDVA_1_Z8 VSS VSS
+ nch_hvt l=0.06U
+ w=0.56U
M1120 A_GWDT_1 XGWDVA_1_Z8 VSS VSS
+ nch_hvt l=0.06U
+	 w=0.56U
M1121 A_GWDT_1 XGWDVA_1_Z8 VSS VSS
+ nch_hvt l=0.06U
+	 w=0.56U
M1122 A_GWDT_1 XGWDVA_1_Z8 VSS VSS
+ nch_hvt l=0.06U
+	 w=0.56U
M1123 VDD B_GRDC_1 XGMXB_1_Z2 VDD
+ pch l=0.06U
+ w=0.41U
M1124 VDD XGWDVB_1_Z4 XGWDVB_1_Z6 VDD
+ pch_hvt l=0.06U
+	 w=0.41U
M1125 VDD XGWDVB_1_Z6 XGWDVB_1_Z8 VDD
+ pch_hvt l=0.06U
+	 w=0.56U
M1126 VDD XGMXB_1_Z2 B_GRDC_1 VDD pch_hvt
+ l=0.12U
+	 w=0.21U
M1127 VDD XGWDVB_1_Z4 XGWDVB_1_Z6 VDD
+ pch_hvt l=0.06U
+	 w=0.41U
M1128 VDD XGWDVB_1_Z6 XGWDVB_1_Z8 VDD
+ pch_hvt l=0.06U
+	 w=0.56U
M1129 VDD B_BWH XGWDVB_1_Z4 VDD pch_hvt
+ l=0.06U
+ w=0.41U
M1130 VDD XGWDVB_1_Z8 B_GWDT_1 VDD
+ pch_hvt l=0.07U
+	 w=1.4U
M1131 VDD B_WENB_1 XGWDVB_1_Z4 VDD pch_hvt
+ l=0.06U
+ w=0.41U
M1132 VDD XGWDVB_1_Z8 B_GWDT_1 VDD
+ pch_hvt l=0.07U
+ w=1.4U
M1133 VDD B_DHT XGWDVB_1_Z4 VDD pch_hvt
+ l=0.06U
+ w=0.41U
M1134 VDD XGWDVB_1_Z8 B_GWDT_1 VDD
+ pch_hvt l=0.07U
+ w=1.4U
M1135 VDD XGWDVB_1_Z8 B_GWDT_1 VDD
+ pch_hvt l=0.07U
+ w=1.4U
M1136 VDD XGWDVB_1_Z7 B_GWDC_1 VDD
+ pch_hvt l=0.07U
+ w=1.4U
M1137 VDD XGWDVB_1_Z7 B_GWDC_1 VDD
+ pch_hvt l=0.07U
+ w=1.4U
M1138 VDD XGWDVB_1_Z7 B_GWDC_1 VDD
+ pch_hvt l=0.07U
+ w=1.4U
M1139 VDD XGWDVB_1_Z7 B_GWDC_1 VDD
+ pch_hvt l=0.07U
+	 w=1.4U
M1140 VDD XGWDVB_1_Z5 XGWDVB_1_Z7 VDD
+ pch_hvt l=0.06U
+	 w=0.56U
M1141 VDD XGWDVB_1_Z5 XGWDVB_1_Z7 VDD
+ pch_hvt l=0.06U
+	 w=0.56U
M1142 XGMXB_1_GRDTB B_GRDT_1 VSS VSS nch
+ l=0.06U
+ w=0.41U
M1143 XGMXB_1_GRDTB B_GRDT_1 VSS VSS
+ nch l=0.06U
+ w=0.41U
M1144 XGMXB_1_Z3 XGMXB_1_Z2 VSS VSS
+ nch l=0.06U
+ w=0.41U
M1145 XGMXB_1_DLRSB B_DLRS VSS VSS nch
+ l=0.06U
+ w=0.41U
M1146 B_QLATCH XGMXB_1_Z1 VSS VSS nch
+ l=0.06U
+ w=0.41U
M1147 B_QLATCH XGMXB_1_Z1 VSS VSS nch
+ l=0.06U
+ w=0.41U
M1148 B_MX XGMXB_1_GRDTB B_MXN VSS nch
+ l=0.06U
+ w=0.6U
M1149 B_MX XGMXB_1_GRDTB B_MXN VSS nch
+ l=0.06U
+ w=0.6U
M1150 B_MX XGMXB_1_GRDTB B_MXN VSS nch
+ l=0.06U
+ w=0.6U
M1151 B_MX XGMXB_1_GRDTB B_MXN VSS nch
+ l=0.06U
+ w=0.6U
M1152 VDD B_GRDT_1 XGMXB_1_GRDTB VDD pch
+ l=0.06U
+ w=1.1U
M1153 VDD B_GRDT_1 XGMXB_1_GRDTB VDD
+ pch l=0.06U
+ w=1.1U
M1154 VDD XGMXB_1_DLRSB B_GRDT_1 VDD pch
+ l=0.06U
+ w=1.14U
M1155 VDD XGMXB_1_DLRSB B_GRDT_1 VDD pch
+ l=0.06U
+ w=1.14U
M1156 VDD XGMXB_1_DLRSB B_GRDT_1 VDD pch
+ l=0.06U
+ w=1.14U
M1157 B_GRDC_1 XGMXB_1_DLRSB VDD VDD pch
+ l=0.06U
+ w=1.14U
M1158 B_GRDC_1 XGMXB_1_DLRSB VDD VDD pch
+ l=0.06U
+ w=1.14U
M1159 B_GRDC_1 XGMXB_1_DLRSB VDD VDD pch
+ l=0.06U
+ w=1.14U
M1160 VDD XGMXB_1_Z2 XGMXB_1_Z3 VDD
+ pch l=0.06U
+ w=0.41U
M1161 B_QLATCH XGMXB_1_Z3 VDD VDD pch
+ l=0.06U
+ w=0.82U
M1162 B_QLATCH XGMXB_1_Z3 VDD VDD pch
+ l=0.06U
+ w=0.82U
M1163 VDD B_DLRS XGMXB_1_DLRSB VDD pch
+ l=0.06U
+ w=0.82U
M1164 B_MX B_GRDC_1 B_MXP VDD pch
+ l=0.06U
+ w=0.75U
M1165 B_MX B_GRDC_1 B_MXP VDD pch
+ l=0.06U
+ w=0.75U
M1166 B_MX B_GRDC_1 B_MXP VDD pch
+ l=0.06U
+ w=0.75U
M1167 B_MX B_GRDC_1 B_MXP VDD pch
+ l=0.06U
+ w=0.75U
M1168 VDD B_GRDT_1 XGMXB_1_Z1 VDD
+ pch l=0.06U
+ w=0.41U
M1169 VDD B_GRDT_1 B_GRDC_1 VDD pch
+ l=0.06U
+ w=0.41U
M1170 B_GRDT_1 B_GRDC_1 VDD VDD pch
+ l=0.06U
+ w=0.41U
M1171 VDD XGMXB_1_Z1 B_GRDT_1 VDD pch_hvt
+ l=0.12U
+ w=0.21U
M1172 XGMXB_1_Z1 B_GRDT_1 VSS VSS
+ nch l=0.06U
+ w=0.21U
M1173 XGWDVB_1_Z1 B_WENB_1 XGWDVB_1_Z2 VSS
+ nch_hvt l=0.06U
+	 w=0.41U
M1174 XGWDVB_1_Z5 XGWDVB_1_Z3 VSS VSS
+ nch_hvt l=0.06U
+	 w=0.41U
M1175 XGWDVB_1_Z4 B_DHT XGWDVB_1_Z2 VSS nch_hvt
+ l=0.06U
+ w=0.41U
M1176 VSS B_BWH XGWDVB_1_Z1 VSS nch_hvt
+ l=0.06U
+ w=0.41U
M1177 XGWDVB_1_Z3 B_DHC XGWDVB_1_Z2 VSS nch_hvt
+ l=0.06U
+ w=0.41U
M1178 VDD B_WENB_1 XGWDVB_1_Z3 VDD pch_hvt
+ l=0.06U
+ w=0.41U
M1179 VDD XGWDVB_1_Z3 XGWDVB_1_Z5 VDD
+ pch_hvt l=0.06U
+	 w=0.41U
M1180 VDD XGWDVB_1_Z3 XGWDVB_1_Z5 VDD
+ pch_hvt l=0.06U
+	 w=0.41U
M1181 VDD B_BWH XGWDVB_1_Z3 VDD pch_hvt
+ l=0.06U
+ w=0.41U
M1182 VDD B_DHC XGWDVB_1_Z3 VDD pch_hvt
+ l=0.06U
+ w=0.41U
M1183 XGWDVB_1_Z7 XGWDVB_1_Z5 VSS VSS
+ nch_hvt l=0.06U
+	 w=0.56U
M1184 XGWDVB_1_Z7 XGWDVB_1_Z5 VSS VSS
+ nch_hvt l=0.06U
+	 w=0.56U
M1185 XGWDVB_1_Z8 XGWDVB_1_Z6 VSS VSS
+ nch_hvt l=0.06U
+	 w=0.56U
M1186 XGWDVB_1_Z8 XGWDVB_1_Z6 VSS VSS
+ nch_hvt l=0.06U
+	 w=0.56U
M1187 B_GWDC_1 XGWDVB_1_Z7 VSS VSS
+ nch_hvt l=0.06U
+ w=0.56U
M1188 B_GWDC_1 XGWDVB_1_Z7 VSS VSS
+ nch_hvt l=0.06U
+	 w=0.56U
M1189 B_GWDC_1 XGWDVB_1_Z7 VSS VSS
+ nch_hvt l=0.06U
+	 w=0.56U
M1190 B_GWDC_1 XGWDVB_1_Z7 VSS VSS
+ nch_hvt l=0.06U
+	 w=0.56U
M1191 B_GWDT_1 XGWDVB_1_Z8 VSS VSS
+ nch_hvt l=0.06U
+ w=0.56U
M1192 B_GWDT_1 XGWDVB_1_Z8 VSS VSS
+ nch_hvt l=0.06U
+	 w=0.56U
M1193 B_GWDT_1 XGWDVB_1_Z8 VSS VSS
+ nch_hvt l=0.06U
+	 w=0.56U
M1194 B_GWDT_1 XGWDVB_1_Z8 VSS VSS
+ nch_hvt l=0.06U
+	 w=0.56U
M1195 B_MX XDOUTB_QCKC XDOUTB_Z2 VSS nch
+ l=0.06U
+ w=0.42U
M1196 VSS XDOUTB_Z7 XDOUTB_Z2 VSS nch
+ l=0.06U
+ w=0.42U
M1197 B_Q B_MX VSS VSS nch
+ l=0.06U
+ w=0.375U
M1198 B_Q B_MX VSS VSS nch
+ l=0.06U
+ w=0.375U
M1199 B_Q B_MX VSS VSS nch
+ l=0.06U
+ w=0.375U
M1200 B_Q B_MX VSS VSS nch
+ l=0.06U
+ w=0.375U
M1201 A_MX XDOUTA_QCKC XDOUTA_Z2 VSS nch
+ l=0.06U
+ w=0.42U
M1202 VSS XDOUTA_Z7 XDOUTA_Z2 VSS nch
+ l=0.06U
+ w=0.42U
M1203 A_Q A_MX VSS VSS nch
+ l=0.06U
+ w=0.375U
M1204 A_Q A_MX VSS VSS nch
+ l=0.06U
+ w=0.375U
M1205 A_Q A_MX VSS VSS nch
+ l=0.06U
+ w=0.375U
M1206 A_Q A_MX VSS VSS nch
+ l=0.06U
+ w=0.375U
M1207 XDOUTB_DLRSB B_DLRS VSS VSS nch_hvt
+ l=0.06U
+ w=0.21U
M1208 XDOUTA_DLRSB A_DLRS VSS VSS nch_hvt
+ l=0.06U
+ w=0.21U
M1209 XGWDVA_1_Z6 XGWDVA_1_Z4 VSS VSS
+ nch_hvt l=0.06U
+	 w=0.41U
M1210 XGWDVB_1_Z6 XGWDVB_1_Z4 VSS VSS
+ nch_hvt l=0.06U
+	 w=0.41U
M1211 XGWDVB_0_Z6 XGWDVB_0_Z4 VSS VSS
+ nch_hvt l=0.06U
+	 w=0.41U
M1212 XGWDVA_0_Z6 XGWDVA_0_Z4 VSS VSS
+ nch_hvt l=0.06U
+	 w=0.41U
M1213 XGMXB_1_Z2 B_GRDC_1 VSS VSS
+ nch l=0.06U
+ w=0.21U
M1214 XGMXA_1_Z2 A_GRDC_1 VSS VSS
+ nch l=0.06U
+ w=0.21U
M1215 XGMXA_0_Z2 A_GRDC_0 VSS VSS
+ nch l=0.06U
+ w=0.21U
M1216 XGMXB_0_Z2 B_GRDC_0 VSS VSS
+ nch l=0.06U
+ w=0.21U
.ENDS
* BIT84
.SUBCKT SDL400W20S_BIT84 AWTI A_BWEB A_BWEBM A_CKD A_D A_DLRS A_DM
+	 A_WENB_3 A_WENB_2 A_WENB_1 A_WENB_0 BISTC BISTT B_BWEB
+	 B_BWEBM B_CKD B_D B_DLRS B_DM B_WENB_3 B_WENB_2 B_WENB_1
+	 B_WENB_0 A_GWDC_3 A_GWDC_2 A_GWDC_1 A_GWDC_0 A_GWDT_3
+	 A_GWDT_2 A_GWDT_1 A_GWDT_0 A_Q B_GWDC_3 B_GWDC_2 B_GWDC_1
+	 B_GWDC_0 B_GWDT_3 B_GWDT_2 B_GWDT_1 B_GWDT_0 B_Q A_GRDC_3
+	 A_GRDC_2 A_GRDC_1 A_GRDC_0 A_GRDT_3 A_GRDT_2 A_GRDT_1
+	 A_GRDT_0 B_GRDC_3 B_GRDC_2 B_GRDC_1 B_GRDC_0 B_GRDT_3
+	 B_GRDT_2 B_GRDT_1 B_GRDT_0
M1217 VDD XGWDVA_0_Z5 XGWDVA_0_Z7 VDD
+ pch_hvt l=0.06U
+	 w=0.56U
M1218 VDD XGWDVA_0_Z5 XGWDVA_0_Z7 VDD
+ pch_hvt l=0.06U
+	 w=0.56U
M1219 VDD XGWDVA_0_Z7 A_GWDC_0 VDD
+ pch_hvt l=0.07U
+	 w=1.4U
M1220 VDD XGWDVA_0_Z7 A_GWDC_0 VDD
+ pch_hvt l=0.07U
+ w=1.4U
M1221 VDD XGWDVA_0_Z7 A_GWDC_0 VDD
+ pch_hvt l=0.07U
+ w=1.4U
M1222 VDD XGWDVA_0_Z7 A_GWDC_0 VDD
+ pch_hvt l=0.07U
+ w=1.4U
M1223 VDD XGWDVA_0_Z8 A_GWDT_0 VDD
+ pch_hvt l=0.07U
+ w=1.4U
M1224 VDD XGWDVA_0_Z8 A_GWDT_0 VDD
+ pch_hvt l=0.07U
+ w=1.4U
M1225 VDD A_DHT XGWDVA_0_Z4 VDD pch_hvt
+ l=0.06U
+ w=0.41U
M1226 VDD XGWDVA_0_Z8 A_GWDT_0 VDD
+ pch_hvt l=0.07U
+ w=1.4U
M1227 VDD A_WENB_0 XGWDVA_0_Z4 VDD pch_hvt
+ l=0.06U
+ w=0.41U
M1228 VDD XGWDVA_0_Z8 A_GWDT_0 VDD
+ pch_hvt l=0.07U
+	 w=1.4U
M1229 VDD A_BWH XGWDVA_0_Z4 VDD pch_hvt
+ l=0.06U
+ w=0.41U
M1230 VDD XGWDVA_0_Z6 XGWDVA_0_Z8 VDD
+ pch_hvt l=0.06U
+	 w=0.56U
M1231 VDD XGWDVA_0_Z4 XGWDVA_0_Z6 VDD
+ pch_hvt l=0.06U
+	 w=0.41U
M1232 VDD A_GRDC_0 XGMXA_0_Z2 VDD
+ pch l=0.06U
+ w=0.41U
M1233 VDD XGWDVA_0_Z4 XGWDVA_0_Z6 VDD
+ pch_hvt l=0.06U
+	 w=0.41U
M1234 VDD XGWDVA_0_Z6 XGWDVA_0_Z8 VDD
+ pch_hvt l=0.06U
+	 w=0.56U
M1235 VDD XGMXA_0_Z2 A_GRDC_0 VDD pch_hvt
+ l=0.12U
+	 w=0.21U
M1236 XGMXA_0_GRDTB A_GRDT_0 VSS VSS nch
+ l=0.06U
+ w=0.41U
M1237 XGMXA_0_GRDTB A_GRDT_0 VSS VSS
+ nch l=0.06U
+ w=0.41U
M1238 XGMXA_0_Z3 XGMXA_0_Z2 VSS VSS
+ nch l=0.06U
+ w=0.41U
M1239 XGMXA_0_DLRSB A_DLRS VSS VSS nch
+ l=0.06U
+ w=0.41U
M1240 A_QLATCH XGMXA_0_Z1 VSS VSS nch
+ l=0.06U
+ w=0.41U
M1241 A_QLATCH XGMXA_0_Z1 VSS VSS nch
+ l=0.06U
+ w=0.41U
M1242 A_MX XGMXA_0_GRDTB A_MXN VSS nch
+ l=0.06U
+ w=0.6U
M1243 A_MX XGMXA_0_GRDTB A_MXN VSS nch
+ l=0.06U
+ w=0.6U
M1244 A_MX XGMXA_0_GRDTB A_MXN VSS nch
+ l=0.06U
+ w=0.6U
M1245 A_MX XGMXA_0_GRDTB A_MXN VSS nch
+ l=0.06U
+ w=0.6U
M1246 VDD A_GRDT_0 XGMXA_0_GRDTB VDD pch
+ l=0.06U
+ w=1.1U
M1247 VDD A_GRDT_0 XGMXA_0_GRDTB VDD
+ pch l=0.06U
+ w=1.1U
M1248 VDD XGMXA_0_DLRSB A_GRDT_0 VDD pch
+ l=0.06U
+ w=1.14U
M1249 VDD XGMXA_0_DLRSB A_GRDT_0 VDD pch
+ l=0.06U
+ w=1.14U
M1250 VDD XGMXA_0_DLRSB A_GRDT_0 VDD pch
+ l=0.06U
+ w=1.14U
M1251 A_GRDC_0 XGMXA_0_DLRSB VDD VDD pch
+ l=0.06U
+ w=1.14U
M1252 A_GRDC_0 XGMXA_0_DLRSB VDD VDD pch
+ l=0.06U
+ w=1.14U
M1253 A_GRDC_0 XGMXA_0_DLRSB VDD VDD pch
+ l=0.06U
+ w=1.14U
M1254 VDD XGMXA_0_Z2 XGMXA_0_Z3 VDD
+ pch l=0.06U
+ w=0.41U
M1255 A_QLATCH XGMXA_0_Z3 VDD VDD pch
+ l=0.06U
+ w=0.82U
M1256 A_QLATCH XGMXA_0_Z3 VDD VDD pch
+ l=0.06U
+ w=0.82U
M1257 VDD A_DLRS XGMXA_0_DLRSB VDD pch
+ l=0.06U
+ w=0.82U
M1258 A_MX A_GRDC_0 A_MXP VDD pch
+ l=0.06U
+ w=0.75U
M1259 A_MX A_GRDC_0 A_MXP VDD pch
+ l=0.06U
+ w=0.75U
M1260 A_MX A_GRDC_0 A_MXP VDD pch
+ l=0.06U
+ w=0.75U
M1261 A_MX A_GRDC_0 A_MXP VDD pch
+ l=0.06U
+ w=0.75U
M1262 VDD A_GRDT_0 XGMXA_0_Z1 VDD
+ pch l=0.06U
+ w=0.41U
M1263 VDD A_GRDT_0 A_GRDC_0 VDD pch
+ l=0.06U
+ w=0.41U
M1264 A_GRDT_0 A_GRDC_0 VDD VDD pch
+ l=0.06U
+ w=0.41U
M1265 VDD XGMXA_0_Z1 A_GRDT_0 VDD pch_hvt
+ l=0.12U
+ w=0.21U
M1266 XGMXA_0_Z1 A_GRDT_0 VSS VSS
+ nch l=0.06U
+ w=0.21U
M1267 XGWDVA_0_Z1 A_WENB_0 XGWDVA_0_Z2 VSS
+ nch_hvt l=0.06U
+	 w=0.41U
M1268 XGWDVA_0_Z5 XGWDVA_0_Z3 VSS VSS
+ nch_hvt l=0.06U
+	 w=0.41U
M1269 XGWDVA_0_Z4 A_DHT XGWDVA_0_Z2 VSS nch_hvt
+ l=0.06U
+ w=0.41U
M1270 VSS A_BWH XGWDVA_0_Z1 VSS nch_hvt
+ l=0.06U
+ w=0.41U
M1271 XGWDVA_0_Z3 A_DHC XGWDVA_0_Z2 VSS nch_hvt
+ l=0.06U
+ w=0.41U
M1272 VDD A_WENB_0 XGWDVA_0_Z3 VDD pch_hvt
+ l=0.06U
+ w=0.41U
M1273 VDD XGWDVA_0_Z3 XGWDVA_0_Z5 VDD
+ pch_hvt l=0.06U
+	 w=0.41U
M1274 VDD XGWDVA_0_Z3 XGWDVA_0_Z5 VDD
+ pch_hvt l=0.06U
+	 w=0.41U
M1275 VDD A_BWH XGWDVA_0_Z3 VDD pch_hvt
+ l=0.06U
+ w=0.41U
M1276 VDD A_DHC XGWDVA_0_Z3 VDD pch_hvt
+ l=0.06U
+ w=0.41U
M1277 XGWDVA_0_Z7 XGWDVA_0_Z5 VSS VSS
+ nch_hvt l=0.06U
+	 w=0.56U
M1278 XGWDVA_0_Z7 XGWDVA_0_Z5 VSS VSS
+ nch_hvt l=0.06U
+	 w=0.56U
M1279 XGWDVA_0_Z8 XGWDVA_0_Z6 VSS VSS
+ nch_hvt l=0.06U
+	 w=0.56U
M1280 XGWDVA_0_Z8 XGWDVA_0_Z6 VSS VSS
+ nch_hvt l=0.06U
+	 w=0.56U
M1281 A_GWDC_0 XGWDVA_0_Z7 VSS VSS
+ nch_hvt l=0.06U
+ w=0.56U
M1282 A_GWDC_0 XGWDVA_0_Z7 VSS VSS
+ nch_hvt l=0.06U
+	 w=0.56U
M1283 A_GWDC_0 XGWDVA_0_Z7 VSS VSS
+ nch_hvt l=0.06U
+	 w=0.56U
M1284 A_GWDC_0 XGWDVA_0_Z7 VSS VSS
+ nch_hvt l=0.06U
+	 w=0.56U
M1285 A_GWDT_0 XGWDVA_0_Z8 VSS VSS
+ nch_hvt l=0.06U
+ w=0.56U
M1286 A_GWDT_0 XGWDVA_0_Z8 VSS VSS
+ nch_hvt l=0.06U
+	 w=0.56U
M1287 A_GWDT_0 XGWDVA_0_Z8 VSS VSS
+ nch_hvt l=0.06U
+	 w=0.56U
M1288 A_GWDT_0 XGWDVA_0_Z8 VSS VSS
+ nch_hvt l=0.06U
+	 w=0.56U
M1289 VDD B_GRDC_0 XGMXB_0_Z2 VDD
+ pch l=0.06U
+ w=0.41U
M1290 VDD XGWDVB_0_Z4 XGWDVB_0_Z6 VDD
+ pch_hvt l=0.06U
+	 w=0.41U
M1291 VDD XGWDVB_0_Z6 XGWDVB_0_Z8 VDD
+ pch_hvt l=0.06U
+	 w=0.56U
M1292 VDD XGMXB_0_Z2 B_GRDC_0 VDD pch_hvt
+ l=0.12U
+	 w=0.21U
M1293 VDD XGWDVB_0_Z4 XGWDVB_0_Z6 VDD
+ pch_hvt l=0.06U
+	 w=0.41U
M1294 VDD XGWDVB_0_Z6 XGWDVB_0_Z8 VDD
+ pch_hvt l=0.06U
+	 w=0.56U
M1295 VDD B_BWH XGWDVB_0_Z4 VDD pch_hvt
+ l=0.06U
+ w=0.41U
M1296 VDD XGWDVB_0_Z8 B_GWDT_0 VDD
+ pch_hvt l=0.07U
+	 w=1.4U
M1297 VDD B_WENB_0 XGWDVB_0_Z4 VDD pch_hvt
+ l=0.06U
+ w=0.41U
M1298 VDD XGWDVB_0_Z8 B_GWDT_0 VDD
+ pch_hvt l=0.07U
+ w=1.4U
M1299 VDD B_DHT XGWDVB_0_Z4 VDD pch_hvt
+ l=0.06U
+ w=0.41U
M1300 VDD XGWDVB_0_Z8 B_GWDT_0 VDD
+ pch_hvt l=0.07U
+ w=1.4U
M1301 VDD XGWDVB_0_Z8 B_GWDT_0 VDD
+ pch_hvt l=0.07U
+ w=1.4U
M1302 VDD XGWDVB_0_Z7 B_GWDC_0 VDD
+ pch_hvt l=0.07U
+ w=1.4U
M1303 VDD XGWDVB_0_Z7 B_GWDC_0 VDD
+ pch_hvt l=0.07U
+ w=1.4U
M1304 VDD XGWDVB_0_Z7 B_GWDC_0 VDD
+ pch_hvt l=0.07U
+ w=1.4U
M1305 VDD XGWDVB_0_Z7 B_GWDC_0 VDD
+ pch_hvt l=0.07U
+	 w=1.4U
M1306 VDD XGWDVB_0_Z5 XGWDVB_0_Z7 VDD
+ pch_hvt l=0.06U
+	 w=0.56U
M1307 VDD XGWDVB_0_Z5 XGWDVB_0_Z7 VDD
+ pch_hvt l=0.06U
+	 w=0.56U
M1308 XGMXB_0_GRDTB B_GRDT_0 VSS VSS nch
+ l=0.06U
+ w=0.41U
M1309 XGMXB_0_GRDTB B_GRDT_0 VSS VSS
+ nch l=0.06U
+ w=0.41U
M1310 XGMXB_0_Z3 XGMXB_0_Z2 VSS VSS
+ nch l=0.06U
+ w=0.41U
M1311 XGMXB_0_DLRSB B_DLRS VSS VSS nch
+ l=0.06U
+ w=0.41U
M1312 B_QLATCH XGMXB_0_Z1 VSS VSS nch
+ l=0.06U
+ w=0.41U
M1313 B_QLATCH XGMXB_0_Z1 VSS VSS nch
+ l=0.06U
+ w=0.41U
M1314 B_MX XGMXB_0_GRDTB B_MXN VSS nch
+ l=0.06U
+ w=0.6U
M1315 B_MX XGMXB_0_GRDTB B_MXN VSS nch
+ l=0.06U
+ w=0.6U
M1316 B_MX XGMXB_0_GRDTB B_MXN VSS nch
+ l=0.06U
+ w=0.6U
M1317 B_MX XGMXB_0_GRDTB B_MXN VSS nch
+ l=0.06U
+ w=0.6U
M1318 VDD B_GRDT_0 XGMXB_0_GRDTB VDD pch
+ l=0.06U
+ w=1.1U
M1319 VDD B_GRDT_0 XGMXB_0_GRDTB VDD
+ pch l=0.06U
+ w=1.1U
M1320 VDD XGMXB_0_DLRSB B_GRDT_0 VDD pch
+ l=0.06U
+ w=1.14U
M1321 VDD XGMXB_0_DLRSB B_GRDT_0 VDD pch
+ l=0.06U
+ w=1.14U
M1322 VDD XGMXB_0_DLRSB B_GRDT_0 VDD pch
+ l=0.06U
+ w=1.14U
M1323 B_GRDC_0 XGMXB_0_DLRSB VDD VDD pch
+ l=0.06U
+ w=1.14U
M1324 B_GRDC_0 XGMXB_0_DLRSB VDD VDD pch
+ l=0.06U
+ w=1.14U
M1325 B_GRDC_0 XGMXB_0_DLRSB VDD VDD pch
+ l=0.06U
+ w=1.14U
M1326 VDD XGMXB_0_Z2 XGMXB_0_Z3 VDD
+ pch l=0.06U
+ w=0.41U
M1327 B_QLATCH XGMXB_0_Z3 VDD VDD pch
+ l=0.06U
+ w=0.82U
M1328 B_QLATCH XGMXB_0_Z3 VDD VDD pch
+ l=0.06U
+ w=0.82U
M1329 VDD B_DLRS XGMXB_0_DLRSB VDD pch
+ l=0.06U
+ w=0.82U
M1330 B_MX B_GRDC_0 B_MXP VDD pch
+ l=0.06U
+ w=0.75U
M1331 B_MX B_GRDC_0 B_MXP VDD pch
+ l=0.06U
+ w=0.75U
M1332 B_MX B_GRDC_0 B_MXP VDD pch
+ l=0.06U
+ w=0.75U
M1333 B_MX B_GRDC_0 B_MXP VDD pch
+ l=0.06U
+ w=0.75U
M1334 VDD B_GRDT_0 XGMXB_0_Z1 VDD
+ pch l=0.06U
+ w=0.41U
M1335 VDD B_GRDT_0 B_GRDC_0 VDD pch
+ l=0.06U
+ w=0.41U
M1336 B_GRDT_0 B_GRDC_0 VDD VDD pch
+ l=0.06U
+ w=0.41U
M1337 VDD XGMXB_0_Z1 B_GRDT_0 VDD pch_hvt
+ l=0.12U
+ w=0.21U
M1338 XGMXB_0_Z1 B_GRDT_0 VSS VSS
+ nch l=0.06U
+ w=0.21U
M1339 XGWDVB_0_Z1 B_WENB_0 XGWDVB_0_Z2 VSS
+ nch_hvt l=0.06U
+	 w=0.41U
M1340 XGWDVB_0_Z5 XGWDVB_0_Z3 VSS VSS
+ nch_hvt l=0.06U
+	 w=0.41U
M1341 XGWDVB_0_Z4 B_DHT XGWDVB_0_Z2 VSS nch_hvt
+ l=0.06U
+ w=0.41U
M1342 VSS B_BWH XGWDVB_0_Z1 VSS nch_hvt
+ l=0.06U
+ w=0.41U
M1343 XGWDVB_0_Z3 B_DHC XGWDVB_0_Z2 VSS nch_hvt
+ l=0.06U
+ w=0.41U
M1344 VDD B_WENB_0 XGWDVB_0_Z3 VDD pch_hvt
+ l=0.06U
+ w=0.41U
M1345 VDD XGWDVB_0_Z3 XGWDVB_0_Z5 VDD
+ pch_hvt l=0.06U
+	 w=0.41U
M1346 VDD XGWDVB_0_Z3 XGWDVB_0_Z5 VDD
+ pch_hvt l=0.06U
+	 w=0.41U
M1347 VDD B_BWH XGWDVB_0_Z3 VDD pch_hvt
+ l=0.06U
+ w=0.41U
M1348 VDD B_DHC XGWDVB_0_Z3 VDD pch_hvt
+ l=0.06U
+ w=0.41U
M1349 XGWDVB_0_Z7 XGWDVB_0_Z5 VSS VSS
+ nch_hvt l=0.06U
+	 w=0.56U
M1350 XGWDVB_0_Z7 XGWDVB_0_Z5 VSS VSS
+ nch_hvt l=0.06U
+	 w=0.56U
M1351 XGWDVB_0_Z8 XGWDVB_0_Z6 VSS VSS
+ nch_hvt l=0.06U
+	 w=0.56U
M1352 XGWDVB_0_Z8 XGWDVB_0_Z6 VSS VSS
+ nch_hvt l=0.06U
+	 w=0.56U
M1353 B_GWDC_0 XGWDVB_0_Z7 VSS VSS
+ nch_hvt l=0.06U
+ w=0.56U
M1354 B_GWDC_0 XGWDVB_0_Z7 VSS VSS
+ nch_hvt l=0.06U
+	 w=0.56U
M1355 B_GWDC_0 XGWDVB_0_Z7 VSS VSS
+ nch_hvt l=0.06U
+	 w=0.56U
M1356 B_GWDC_0 XGWDVB_0_Z7 VSS VSS
+ nch_hvt l=0.06U
+	 w=0.56U
M1357 B_GWDT_0 XGWDVB_0_Z8 VSS VSS
+ nch_hvt l=0.06U
+ w=0.56U
M1358 B_GWDT_0 XGWDVB_0_Z8 VSS VSS
+ nch_hvt l=0.06U
+	 w=0.56U
M1359 B_GWDT_0 XGWDVB_0_Z8 VSS VSS
+ nch_hvt l=0.06U
+	 w=0.56U
M1360 B_GWDT_0 XGWDVB_0_Z8 VSS VSS
+ nch_hvt l=0.06U
+	 w=0.56U
M1361 VDD XGWDVA_1_Z5 XGWDVA_1_Z7 VDD
+ pch_hvt l=0.06U
+	 w=0.56U
M1362 VDD XGWDVA_1_Z5 XGWDVA_1_Z7 VDD
+ pch_hvt l=0.06U
+	 w=0.56U
M1363 VDD XGWDVA_1_Z7 A_GWDC_1 VDD
+ pch_hvt l=0.07U
+	 w=1.4U
M1364 VDD XGWDVA_1_Z7 A_GWDC_1 VDD
+ pch_hvt l=0.07U
+ w=1.4U
M1365 VDD XGWDVA_1_Z7 A_GWDC_1 VDD
+ pch_hvt l=0.07U
+ w=1.4U
M1366 VDD XGWDVA_1_Z7 A_GWDC_1 VDD
+ pch_hvt l=0.07U
+ w=1.4U
M1367 VDD XGWDVA_1_Z8 A_GWDT_1 VDD
+ pch_hvt l=0.07U
+ w=1.4U
M1368 VDD XGWDVA_1_Z8 A_GWDT_1 VDD
+ pch_hvt l=0.07U
+ w=1.4U
M1369 VDD A_DHT XGWDVA_1_Z4 VDD pch_hvt
+ l=0.06U
+ w=0.41U
M1370 VDD XGWDVA_1_Z8 A_GWDT_1 VDD
+ pch_hvt l=0.07U
+ w=1.4U
M1371 VDD A_WENB_1 XGWDVA_1_Z4 VDD pch_hvt
+ l=0.06U
+ w=0.41U
M1372 VDD XGWDVA_1_Z8 A_GWDT_1 VDD
+ pch_hvt l=0.07U
+	 w=1.4U
M1373 VDD A_BWH XGWDVA_1_Z4 VDD pch_hvt
+ l=0.06U
+ w=0.41U
M1374 VDD XGWDVA_1_Z6 XGWDVA_1_Z8 VDD
+ pch_hvt l=0.06U
+	 w=0.56U
M1375 VDD XGWDVA_1_Z4 XGWDVA_1_Z6 VDD
+ pch_hvt l=0.06U
+	 w=0.41U
M1376 VDD A_GRDC_1 XGMXA_1_Z2 VDD
+ pch l=0.06U
+ w=0.41U
M1377 VDD XGWDVA_1_Z4 XGWDVA_1_Z6 VDD
+ pch_hvt l=0.06U
+	 w=0.41U
M1378 VDD XGWDVA_1_Z6 XGWDVA_1_Z8 VDD
+ pch_hvt l=0.06U
+	 w=0.56U
M1379 VDD XGMXA_1_Z2 A_GRDC_1 VDD pch_hvt
+ l=0.12U
+	 w=0.21U
M1380 XGMXA_1_GRDTB A_GRDT_1 VSS VSS nch
+ l=0.06U
+ w=0.41U
M1381 XGMXA_1_GRDTB A_GRDT_1 VSS VSS
+ nch l=0.06U
+ w=0.41U
M1382 XGMXA_1_Z3 XGMXA_1_Z2 VSS VSS
+ nch l=0.06U
+ w=0.41U
M1383 XGMXA_1_DLRSB A_DLRS VSS VSS nch
+ l=0.06U
+ w=0.41U
M1384 A_QLATCH XGMXA_1_Z1 VSS VSS nch
+ l=0.06U
+ w=0.41U
M1385 A_QLATCH XGMXA_1_Z1 VSS VSS nch
+ l=0.06U
+ w=0.41U
M1386 A_MX XGMXA_1_GRDTB A_MXN VSS nch
+ l=0.06U
+ w=0.6U
M1387 A_MX XGMXA_1_GRDTB A_MXN VSS nch
+ l=0.06U
+ w=0.6U
M1388 A_MX XGMXA_1_GRDTB A_MXN VSS nch
+ l=0.06U
+ w=0.6U
M1389 A_MX XGMXA_1_GRDTB A_MXN VSS nch
+ l=0.06U
+ w=0.6U
M1390 VDD A_GRDT_1 XGMXA_1_GRDTB VDD pch
+ l=0.06U
+ w=1.1U
M1391 VDD A_GRDT_1 XGMXA_1_GRDTB VDD
+ pch l=0.06U
+ w=1.1U
M1392 VDD XGMXA_1_DLRSB A_GRDT_1 VDD pch
+ l=0.06U
+ w=1.14U
M1393 VDD XGMXA_1_DLRSB A_GRDT_1 VDD pch
+ l=0.06U
+ w=1.14U
M1394 VDD XGMXA_1_DLRSB A_GRDT_1 VDD pch
+ l=0.06U
+ w=1.14U
M1395 A_GRDC_1 XGMXA_1_DLRSB VDD VDD pch
+ l=0.06U
+ w=1.14U
M1396 A_GRDC_1 XGMXA_1_DLRSB VDD VDD pch
+ l=0.06U
+ w=1.14U
M1397 A_GRDC_1 XGMXA_1_DLRSB VDD VDD pch
+ l=0.06U
+ w=1.14U
M1398 VDD XGMXA_1_Z2 XGMXA_1_Z3 VDD
+ pch l=0.06U
+ w=0.41U
M1399 A_QLATCH XGMXA_1_Z3 VDD VDD pch
+ l=0.06U
+ w=0.82U
M1400 A_QLATCH XGMXA_1_Z3 VDD VDD pch
+ l=0.06U
+ w=0.82U
M1401 VDD A_DLRS XGMXA_1_DLRSB VDD pch
+ l=0.06U
+ w=0.82U
M1402 A_MX A_GRDC_1 A_MXP VDD pch
+ l=0.06U
+ w=0.75U
M1403 A_MX A_GRDC_1 A_MXP VDD pch
+ l=0.06U
+ w=0.75U
M1404 A_MX A_GRDC_1 A_MXP VDD pch
+ l=0.06U
+ w=0.75U
M1405 A_MX A_GRDC_1 A_MXP VDD pch
+ l=0.06U
+ w=0.75U
M1406 VDD A_GRDT_1 XGMXA_1_Z1 VDD
+ pch l=0.06U
+ w=0.41U
M1407 VDD A_GRDT_1 A_GRDC_1 VDD pch
+ l=0.06U
+ w=0.41U
M1408 A_GRDT_1 A_GRDC_1 VDD VDD pch
+ l=0.06U
+ w=0.41U
M1409 VDD XGMXA_1_Z1 A_GRDT_1 VDD pch_hvt
+ l=0.12U
+ w=0.21U
M1410 XGMXA_1_Z1 A_GRDT_1 VSS VSS
+ nch l=0.06U
+ w=0.21U
M1411 XGWDVA_1_Z1 A_WENB_1 XGWDVA_1_Z2 VSS
+ nch_hvt l=0.06U
+	 w=0.41U
M1412 XGWDVA_1_Z5 XGWDVA_1_Z3 VSS VSS
+ nch_hvt l=0.06U
+	 w=0.41U
M1413 XGWDVA_1_Z4 A_DHT XGWDVA_1_Z2 VSS nch_hvt
+ l=0.06U
+ w=0.41U
M1414 VSS A_BWH XGWDVA_1_Z1 VSS nch_hvt
+ l=0.06U
+ w=0.41U
M1415 XGWDVA_1_Z3 A_DHC XGWDVA_1_Z2 VSS nch_hvt
+ l=0.06U
+ w=0.41U
M1416 VDD A_WENB_1 XGWDVA_1_Z3 VDD pch_hvt
+ l=0.06U
+ w=0.41U
M1417 VDD XGWDVA_1_Z3 XGWDVA_1_Z5 VDD
+ pch_hvt l=0.06U
+	 w=0.41U
M1418 VDD XGWDVA_1_Z3 XGWDVA_1_Z5 VDD
+ pch_hvt l=0.06U
+	 w=0.41U
M1419 VDD A_BWH XGWDVA_1_Z3 VDD pch_hvt
+ l=0.06U
+ w=0.41U
M1420 VDD A_DHC XGWDVA_1_Z3 VDD pch_hvt
+ l=0.06U
+ w=0.41U
M1421 XGWDVA_1_Z7 XGWDVA_1_Z5 VSS VSS
+ nch_hvt l=0.06U
+	 w=0.56U
M1422 XGWDVA_1_Z7 XGWDVA_1_Z5 VSS VSS
+ nch_hvt l=0.06U
+	 w=0.56U
M1423 XGWDVA_1_Z8 XGWDVA_1_Z6 VSS VSS
+ nch_hvt l=0.06U
+	 w=0.56U
M1424 XGWDVA_1_Z8 XGWDVA_1_Z6 VSS VSS
+ nch_hvt l=0.06U
+	 w=0.56U
M1425 A_GWDC_1 XGWDVA_1_Z7 VSS VSS
+ nch_hvt l=0.06U
+ w=0.56U
M1426 A_GWDC_1 XGWDVA_1_Z7 VSS VSS
+ nch_hvt l=0.06U
+	 w=0.56U
M1427 A_GWDC_1 XGWDVA_1_Z7 VSS VSS
+ nch_hvt l=0.06U
+	 w=0.56U
M1428 A_GWDC_1 XGWDVA_1_Z7 VSS VSS
+ nch_hvt l=0.06U
+	 w=0.56U
M1429 A_GWDT_1 XGWDVA_1_Z8 VSS VSS
+ nch_hvt l=0.06U
+ w=0.56U
M1430 A_GWDT_1 XGWDVA_1_Z8 VSS VSS
+ nch_hvt l=0.06U
+	 w=0.56U
M1431 A_GWDT_1 XGWDVA_1_Z8 VSS VSS
+ nch_hvt l=0.06U
+	 w=0.56U
M1432 A_GWDT_1 XGWDVA_1_Z8 VSS VSS
+ nch_hvt l=0.06U
+	 w=0.56U
M1433 VDD B_GRDC_1 XGMXB_1_Z2 VDD
+ pch l=0.06U
+ w=0.41U
M1434 VDD XGWDVB_1_Z4 XGWDVB_1_Z6 VDD
+ pch_hvt l=0.06U
+	 w=0.41U
M1435 VDD XGWDVB_1_Z6 XGWDVB_1_Z8 VDD
+ pch_hvt l=0.06U
+	 w=0.56U
M1436 VDD XGMXB_1_Z2 B_GRDC_1 VDD pch_hvt
+ l=0.12U
+	 w=0.21U
M1437 VDD XGWDVB_1_Z4 XGWDVB_1_Z6 VDD
+ pch_hvt l=0.06U
+	 w=0.41U
M1438 VDD XGWDVB_1_Z6 XGWDVB_1_Z8 VDD
+ pch_hvt l=0.06U
+	 w=0.56U
M1439 VDD B_BWH XGWDVB_1_Z4 VDD pch_hvt
+ l=0.06U
+ w=0.41U
M1440 VDD XGWDVB_1_Z8 B_GWDT_1 VDD
+ pch_hvt l=0.07U
+	 w=1.4U
M1441 VDD B_WENB_1 XGWDVB_1_Z4 VDD pch_hvt
+ l=0.06U
+ w=0.41U
M1442 VDD XGWDVB_1_Z8 B_GWDT_1 VDD
+ pch_hvt l=0.07U
+ w=1.4U
M1443 VDD B_DHT XGWDVB_1_Z4 VDD pch_hvt
+ l=0.06U
+ w=0.41U
M1444 VDD XGWDVB_1_Z8 B_GWDT_1 VDD
+ pch_hvt l=0.07U
+ w=1.4U
M1445 VDD XGWDVB_1_Z8 B_GWDT_1 VDD
+ pch_hvt l=0.07U
+ w=1.4U
M1446 VDD XGWDVB_1_Z7 B_GWDC_1 VDD
+ pch_hvt l=0.07U
+ w=1.4U
M1447 VDD XGWDVB_1_Z7 B_GWDC_1 VDD
+ pch_hvt l=0.07U
+ w=1.4U
M1448 VDD XGWDVB_1_Z7 B_GWDC_1 VDD
+ pch_hvt l=0.07U
+ w=1.4U
M1449 VDD XGWDVB_1_Z7 B_GWDC_1 VDD
+ pch_hvt l=0.07U
+	 w=1.4U
M1450 VDD XGWDVB_1_Z5 XGWDVB_1_Z7 VDD
+ pch_hvt l=0.06U
+	 w=0.56U
M1451 VDD XGWDVB_1_Z5 XGWDVB_1_Z7 VDD
+ pch_hvt l=0.06U
+	 w=0.56U
M1452 XGMXB_1_GRDTB B_GRDT_1 VSS VSS nch
+ l=0.06U
+ w=0.41U
M1453 XGMXB_1_GRDTB B_GRDT_1 VSS VSS
+ nch l=0.06U
+ w=0.41U
M1454 XGMXB_1_Z3 XGMXB_1_Z2 VSS VSS
+ nch l=0.06U
+ w=0.41U
M1455 XGMXB_1_DLRSB B_DLRS VSS VSS nch
+ l=0.06U
+ w=0.41U
M1456 B_QLATCH XGMXB_1_Z1 VSS VSS nch
+ l=0.06U
+ w=0.41U
M1457 B_QLATCH XGMXB_1_Z1 VSS VSS nch
+ l=0.06U
+ w=0.41U
M1458 B_MX XGMXB_1_GRDTB B_MXN VSS nch
+ l=0.06U
+ w=0.6U
M1459 B_MX XGMXB_1_GRDTB B_MXN VSS nch
+ l=0.06U
+ w=0.6U
M1460 B_MX XGMXB_1_GRDTB B_MXN VSS nch
+ l=0.06U
+ w=0.6U
M1461 B_MX XGMXB_1_GRDTB B_MXN VSS nch
+ l=0.06U
+ w=0.6U
M1462 VDD B_GRDT_1 XGMXB_1_GRDTB VDD pch
+ l=0.06U
+ w=1.1U
M1463 VDD B_GRDT_1 XGMXB_1_GRDTB VDD
+ pch l=0.06U
+ w=1.1U
M1464 VDD XGMXB_1_DLRSB B_GRDT_1 VDD pch
+ l=0.06U
+ w=1.14U
M1465 VDD XGMXB_1_DLRSB B_GRDT_1 VDD pch
+ l=0.06U
+ w=1.14U
M1466 VDD XGMXB_1_DLRSB B_GRDT_1 VDD pch
+ l=0.06U
+ w=1.14U
M1467 B_GRDC_1 XGMXB_1_DLRSB VDD VDD pch
+ l=0.06U
+ w=1.14U
M1468 B_GRDC_1 XGMXB_1_DLRSB VDD VDD pch
+ l=0.06U
+ w=1.14U
M1469 B_GRDC_1 XGMXB_1_DLRSB VDD VDD pch
+ l=0.06U
+ w=1.14U
M1470 VDD XGMXB_1_Z2 XGMXB_1_Z3 VDD
+ pch l=0.06U
+ w=0.41U
M1471 B_QLATCH XGMXB_1_Z3 VDD VDD pch
+ l=0.06U
+ w=0.82U
M1472 B_QLATCH XGMXB_1_Z3 VDD VDD pch
+ l=0.06U
+ w=0.82U
M1473 VDD B_DLRS XGMXB_1_DLRSB VDD pch
+ l=0.06U
+ w=0.82U
M1474 B_MX B_GRDC_1 B_MXP VDD pch
+ l=0.06U
+ w=0.75U
M1475 B_MX B_GRDC_1 B_MXP VDD pch
+ l=0.06U
+ w=0.75U
M1476 B_MX B_GRDC_1 B_MXP VDD pch
+ l=0.06U
+ w=0.75U
M1477 B_MX B_GRDC_1 B_MXP VDD pch
+ l=0.06U
+ w=0.75U
M1478 VDD B_GRDT_1 XGMXB_1_Z1 VDD
+ pch l=0.06U
+ w=0.41U
M1479 VDD B_GRDT_1 B_GRDC_1 VDD pch
+ l=0.06U
+ w=0.41U
M1480 B_GRDT_1 B_GRDC_1 VDD VDD pch
+ l=0.06U
+ w=0.41U
M1481 VDD XGMXB_1_Z1 B_GRDT_1 VDD pch_hvt
+ l=0.12U
+ w=0.21U
M1482 XGMXB_1_Z1 B_GRDT_1 VSS VSS
+ nch l=0.06U
+ w=0.21U
M1483 XGWDVB_1_Z1 B_WENB_1 XGWDVB_1_Z2 VSS
+ nch_hvt l=0.06U
+	 w=0.41U
M1484 XGWDVB_1_Z5 XGWDVB_1_Z3 VSS VSS
+ nch_hvt l=0.06U
+	 w=0.41U
M1485 XGWDVB_1_Z4 B_DHT XGWDVB_1_Z2 VSS nch_hvt
+ l=0.06U
+ w=0.41U
M1486 VSS B_BWH XGWDVB_1_Z1 VSS nch_hvt
+ l=0.06U
+ w=0.41U
M1487 XGWDVB_1_Z3 B_DHC XGWDVB_1_Z2 VSS nch_hvt
+ l=0.06U
+ w=0.41U
M1488 VDD B_WENB_1 XGWDVB_1_Z3 VDD pch_hvt
+ l=0.06U
+ w=0.41U
M1489 VDD XGWDVB_1_Z3 XGWDVB_1_Z5 VDD
+ pch_hvt l=0.06U
+	 w=0.41U
M1490 VDD XGWDVB_1_Z3 XGWDVB_1_Z5 VDD
+ pch_hvt l=0.06U
+	 w=0.41U
M1491 VDD B_BWH XGWDVB_1_Z3 VDD pch_hvt
+ l=0.06U
+ w=0.41U
M1492 VDD B_DHC XGWDVB_1_Z3 VDD pch_hvt
+ l=0.06U
+ w=0.41U
M1493 XGWDVB_1_Z7 XGWDVB_1_Z5 VSS VSS
+ nch_hvt l=0.06U
+	 w=0.56U
M1494 XGWDVB_1_Z7 XGWDVB_1_Z5 VSS VSS
+ nch_hvt l=0.06U
+	 w=0.56U
M1495 XGWDVB_1_Z8 XGWDVB_1_Z6 VSS VSS
+ nch_hvt l=0.06U
+	 w=0.56U
M1496 XGWDVB_1_Z8 XGWDVB_1_Z6 VSS VSS
+ nch_hvt l=0.06U
+	 w=0.56U
M1497 B_GWDC_1 XGWDVB_1_Z7 VSS VSS
+ nch_hvt l=0.06U
+ w=0.56U
M1498 B_GWDC_1 XGWDVB_1_Z7 VSS VSS
+ nch_hvt l=0.06U
+	 w=0.56U
M1499 B_GWDC_1 XGWDVB_1_Z7 VSS VSS
+ nch_hvt l=0.06U
+	 w=0.56U
M1500 B_GWDC_1 XGWDVB_1_Z7 VSS VSS
+ nch_hvt l=0.06U
+	 w=0.56U
M1501 B_GWDT_1 XGWDVB_1_Z8 VSS VSS
+ nch_hvt l=0.06U
+ w=0.56U
M1502 B_GWDT_1 XGWDVB_1_Z8 VSS VSS
+ nch_hvt l=0.06U
+	 w=0.56U
M1503 B_GWDT_1 XGWDVB_1_Z8 VSS VSS
+ nch_hvt l=0.06U
+	 w=0.56U
M1504 B_GWDT_1 XGWDVB_1_Z8 VSS VSS
+ nch_hvt l=0.06U
+	 w=0.56U
M1505 XDINA_Z12 A_DHC VDD VDD pch
+ l=0.06U
+ w=0.42U
M1506 XDINA_Z12 XDINA_CLKC XDINA_Z4 VDD
+ pch l=0.06U
+	 w=0.21U
M1507 XDINA_Z4 XDINA_DC XDINA_Z9 VDD
+ pch l=0.1U
+ w=0.42U
M1508 XDINA_Z9 A_CKD VDD VDD pch
+ l=0.06U
+ w=0.21U
M1509 VDD XDINA_Z4 A_DHC VDD pch
+ l=0.06U
+ w=0.42U
M1510 VDD XDINA_Z4 A_DHC VDD pch
+ l=0.06U
+ w=0.42U
M1511 VDD XDINA_Z8 A_BWH VDD pch
+ l=0.06U
+ w=0.42U
M1512 A_MX XDOUTA_QCKT XDOUTA_Z1 VDD pch
+ l=0.06U
+ w=0.82U
M1513 A_BWH XDINA_Z8 VSS VSS nch
+ l=0.06U
+ w=0.41U
M1514 VDD XDINA_Z8 A_BWH VDD pch
+ l=0.06U
+ w=0.42U
M1515 VSS A_BWH XDINA_Z14 VSS nch
+ l=0.06U
+ w=0.21U
M1516 VDD XDOUTA_Z7 XDOUTA_Z1 VDD pch
+ l=0.06U
+ w=0.82U
M1517 VDD A_CKD XDINA_Z13 VDD pch
+ l=0.06U
+ w=0.21U
M1518 VDD A_MX A_Q VDD pch
+ l=0.06U
+ w=0.75U
M1519 XDINA_Z8 A_CKD XDINA_Z14 VSS nch
+ l=0.06U
+ w=0.21U
M1520 XDINA_Z13 XDINA_BWC XDINA_Z8 VDD
+ pch l=0.1U
+ w=0.42U
M1521 VDD A_MX A_Q VDD pch
+ l=0.06U
+ w=0.75U
M1522 XDINA_Z15 XDINA_BWC XDINA_Z8 VSS
+ nch l=0.1U
+ w=0.21U
M1523 XDINA_Z16 XDINA_CLKC XDINA_Z8 VDD
+ pch l=0.06U
+	 w=0.21U
M1524 VDD A_MX A_Q VDD pch
+ l=0.06U
+ w=0.75U
M1525 XDINA_Z16 A_BWH VDD VDD pch
+ l=0.06U
+ w=0.42U
M1526 VDD A_MX A_Q VDD pch
+ l=0.06U
+ w=0.75U
M1527 VDD XDINA_BWT XDINA_BWC VDD pch
+ l=0.1U
+ w=0.42U
M1528 VDD A_BWH XDINA_Z17 VDD pch
+ l=0.06U
+ w=0.42U
M1529 VDD A_BWH XDINA_Z17 VDD pch
+ l=0.06U
+ w=0.42U
M1530 XDINA_Z19 XDINA_BWC VDD VDD pch
+ l=0.06U
+ w=0.42U
M1531 VDD A_CKD XDINA_CLKC VDD pch
+ l=0.06U
+ w=0.21U
M1532 XDINA_Z18 XDINA_BWT VDD VDD pch
+ l=0.06U
+ w=0.42U
M1533 XDINA_Z18 XDINA_DT A_AWTD VDD pch
+ l=0.06U
+ w=0.42U
M1534 A_AWTD XDINA_DC XDINA_Z19 VDD pch
+ l=0.06U
+ w=0.42U
M1535 VDD A_DHC A_DHT VDD pch
+ l=0.06U
+ w=0.42U
M1536 VDD A_DHC A_DHT VDD pch
+ l=0.06U
+ w=0.42U
M1537 VDD XDINA_DT XDINA_DC VDD pch
+ l=0.1U
+ w=0.42U
M1538 XDINA_Z26 A_BWEBM VDD VDD pch
+ l=0.1U
+ w=0.42U
M1539 VDD XDINA_BWX XDINA_BWT VDD pch
+ l=0.1U
+ w=0.42U
M1540 XDINA_Z26 BISTC XDINA_BWX VDD pch
+ l=0.1U
+ w=0.42U
M1541 XDINA_BWX BISTT XDINA_Z25 VDD pch
+ l=0.1U
+ w=0.42U
M1542 XDINA_Z25 A_BWEB VDD VDD pch
+ l=0.1U
+ w=0.42U
M1543 XDINA_DX BISTC XDINA_Z22 VDD pch
+ l=0.1U
+ w=0.42U
M1544 XDINA_Z21 BISTT XDINA_DX VDD pch
+ l=0.1U
+ w=0.42U
M1545 VDD A_D XDINA_Z21 VDD pch
+ l=0.1U
+ w=0.42U
M1546 VDD XDINA_DX XDINA_DT VDD pch
+ l=0.1U
+ w=0.42U
M1547 XDINA_Z22 A_DM VDD VDD pch
+ l=0.1U
+ w=0.42U
M1548 VDD A_DLRS XDOUTA_DLRSB VDD pch_hvt
+ l=0.06U
+ w=0.21U
M1549 VSS XDINA_CLKC XDINA_Z15 VSS nch
+ l=0.06U
+ w=0.21U
M1550 XDINA_Z28 A_BWEBM VSS VSS nch
+ l=0.1U
+ w=0.21U
M1551 XDINA_BWT XDINA_BWX VSS VSS nch
+ l=0.1U
+ w=0.21U
M1552 XDINA_Z28 BISTT XDINA_BWX VSS nch
+ l=0.1U
+ w=0.21U
M1553 XDINA_Z23 BISTC XDINA_DX VSS nch
+ l=0.1U
+ w=0.21U
M1554 XDINA_Z27 BISTC XDINA_BWX VSS nch
+ l=0.1U
+ w=0.21U
M1555 XDINA_Z27 A_BWEB VSS VSS nch
+ l=0.1U
+ w=0.21U
M1556 XDINA_Z24 BISTT XDINA_DX VSS nch
+ l=0.1U
+ w=0.21U
M1557 XDINA_Z23 A_D VSS VSS nch
+ l=0.1U
+ w=0.21U
M1558 XDINA_DT XDINA_DX VSS VSS nch
+ l=0.1U
+ w=0.21U
M1559 XDINA_Z24 A_DM VSS VSS nch
+ l=0.1U
+ w=0.21U
M1560 XDINA_BWC XDINA_BWT VSS VSS nch
+ l=0.1U
+ w=0.21U
M1561 XDINA_Z17 A_BWH VSS VSS nch
+ l=0.06U
+ w=0.41U
M1562 A_DHT A_DHC VSS VSS nch
+ l=0.06U
+ w=0.41U
M1563 XDINA_DC XDINA_DT VSS VSS nch
+ l=0.1U
+ w=0.21U
M1564 XDINA_Z20 XDINA_BWC VSS VSS nch
+ l=0.06U
+	 w=0.21U
M1565 XDINA_CLKC A_CKD VSS VSS nch
+ l=0.06U
+ w=0.21U
M1566 A_AWTD XDINA_BWT XDINA_Z20 VSS nch
+ l=0.06U
+	 w=0.21U
M1567 A_AWTD XDINA_DT XDINA_Z20 VSS nch
+ l=0.06U
+	 w=0.21U
M1568 XDINA_Z20 XDINA_DC VSS VSS nch
+ l=0.06U
+	 w=0.21U
M1569 XDINA_Z10 A_DHC VSS VSS nch
+ l=0.06U
+ w=0.21U
M1570 A_DHC XDINA_Z4 VSS VSS nch
+ l=0.06U
+ w=0.41U
M1571 XDINA_Z11 XDINA_DC XDINA_Z4 VSS
+ nch l=0.1U
+ w=0.21U
M1572 XDINA_Z11 XDINA_CLKC VSS VSS nch
+ l=0.06U
+ w=0.21U
M1573 XDINA_Z10 A_CKD XDINA_Z4 VSS nch
+ l=0.06U
+ w=0.21U
M1574 VSS A_AWTD XDOUTA_Z4 VSS nch_hvt
+ l=0.06U
+ w=0.21U
M1575 A_MXN XDOUTA_AWTC VSS VSS nch_hvt
+ l=0.06U
+ w=0.8U
M1576 A_MXN XDOUTA_AWTC VSS VSS nch_hvt
+ l=0.06U
+ w=0.8U
M1577 A_MXN XDOUTA_AWTC VSS VSS nch_hvt
+ l=0.06U
+ w=0.8U
M1578 XDOUTA_Z6 XDOUTA_AWTC XDOUTA_Z7 VSS
+ nch_hvt l=0.06U
+	 w=0.21U
M1579 XDOUTA_Z4 XDOUTA_AWTT XDOUTA_Z7 VSS
+ nch_hvt l=0.06U
+	 w=0.21U
M1580 XDOUTA_Z6 A_QLATCH VSS VSS nch_hvt
+ l=0.06U
+ w=0.21U
M1581 VDD XDOUTA_DLRSB XDOUTA_QCKC VDD pch_hvt
+ l=0.06U
+ w=0.41U
M1582 VDD XDOUTA_QCKC XDOUTA_QCKT VDD pch_hvt
+ l=0.06U
+ w=0.41U
M1583 VDD AWTI XDOUTA_AWTC VDD pch_hvt
+ l=0.06U
+ w=0.42U
M1584 VDD XDOUTA_AWTC XDOUTA_QCKC VDD pch_hvt
+ l=0.06U
+ w=0.41U
M1585 VDD XDOUTA_AWTC XDOUTA_AWTT VDD pch_hvt
+ l=0.06U
+ w=0.42U
M1586 VDD XDOUTA_Z8 A_QLATCH VDD pch_hvt
+ l=0.12U
+ w=0.32U
M1587 XDOUTA_Z3 XDOUTA_AWTC XDOUTA_Z7 VDD
+ pch_hvt l=0.06U
+	 w=0.42U
M1588 VDD A_AWTD XDOUTA_Z3 VDD pch_hvt
+ l=0.06U
+ w=0.42U
M1589 VDD XDOUTA_AWTT A_MXP VDD pch_hvt
+ l=0.06U
+ w=1U
M1590 VDD XDOUTA_AWTT A_MXP VDD pch_hvt
+ l=0.06U
+ w=1U
M1591 VDD XDOUTA_AWTT A_MXP VDD pch_hvt
+ l=0.06U
+ w=1U
M1592 XDOUTA_Z7 XDOUTA_AWTT XDOUTA_Z5 VDD
+ pch_hvt l=0.06U
+	 w=0.42U
M1593 VDD A_QLATCH XDOUTA_Z8 VDD pch_hvt
+ l=0.08U
+ w=0.42U
M1594 XDOUTA_Z5 A_QLATCH VDD VDD pch_hvt
+ l=0.06U
+ w=0.42U
M1595 XDOUTA_XI31_NET9 XDOUTA_DLRSB XDOUTA_QCKC
+ VSS nch_hvt l=0.06U
+	 w=0.41U
M1596 XDOUTA_QCKT XDOUTA_QCKC VSS VSS nch_hvt
+ l=0.06U
+ w=0.21U
M1597 XDOUTA_AWTC AWTI VSS VSS nch_hvt
+ l=0.06U
+ w=0.21U
M1598 VSS XDOUTA_AWTC XDOUTA_XI31_NET9 VSS
+ nch_hvt l=0.06U
+	 w=0.41U
M1599 XDOUTA_AWTT XDOUTA_AWTC VSS VSS nch_hvt
+ l=0.06U
+ w=0.21U
M1600 A_QLATCH XDOUTA_Z8 VSS VSS nch_hvt
+ l=0.16U
+ w=0.21U
M1601 XDOUTA_Z8 A_QLATCH VSS VSS nch_hvt
+ l=0.08U
+ w=0.21U
M1602 VDD B_MX B_Q VDD pch
+ l=0.06U
+ w=0.75U
M1603 XDINB_Z16 B_BWH VDD VDD pch
+ l=0.06U
+ w=0.42U
M1604 VDD B_DLRS XDOUTB_DLRSB VDD pch_hvt
+ l=0.06U
+ w=0.21U
M1605 XDINB_Z15 XDINB_CLKC VSS VSS nch
+ l=0.06U
+ w=0.21U
M1606 VDD B_MX B_Q VDD pch
+ l=0.06U
+ w=0.75U
M1607 XDINB_Z16 XDINB_CLKC XDINB_Z8 VDD
+ pch l=0.06U
+	 w=0.21U
M1608 VDD B_MX B_Q VDD pch
+ l=0.06U
+ w=0.75U
M1609 XDINB_Z15 XDINB_BWC XDINB_Z8 VSS
+ nch l=0.1U
+ w=0.21U
M1610 XDINB_Z13 XDINB_BWC XDINB_Z8 VDD
+ pch l=0.1U
+ w=0.42U
M1611 XDINB_Z8 B_CKD XDINB_Z14 VSS nch
+ l=0.06U
+ w=0.21U
M1612 VDD B_MX B_Q VDD pch
+ l=0.06U
+ w=0.75U
M1613 VDD B_CKD XDINB_Z13 VDD pch
+ l=0.06U
+ w=0.21U
M1614 VDD XDOUTB_Z7 XDOUTB_Z1 VDD pch
+ l=0.06U
+ w=0.82U
M1615 VSS B_BWH XDINB_Z14 VSS nch
+ l=0.06U
+ w=0.21U
M1616 B_MX XDOUTB_QCKT XDOUTB_Z1 VDD pch
+ l=0.06U
+ w=0.82U
M1617 VDD XDINB_Z8 B_BWH VDD pch
+ l=0.06U
+ w=0.42U
M1618 B_BWH XDINB_Z8 VSS VSS nch
+ l=0.06U
+ w=0.41U
M1619 VDD XDINB_Z8 B_BWH VDD pch
+ l=0.06U
+ w=0.42U
M1620 VDD XDINB_Z4 B_DHC VDD pch
+ l=0.06U
+ w=0.42U
M1621 VDD XDINB_Z4 B_DHC VDD pch
+ l=0.06U
+ w=0.42U
M1622 XDINB_Z9 B_CKD VDD VDD pch
+ l=0.06U
+ w=0.21U
M1623 XDINB_Z4 XDINB_DC XDINB_Z9 VDD
+ pch l=0.1U
+ w=0.42U
M1624 XDINB_Z12 XDINB_CLKC XDINB_Z4 VDD
+ pch l=0.06U
+	 w=0.21U
M1625 XDINB_Z12 B_DHC VDD VDD pch
+ l=0.06U
+ w=0.42U
M1626 VDD XDINB_BWT XDINB_BWC VDD pch
+ l=0.1U
+ w=0.42U
M1627 VDD B_BWH XDINB_Z17 VDD pch
+ l=0.06U
+ w=0.42U
M1628 VDD B_BWH XDINB_Z17 VDD pch
+ l=0.06U
+ w=0.42U
M1629 XDINB_Z19 XDINB_BWC VDD VDD pch
+ l=0.06U
+ w=0.42U
M1630 VDD B_CKD XDINB_CLKC VDD pch
+ l=0.06U
+ w=0.21U
M1631 XDINB_Z18 XDINB_BWT VDD VDD pch
+ l=0.06U
+ w=0.42U
M1632 XDINB_Z18 XDINB_DT B_AWTD VDD pch
+ l=0.06U
+ w=0.42U
M1633 B_AWTD XDINB_DC XDINB_Z19 VDD pch
+ l=0.06U
+ w=0.42U
M1634 VDD B_DHC B_DHT VDD pch
+ l=0.06U
+ w=0.42U
M1635 VDD B_DHC B_DHT VDD pch
+ l=0.06U
+ w=0.42U
M1636 VDD XDINB_DT XDINB_DC VDD pch
+ l=0.1U
+ w=0.42U
M1637 XDINB_Z26 B_BWEBM VDD VDD pch
+ l=0.1U
+ w=0.42U
M1638 VDD XDINB_BWX XDINB_BWT VDD pch
+ l=0.1U
+ w=0.42U
M1639 XDINB_Z26 BISTC XDINB_BWX VDD pch
+ l=0.1U
+ w=0.42U
M1640 XDINB_BWX BISTT XDINB_Z25 VDD pch
+ l=0.1U
+ w=0.42U
M1641 XDINB_Z25 B_BWEB VDD VDD pch
+ l=0.1U
+ w=0.42U
M1642 XDINB_DX BISTC XDINB_Z22 VDD pch
+ l=0.1U
+ w=0.42U
M1643 XDINB_Z21 BISTT XDINB_DX VDD pch
+ l=0.1U
+ w=0.42U
M1644 VDD B_D XDINB_Z21 VDD pch
+ l=0.1U
+ w=0.42U
M1645 VDD XDINB_DX XDINB_DT VDD pch
+ l=0.1U
+ w=0.42U
M1646 XDINB_Z22 B_DM VDD VDD pch
+ l=0.1U
+ w=0.42U
M1647 XDINB_Z28 B_BWEBM VSS VSS nch
+ l=0.1U
+ w=0.21U
M1648 XDINB_BWT XDINB_BWX VSS VSS nch
+ l=0.1U
+ w=0.21U
M1649 XDINB_Z28 BISTT XDINB_BWX VSS nch
+ l=0.1U
+ w=0.21U
M1650 XDINB_Z23 BISTC XDINB_DX VSS nch
+ l=0.1U
+ w=0.21U
M1651 XDINB_Z27 BISTC XDINB_BWX VSS nch
+ l=0.1U
+ w=0.21U
M1652 XDINB_Z27 B_BWEB VSS VSS nch
+ l=0.1U
+ w=0.21U
M1653 XDINB_Z24 BISTT XDINB_DX VSS nch
+ l=0.1U
+ w=0.21U
M1654 XDINB_Z23 B_D VSS VSS nch
+ l=0.1U
+ w=0.21U
M1655 XDINB_DT XDINB_DX VSS VSS nch
+ l=0.1U
+ w=0.21U
M1656 XDINB_Z24 B_DM VSS VSS nch
+ l=0.1U
+ w=0.21U
M1657 XDINB_BWC XDINB_BWT VSS VSS nch
+ l=0.1U
+ w=0.21U
M1658 XDINB_Z17 B_BWH VSS VSS nch
+ l=0.06U
+ w=0.41U
M1659 B_DHT B_DHC VSS VSS nch
+ l=0.06U
+ w=0.41U
M1660 XDINB_DC XDINB_DT VSS VSS nch
+ l=0.1U
+ w=0.21U
M1661 XDINB_Z20 XDINB_BWC VSS VSS nch
+ l=0.06U
+	 w=0.21U
M1662 XDINB_CLKC B_CKD VSS VSS nch
+ l=0.06U
+ w=0.21U
M1663 B_AWTD XDINB_BWT XDINB_Z20 VSS nch
+ l=0.06U
+	 w=0.21U
M1664 B_AWTD XDINB_DT XDINB_Z20 VSS nch
+ l=0.06U
+	 w=0.21U
M1665 XDINB_Z20 XDINB_DC VSS VSS nch
+ l=0.06U
+	 w=0.21U
M1666 XDINB_Z10 B_DHC VSS VSS nch
+ l=0.06U
+ w=0.21U
M1667 B_DHC XDINB_Z4 VSS VSS nch
+ l=0.06U
+ w=0.41U
M1668 XDINB_Z11 XDINB_DC XDINB_Z4 VSS
+ nch l=0.1U
+ w=0.21U
M1669 XDINB_Z11 XDINB_CLKC VSS VSS nch
+ l=0.06U
+ w=0.21U
M1670 XDINB_Z10 B_CKD XDINB_Z4 VSS nch
+ l=0.06U
+ w=0.21U
M1671 VSS B_AWTD XDOUTB_Z4 VSS nch_hvt
+ l=0.06U
+ w=0.21U
M1672 B_MXN XDOUTB_AWTC VSS VSS nch_hvt
+ l=0.06U
+ w=0.8U
M1673 B_MXN XDOUTB_AWTC VSS VSS nch_hvt
+ l=0.06U
+ w=0.8U
M1674 B_MXN XDOUTB_AWTC VSS VSS nch_hvt
+ l=0.06U
+ w=0.8U
M1675 XDOUTB_Z6 XDOUTB_AWTC XDOUTB_Z7 VSS
+ nch_hvt l=0.06U
+	 w=0.21U
M1676 XDOUTB_Z4 XDOUTB_AWTT XDOUTB_Z7 VSS
+ nch_hvt l=0.06U
+	 w=0.21U
M1677 XDOUTB_Z6 B_QLATCH VSS VSS nch_hvt
+ l=0.06U
+ w=0.21U
M1678 VDD XDOUTB_DLRSB XDOUTB_QCKC VDD pch_hvt
+ l=0.06U
+ w=0.41U
M1679 VDD XDOUTB_QCKC XDOUTB_QCKT VDD pch_hvt
+ l=0.06U
+ w=0.41U
M1680 VDD AWTI XDOUTB_AWTC VDD pch_hvt
+ l=0.06U
+ w=0.42U
M1681 VDD XDOUTB_AWTC XDOUTB_QCKC VDD pch_hvt
+ l=0.06U
+ w=0.41U
M1682 VDD XDOUTB_AWTC XDOUTB_AWTT VDD pch_hvt
+ l=0.06U
+ w=0.42U
M1683 VDD XDOUTB_Z8 B_QLATCH VDD pch_hvt
+ l=0.12U
+ w=0.32U
M1684 XDOUTB_Z3 XDOUTB_AWTC XDOUTB_Z7 VDD
+ pch_hvt l=0.06U
+	 w=0.42U
M1685 VDD B_AWTD XDOUTB_Z3 VDD pch_hvt
+ l=0.06U
+ w=0.42U
M1686 VDD XDOUTB_AWTT B_MXP VDD pch_hvt
+ l=0.06U
+ w=1U
M1687 VDD XDOUTB_AWTT B_MXP VDD pch_hvt
+ l=0.06U
+ w=1U
M1688 VDD XDOUTB_AWTT B_MXP VDD pch_hvt
+ l=0.06U
+ w=1U
M1689 XDOUTB_Z7 XDOUTB_AWTT XDOUTB_Z5 VDD
+ pch_hvt l=0.06U
+	 w=0.42U
M1690 VDD B_QLATCH XDOUTB_Z8 VDD pch_hvt
+ l=0.08U
+ w=0.42U
M1691 XDOUTB_Z5 B_QLATCH VDD VDD pch_hvt
+ l=0.06U
+ w=0.42U
M1692 XDOUTB_XI31_NET9 XDOUTB_DLRSB XDOUTB_QCKC
+ VSS nch_hvt l=0.06U
+	 w=0.41U
M1693 XDOUTB_QCKT XDOUTB_QCKC VSS VSS nch_hvt
+ l=0.06U
+ w=0.21U
M1694 XDOUTB_AWTC AWTI VSS VSS nch_hvt
+ l=0.06U
+ w=0.21U
M1695 VSS XDOUTB_AWTC XDOUTB_XI31_NET9 VSS
+ nch_hvt l=0.06U
+	 w=0.41U
M1696 XDOUTB_AWTT XDOUTB_AWTC VSS VSS nch_hvt
+ l=0.06U
+ w=0.21U
M1697 B_QLATCH XDOUTB_Z8 VSS VSS nch_hvt
+ l=0.16U
+ w=0.21U
M1698 XDOUTB_Z8 B_QLATCH VSS VSS nch_hvt
+ l=0.08U
+ w=0.21U
M1699 VDD XGWDVA_2_Z5 XGWDVA_2_Z7 VDD
+ pch_hvt l=0.06U
+	 w=0.56U
M1700 VDD XGWDVA_2_Z5 XGWDVA_2_Z7 VDD
+ pch_hvt l=0.06U
+	 w=0.56U
M1701 VDD XGWDVA_2_Z7 A_GWDC_2 VDD
+ pch_hvt l=0.07U
+	 w=1.4U
M1702 VDD XGWDVA_2_Z7 A_GWDC_2 VDD
+ pch_hvt l=0.07U
+ w=1.4U
M1703 VDD XGWDVA_2_Z7 A_GWDC_2 VDD
+ pch_hvt l=0.07U
+ w=1.4U
M1704 VDD XGWDVA_2_Z7 A_GWDC_2 VDD
+ pch_hvt l=0.07U
+ w=1.4U
M1705 VDD XGWDVA_2_Z8 A_GWDT_2 VDD
+ pch_hvt l=0.07U
+ w=1.4U
M1706 VDD XGWDVA_2_Z8 A_GWDT_2 VDD
+ pch_hvt l=0.07U
+ w=1.4U
M1707 VDD A_DHT XGWDVA_2_Z4 VDD pch_hvt
+ l=0.06U
+ w=0.41U
M1708 VDD XGWDVA_2_Z8 A_GWDT_2 VDD
+ pch_hvt l=0.07U
+ w=1.4U
M1709 VDD A_WENB_2 XGWDVA_2_Z4 VDD pch_hvt
+ l=0.06U
+ w=0.41U
M1710 VDD XGWDVA_2_Z8 A_GWDT_2 VDD
+ pch_hvt l=0.07U
+	 w=1.4U
M1711 VDD A_BWH XGWDVA_2_Z4 VDD pch_hvt
+ l=0.06U
+ w=0.41U
M1712 VDD XGWDVA_2_Z6 XGWDVA_2_Z8 VDD
+ pch_hvt l=0.06U
+	 w=0.56U
M1713 VDD XGWDVA_2_Z4 XGWDVA_2_Z6 VDD
+ pch_hvt l=0.06U
+	 w=0.41U
M1714 VDD A_GRDC_2 XGMXA_2_Z2 VDD
+ pch l=0.06U
+ w=0.41U
M1715 VDD XGWDVA_2_Z4 XGWDVA_2_Z6 VDD
+ pch_hvt l=0.06U
+	 w=0.41U
M1716 VDD XGWDVA_2_Z6 XGWDVA_2_Z8 VDD
+ pch_hvt l=0.06U
+	 w=0.56U
M1717 VDD XGMXA_2_Z2 A_GRDC_2 VDD pch_hvt
+ l=0.12U
+	 w=0.21U
M1718 XGMXA_2_GRDTB A_GRDT_2 VSS VSS nch
+ l=0.06U
+ w=0.41U
M1719 XGMXA_2_GRDTB A_GRDT_2 VSS VSS
+ nch l=0.06U
+ w=0.41U
M1720 XGMXA_2_Z3 XGMXA_2_Z2 VSS VSS
+ nch l=0.06U
+ w=0.41U
M1721 XGMXA_2_DLRSB A_DLRS VSS VSS nch
+ l=0.06U
+ w=0.41U
M1722 A_QLATCH XGMXA_2_Z1 VSS VSS nch
+ l=0.06U
+ w=0.41U
M1723 A_QLATCH XGMXA_2_Z1 VSS VSS nch
+ l=0.06U
+ w=0.41U
M1724 A_MX XGMXA_2_GRDTB A_MXN VSS nch
+ l=0.06U
+ w=0.6U
M1725 A_MX XGMXA_2_GRDTB A_MXN VSS nch
+ l=0.06U
+ w=0.6U
M1726 A_MX XGMXA_2_GRDTB A_MXN VSS nch
+ l=0.06U
+ w=0.6U
M1727 A_MX XGMXA_2_GRDTB A_MXN VSS nch
+ l=0.06U
+ w=0.6U
M1728 VDD A_GRDT_2 XGMXA_2_GRDTB VDD pch
+ l=0.06U
+ w=1.1U
M1729 VDD A_GRDT_2 XGMXA_2_GRDTB VDD
+ pch l=0.06U
+ w=1.1U
M1730 VDD XGMXA_2_DLRSB A_GRDT_2 VDD pch
+ l=0.06U
+ w=1.14U
M1731 VDD XGMXA_2_DLRSB A_GRDT_2 VDD pch
+ l=0.06U
+ w=1.14U
M1732 VDD XGMXA_2_DLRSB A_GRDT_2 VDD pch
+ l=0.06U
+ w=1.14U
M1733 A_GRDC_2 XGMXA_2_DLRSB VDD VDD pch
+ l=0.06U
+ w=1.14U
M1734 A_GRDC_2 XGMXA_2_DLRSB VDD VDD pch
+ l=0.06U
+ w=1.14U
M1735 A_GRDC_2 XGMXA_2_DLRSB VDD VDD pch
+ l=0.06U
+ w=1.14U
M1736 VDD XGMXA_2_Z2 XGMXA_2_Z3 VDD
+ pch l=0.06U
+ w=0.41U
M1737 A_QLATCH XGMXA_2_Z3 VDD VDD pch
+ l=0.06U
+ w=0.82U
M1738 A_QLATCH XGMXA_2_Z3 VDD VDD pch
+ l=0.06U
+ w=0.82U
M1739 VDD A_DLRS XGMXA_2_DLRSB VDD pch
+ l=0.06U
+ w=0.82U
M1740 A_MX A_GRDC_2 A_MXP VDD pch
+ l=0.06U
+ w=0.75U
M1741 A_MX A_GRDC_2 A_MXP VDD pch
+ l=0.06U
+ w=0.75U
M1742 A_MX A_GRDC_2 A_MXP VDD pch
+ l=0.06U
+ w=0.75U
M1743 A_MX A_GRDC_2 A_MXP VDD pch
+ l=0.06U
+ w=0.75U
M1744 VDD A_GRDT_2 XGMXA_2_Z1 VDD
+ pch l=0.06U
+ w=0.41U
M1745 VDD A_GRDT_2 A_GRDC_2 VDD pch
+ l=0.06U
+ w=0.41U
M1746 A_GRDT_2 A_GRDC_2 VDD VDD pch
+ l=0.06U
+ w=0.41U
M1747 VDD XGMXA_2_Z1 A_GRDT_2 VDD pch_hvt
+ l=0.12U
+ w=0.21U
M1748 XGMXA_2_Z1 A_GRDT_2 VSS VSS
+ nch l=0.06U
+ w=0.21U
M1749 XGWDVA_2_Z1 A_WENB_2 XGWDVA_2_Z2 VSS
+ nch_hvt l=0.06U
+	 w=0.41U
M1750 XGWDVA_2_Z5 XGWDVA_2_Z3 VSS VSS
+ nch_hvt l=0.06U
+	 w=0.41U
M1751 XGWDVA_2_Z4 A_DHT XGWDVA_2_Z2 VSS nch_hvt
+ l=0.06U
+ w=0.41U
M1752 VSS A_BWH XGWDVA_2_Z1 VSS nch_hvt
+ l=0.06U
+ w=0.41U
M1753 XGWDVA_2_Z3 A_DHC XGWDVA_2_Z2 VSS nch_hvt
+ l=0.06U
+ w=0.41U
M1754 VDD A_WENB_2 XGWDVA_2_Z3 VDD pch_hvt
+ l=0.06U
+ w=0.41U
M1755 VDD XGWDVA_2_Z3 XGWDVA_2_Z5 VDD
+ pch_hvt l=0.06U
+	 w=0.41U
M1756 VDD XGWDVA_2_Z3 XGWDVA_2_Z5 VDD
+ pch_hvt l=0.06U
+	 w=0.41U
M1757 VDD A_BWH XGWDVA_2_Z3 VDD pch_hvt
+ l=0.06U
+ w=0.41U
M1758 VDD A_DHC XGWDVA_2_Z3 VDD pch_hvt
+ l=0.06U
+ w=0.41U
M1759 XGWDVA_2_Z7 XGWDVA_2_Z5 VSS VSS
+ nch_hvt l=0.06U
+	 w=0.56U
M1760 XGWDVA_2_Z7 XGWDVA_2_Z5 VSS VSS
+ nch_hvt l=0.06U
+	 w=0.56U
M1761 XGWDVA_2_Z8 XGWDVA_2_Z6 VSS VSS
+ nch_hvt l=0.06U
+	 w=0.56U
M1762 XGWDVA_2_Z8 XGWDVA_2_Z6 VSS VSS
+ nch_hvt l=0.06U
+	 w=0.56U
M1763 A_GWDC_2 XGWDVA_2_Z7 VSS VSS
+ nch_hvt l=0.06U
+ w=0.56U
M1764 A_GWDC_2 XGWDVA_2_Z7 VSS VSS
+ nch_hvt l=0.06U
+	 w=0.56U
M1765 A_GWDC_2 XGWDVA_2_Z7 VSS VSS
+ nch_hvt l=0.06U
+	 w=0.56U
M1766 A_GWDC_2 XGWDVA_2_Z7 VSS VSS
+ nch_hvt l=0.06U
+	 w=0.56U
M1767 A_GWDT_2 XGWDVA_2_Z8 VSS VSS
+ nch_hvt l=0.06U
+ w=0.56U
M1768 A_GWDT_2 XGWDVA_2_Z8 VSS VSS
+ nch_hvt l=0.06U
+	 w=0.56U
M1769 A_GWDT_2 XGWDVA_2_Z8 VSS VSS
+ nch_hvt l=0.06U
+	 w=0.56U
M1770 A_GWDT_2 XGWDVA_2_Z8 VSS VSS
+ nch_hvt l=0.06U
+	 w=0.56U
M1771 VDD B_GRDC_2 XGMXB_2_Z2 VDD
+ pch l=0.06U
+ w=0.41U
M1772 VDD XGWDVB_2_Z4 XGWDVB_2_Z6 VDD
+ pch_hvt l=0.06U
+	 w=0.41U
M1773 VDD XGWDVB_2_Z6 XGWDVB_2_Z8 VDD
+ pch_hvt l=0.06U
+	 w=0.56U
M1774 VDD XGMXB_2_Z2 B_GRDC_2 VDD pch_hvt
+ l=0.12U
+	 w=0.21U
M1775 VDD XGWDVB_2_Z4 XGWDVB_2_Z6 VDD
+ pch_hvt l=0.06U
+	 w=0.41U
M1776 VDD XGWDVB_2_Z6 XGWDVB_2_Z8 VDD
+ pch_hvt l=0.06U
+	 w=0.56U
M1777 VDD B_BWH XGWDVB_2_Z4 VDD pch_hvt
+ l=0.06U
+ w=0.41U
M1778 VDD XGWDVB_2_Z8 B_GWDT_2 VDD
+ pch_hvt l=0.07U
+	 w=1.4U
M1779 VDD B_WENB_2 XGWDVB_2_Z4 VDD pch_hvt
+ l=0.06U
+ w=0.41U
M1780 VDD XGWDVB_2_Z8 B_GWDT_2 VDD
+ pch_hvt l=0.07U
+ w=1.4U
M1781 VDD B_DHT XGWDVB_2_Z4 VDD pch_hvt
+ l=0.06U
+ w=0.41U
M1782 VDD XGWDVB_2_Z8 B_GWDT_2 VDD
+ pch_hvt l=0.07U
+ w=1.4U
M1783 VDD XGWDVB_2_Z8 B_GWDT_2 VDD
+ pch_hvt l=0.07U
+ w=1.4U
M1784 VDD XGWDVB_2_Z7 B_GWDC_2 VDD
+ pch_hvt l=0.07U
+ w=1.4U
M1785 VDD XGWDVB_2_Z7 B_GWDC_2 VDD
+ pch_hvt l=0.07U
+ w=1.4U
M1786 VDD XGWDVB_2_Z7 B_GWDC_2 VDD
+ pch_hvt l=0.07U
+ w=1.4U
M1787 VDD XGWDVB_2_Z7 B_GWDC_2 VDD
+ pch_hvt l=0.07U
+	 w=1.4U
M1788 VDD XGWDVB_2_Z5 XGWDVB_2_Z7 VDD
+ pch_hvt l=0.06U
+	 w=0.56U
M1789 VDD XGWDVB_2_Z5 XGWDVB_2_Z7 VDD
+ pch_hvt l=0.06U
+	 w=0.56U
M1790 XGMXB_2_GRDTB B_GRDT_2 VSS VSS nch
+ l=0.06U
+ w=0.41U
M1791 XGMXB_2_GRDTB B_GRDT_2 VSS VSS
+ nch l=0.06U
+ w=0.41U
M1792 XGMXB_2_Z3 XGMXB_2_Z2 VSS VSS
+ nch l=0.06U
+ w=0.41U
M1793 XGMXB_2_DLRSB B_DLRS VSS VSS nch
+ l=0.06U
+ w=0.41U
M1794 B_QLATCH XGMXB_2_Z1 VSS VSS nch
+ l=0.06U
+ w=0.41U
M1795 B_QLATCH XGMXB_2_Z1 VSS VSS nch
+ l=0.06U
+ w=0.41U
M1796 B_MX XGMXB_2_GRDTB B_MXN VSS nch
+ l=0.06U
+ w=0.6U
M1797 B_MX XGMXB_2_GRDTB B_MXN VSS nch
+ l=0.06U
+ w=0.6U
M1798 B_MX XGMXB_2_GRDTB B_MXN VSS nch
+ l=0.06U
+ w=0.6U
M1799 B_MX XGMXB_2_GRDTB B_MXN VSS nch
+ l=0.06U
+ w=0.6U
M1800 VDD B_GRDT_2 XGMXB_2_GRDTB VDD pch
+ l=0.06U
+ w=1.1U
M1801 VDD B_GRDT_2 XGMXB_2_GRDTB VDD
+ pch l=0.06U
+ w=1.1U
M1802 VDD XGMXB_2_DLRSB B_GRDT_2 VDD pch
+ l=0.06U
+ w=1.14U
M1803 VDD XGMXB_2_DLRSB B_GRDT_2 VDD pch
+ l=0.06U
+ w=1.14U
M1804 VDD XGMXB_2_DLRSB B_GRDT_2 VDD pch
+ l=0.06U
+ w=1.14U
M1805 B_GRDC_2 XGMXB_2_DLRSB VDD VDD pch
+ l=0.06U
+ w=1.14U
M1806 B_GRDC_2 XGMXB_2_DLRSB VDD VDD pch
+ l=0.06U
+ w=1.14U
M1807 B_GRDC_2 XGMXB_2_DLRSB VDD VDD pch
+ l=0.06U
+ w=1.14U
M1808 VDD XGMXB_2_Z2 XGMXB_2_Z3 VDD
+ pch l=0.06U
+ w=0.41U
M1809 B_QLATCH XGMXB_2_Z3 VDD VDD pch
+ l=0.06U
+ w=0.82U
M1810 B_QLATCH XGMXB_2_Z3 VDD VDD pch
+ l=0.06U
+ w=0.82U
M1811 VDD B_DLRS XGMXB_2_DLRSB VDD pch
+ l=0.06U
+ w=0.82U
M1812 B_MX B_GRDC_2 B_MXP VDD pch
+ l=0.06U
+ w=0.75U
M1813 B_MX B_GRDC_2 B_MXP VDD pch
+ l=0.06U
+ w=0.75U
M1814 B_MX B_GRDC_2 B_MXP VDD pch
+ l=0.06U
+ w=0.75U
M1815 B_MX B_GRDC_2 B_MXP VDD pch
+ l=0.06U
+ w=0.75U
M1816 VDD B_GRDT_2 XGMXB_2_Z1 VDD
+ pch l=0.06U
+ w=0.41U
M1817 VDD B_GRDT_2 B_GRDC_2 VDD pch
+ l=0.06U
+ w=0.41U
M1818 B_GRDT_2 B_GRDC_2 VDD VDD pch
+ l=0.06U
+ w=0.41U
M1819 VDD XGMXB_2_Z1 B_GRDT_2 VDD pch_hvt
+ l=0.12U
+ w=0.21U
M1820 XGMXB_2_Z1 B_GRDT_2 VSS VSS
+ nch l=0.06U
+ w=0.21U
M1821 XGWDVB_2_Z1 B_WENB_2 XGWDVB_2_Z2 VSS
+ nch_hvt l=0.06U
+	 w=0.41U
M1822 XGWDVB_2_Z5 XGWDVB_2_Z3 VSS VSS
+ nch_hvt l=0.06U
+	 w=0.41U
M1823 XGWDVB_2_Z4 B_DHT XGWDVB_2_Z2 VSS nch_hvt
+ l=0.06U
+ w=0.41U
M1824 VSS B_BWH XGWDVB_2_Z1 VSS nch_hvt
+ l=0.06U
+ w=0.41U
M1825 XGWDVB_2_Z3 B_DHC XGWDVB_2_Z2 VSS nch_hvt
+ l=0.06U
+ w=0.41U
M1826 VDD B_WENB_2 XGWDVB_2_Z3 VDD pch_hvt
+ l=0.06U
+ w=0.41U
M1827 VDD XGWDVB_2_Z3 XGWDVB_2_Z5 VDD
+ pch_hvt l=0.06U
+	 w=0.41U
M1828 VDD XGWDVB_2_Z3 XGWDVB_2_Z5 VDD
+ pch_hvt l=0.06U
+	 w=0.41U
M1829 VDD B_BWH XGWDVB_2_Z3 VDD pch_hvt
+ l=0.06U
+ w=0.41U
M1830 VDD B_DHC XGWDVB_2_Z3 VDD pch_hvt
+ l=0.06U
+ w=0.41U
M1831 XGWDVB_2_Z7 XGWDVB_2_Z5 VSS VSS
+ nch_hvt l=0.06U
+	 w=0.56U
M1832 XGWDVB_2_Z7 XGWDVB_2_Z5 VSS VSS
+ nch_hvt l=0.06U
+	 w=0.56U
M1833 XGWDVB_2_Z8 XGWDVB_2_Z6 VSS VSS
+ nch_hvt l=0.06U
+	 w=0.56U
M1834 XGWDVB_2_Z8 XGWDVB_2_Z6 VSS VSS
+ nch_hvt l=0.06U
+	 w=0.56U
M1835 B_GWDC_2 XGWDVB_2_Z7 VSS VSS
+ nch_hvt l=0.06U
+ w=0.56U
M1836 B_GWDC_2 XGWDVB_2_Z7 VSS VSS
+ nch_hvt l=0.06U
+	 w=0.56U
M1837 B_GWDC_2 XGWDVB_2_Z7 VSS VSS
+ nch_hvt l=0.06U
+	 w=0.56U
M1838 B_GWDC_2 XGWDVB_2_Z7 VSS VSS
+ nch_hvt l=0.06U
+	 w=0.56U
M1839 B_GWDT_2 XGWDVB_2_Z8 VSS VSS
+ nch_hvt l=0.06U
+ w=0.56U
M1840 B_GWDT_2 XGWDVB_2_Z8 VSS VSS
+ nch_hvt l=0.06U
+	 w=0.56U
M1841 B_GWDT_2 XGWDVB_2_Z8 VSS VSS
+ nch_hvt l=0.06U
+	 w=0.56U
M1842 B_GWDT_2 XGWDVB_2_Z8 VSS VSS
+ nch_hvt l=0.06U
+	 w=0.56U
M1843 VDD XGWDVA_3_Z5 XGWDVA_3_Z7 VDD
+ pch_hvt l=0.06U
+	 w=0.56U
M1844 VDD XGWDVA_3_Z5 XGWDVA_3_Z7 VDD
+ pch_hvt l=0.06U
+	 w=0.56U
M1845 VDD XGWDVA_3_Z7 A_GWDC_3 VDD
+ pch_hvt l=0.07U
+	 w=1.4U
M1846 VDD XGWDVA_3_Z7 A_GWDC_3 VDD
+ pch_hvt l=0.07U
+ w=1.4U
M1847 VDD XGWDVA_3_Z7 A_GWDC_3 VDD
+ pch_hvt l=0.07U
+ w=1.4U
M1848 VDD XGWDVA_3_Z7 A_GWDC_3 VDD
+ pch_hvt l=0.07U
+ w=1.4U
M1849 VDD XGWDVA_3_Z8 A_GWDT_3 VDD
+ pch_hvt l=0.07U
+ w=1.4U
M1850 VDD XGWDVA_3_Z8 A_GWDT_3 VDD
+ pch_hvt l=0.07U
+ w=1.4U
M1851 VDD A_DHT XGWDVA_3_Z4 VDD pch_hvt
+ l=0.06U
+ w=0.41U
M1852 VDD XGWDVA_3_Z8 A_GWDT_3 VDD
+ pch_hvt l=0.07U
+ w=1.4U
M1853 VDD A_WENB_3 XGWDVA_3_Z4 VDD pch_hvt
+ l=0.06U
+ w=0.41U
M1854 VDD XGWDVA_3_Z8 A_GWDT_3 VDD
+ pch_hvt l=0.07U
+	 w=1.4U
M1855 VDD A_BWH XGWDVA_3_Z4 VDD pch_hvt
+ l=0.06U
+ w=0.41U
M1856 VDD XGWDVA_3_Z6 XGWDVA_3_Z8 VDD
+ pch_hvt l=0.06U
+	 w=0.56U
M1857 VDD XGWDVA_3_Z4 XGWDVA_3_Z6 VDD
+ pch_hvt l=0.06U
+	 w=0.41U
M1858 VDD A_GRDC_3 XGMXA_3_Z2 VDD
+ pch l=0.06U
+ w=0.41U
M1859 VDD XGWDVA_3_Z4 XGWDVA_3_Z6 VDD
+ pch_hvt l=0.06U
+	 w=0.41U
M1860 VDD XGWDVA_3_Z6 XGWDVA_3_Z8 VDD
+ pch_hvt l=0.06U
+	 w=0.56U
M1861 VDD XGMXA_3_Z2 A_GRDC_3 VDD pch_hvt
+ l=0.12U
+	 w=0.21U
M1862 XGMXA_3_GRDTB A_GRDT_3 VSS VSS nch
+ l=0.06U
+ w=0.41U
M1863 XGMXA_3_GRDTB A_GRDT_3 VSS VSS
+ nch l=0.06U
+ w=0.41U
M1864 XGMXA_3_Z3 XGMXA_3_Z2 VSS VSS
+ nch l=0.06U
+ w=0.41U
M1865 XGMXA_3_DLRSB A_DLRS VSS VSS nch
+ l=0.06U
+ w=0.41U
M1866 A_QLATCH XGMXA_3_Z1 VSS VSS nch
+ l=0.06U
+ w=0.41U
M1867 A_QLATCH XGMXA_3_Z1 VSS VSS nch
+ l=0.06U
+ w=0.41U
M1868 A_MX XGMXA_3_GRDTB A_MXN VSS nch
+ l=0.06U
+ w=0.6U
M1869 A_MX XGMXA_3_GRDTB A_MXN VSS nch
+ l=0.06U
+ w=0.6U
M1870 A_MX XGMXA_3_GRDTB A_MXN VSS nch
+ l=0.06U
+ w=0.6U
M1871 A_MX XGMXA_3_GRDTB A_MXN VSS nch
+ l=0.06U
+ w=0.6U
M1872 VDD A_GRDT_3 XGMXA_3_GRDTB VDD pch
+ l=0.06U
+ w=1.1U
M1873 VDD A_GRDT_3 XGMXA_3_GRDTB VDD
+ pch l=0.06U
+ w=1.1U
M1874 VDD XGMXA_3_DLRSB A_GRDT_3 VDD pch
+ l=0.06U
+ w=1.14U
M1875 VDD XGMXA_3_DLRSB A_GRDT_3 VDD pch
+ l=0.06U
+ w=1.14U
M1876 VDD XGMXA_3_DLRSB A_GRDT_3 VDD pch
+ l=0.06U
+ w=1.14U
M1877 A_GRDC_3 XGMXA_3_DLRSB VDD VDD pch
+ l=0.06U
+ w=1.14U
M1878 A_GRDC_3 XGMXA_3_DLRSB VDD VDD pch
+ l=0.06U
+ w=1.14U
M1879 A_GRDC_3 XGMXA_3_DLRSB VDD VDD pch
+ l=0.06U
+ w=1.14U
M1880 VDD XGMXA_3_Z2 XGMXA_3_Z3 VDD
+ pch l=0.06U
+ w=0.41U
M1881 A_QLATCH XGMXA_3_Z3 VDD VDD pch
+ l=0.06U
+ w=0.82U
M1882 A_QLATCH XGMXA_3_Z3 VDD VDD pch
+ l=0.06U
+ w=0.82U
M1883 VDD A_DLRS XGMXA_3_DLRSB VDD pch
+ l=0.06U
+ w=0.82U
M1884 A_MX A_GRDC_3 A_MXP VDD pch
+ l=0.06U
+ w=0.75U
M1885 A_MX A_GRDC_3 A_MXP VDD pch
+ l=0.06U
+ w=0.75U
M1886 A_MX A_GRDC_3 A_MXP VDD pch
+ l=0.06U
+ w=0.75U
M1887 A_MX A_GRDC_3 A_MXP VDD pch
+ l=0.06U
+ w=0.75U
M1888 VDD A_GRDT_3 XGMXA_3_Z1 VDD
+ pch l=0.06U
+ w=0.41U
M1889 VDD A_GRDT_3 A_GRDC_3 VDD pch
+ l=0.06U
+ w=0.41U
M1890 A_GRDT_3 A_GRDC_3 VDD VDD pch
+ l=0.06U
+ w=0.41U
M1891 VDD XGMXA_3_Z1 A_GRDT_3 VDD pch_hvt
+ l=0.12U
+ w=0.21U
M1892 XGMXA_3_Z1 A_GRDT_3 VSS VSS
+ nch l=0.06U
+ w=0.21U
M1893 XGWDVA_3_Z1 A_WENB_3 XGWDVA_3_Z2 VSS
+ nch_hvt l=0.06U
+	 w=0.41U
M1894 XGWDVA_3_Z5 XGWDVA_3_Z3 VSS VSS
+ nch_hvt l=0.06U
+	 w=0.41U
M1895 XGWDVA_3_Z4 A_DHT XGWDVA_3_Z2 VSS nch_hvt
+ l=0.06U
+ w=0.41U
M1896 VSS A_BWH XGWDVA_3_Z1 VSS nch_hvt
+ l=0.06U
+ w=0.41U
M1897 XGWDVA_3_Z3 A_DHC XGWDVA_3_Z2 VSS nch_hvt
+ l=0.06U
+ w=0.41U
M1898 VDD A_WENB_3 XGWDVA_3_Z3 VDD pch_hvt
+ l=0.06U
+ w=0.41U
M1899 VDD XGWDVA_3_Z3 XGWDVA_3_Z5 VDD
+ pch_hvt l=0.06U
+	 w=0.41U
M1900 VDD XGWDVA_3_Z3 XGWDVA_3_Z5 VDD
+ pch_hvt l=0.06U
+	 w=0.41U
M1901 VDD A_BWH XGWDVA_3_Z3 VDD pch_hvt
+ l=0.06U
+ w=0.41U
M1902 VDD A_DHC XGWDVA_3_Z3 VDD pch_hvt
+ l=0.06U
+ w=0.41U
M1903 XGWDVA_3_Z7 XGWDVA_3_Z5 VSS VSS
+ nch_hvt l=0.06U
+	 w=0.56U
M1904 XGWDVA_3_Z7 XGWDVA_3_Z5 VSS VSS
+ nch_hvt l=0.06U
+	 w=0.56U
M1905 XGWDVA_3_Z8 XGWDVA_3_Z6 VSS VSS
+ nch_hvt l=0.06U
+	 w=0.56U
M1906 XGWDVA_3_Z8 XGWDVA_3_Z6 VSS VSS
+ nch_hvt l=0.06U
+	 w=0.56U
M1907 A_GWDC_3 XGWDVA_3_Z7 VSS VSS
+ nch_hvt l=0.06U
+ w=0.56U
M1908 A_GWDC_3 XGWDVA_3_Z7 VSS VSS
+ nch_hvt l=0.06U
+	 w=0.56U
M1909 A_GWDC_3 XGWDVA_3_Z7 VSS VSS
+ nch_hvt l=0.06U
+	 w=0.56U
M1910 A_GWDC_3 XGWDVA_3_Z7 VSS VSS
+ nch_hvt l=0.06U
+	 w=0.56U
M1911 A_GWDT_3 XGWDVA_3_Z8 VSS VSS
+ nch_hvt l=0.06U
+ w=0.56U
M1912 A_GWDT_3 XGWDVA_3_Z8 VSS VSS
+ nch_hvt l=0.06U
+	 w=0.56U
M1913 A_GWDT_3 XGWDVA_3_Z8 VSS VSS
+ nch_hvt l=0.06U
+	 w=0.56U
M1914 A_GWDT_3 XGWDVA_3_Z8 VSS VSS
+ nch_hvt l=0.06U
+	 w=0.56U
M1915 VDD B_GRDC_3 XGMXB_3_Z2 VDD
+ pch l=0.06U
+ w=0.41U
M1916 VDD XGWDVB_3_Z4 XGWDVB_3_Z6 VDD
+ pch_hvt l=0.06U
+	 w=0.41U
M1917 VDD XGWDVB_3_Z6 XGWDVB_3_Z8 VDD
+ pch_hvt l=0.06U
+	 w=0.56U
M1918 VDD XGMXB_3_Z2 B_GRDC_3 VDD pch_hvt
+ l=0.12U
+	 w=0.21U
M1919 VDD XGWDVB_3_Z4 XGWDVB_3_Z6 VDD
+ pch_hvt l=0.06U
+	 w=0.41U
M1920 VDD XGWDVB_3_Z6 XGWDVB_3_Z8 VDD
+ pch_hvt l=0.06U
+	 w=0.56U
M1921 VDD B_BWH XGWDVB_3_Z4 VDD pch_hvt
+ l=0.06U
+ w=0.41U
M1922 VDD XGWDVB_3_Z8 B_GWDT_3 VDD
+ pch_hvt l=0.07U
+	 w=1.4U
M1923 VDD B_WENB_3 XGWDVB_3_Z4 VDD pch_hvt
+ l=0.06U
+ w=0.41U
M1924 VDD XGWDVB_3_Z8 B_GWDT_3 VDD
+ pch_hvt l=0.07U
+ w=1.4U
M1925 VDD B_DHT XGWDVB_3_Z4 VDD pch_hvt
+ l=0.06U
+ w=0.41U
M1926 VDD XGWDVB_3_Z8 B_GWDT_3 VDD
+ pch_hvt l=0.07U
+ w=1.4U
M1927 VDD XGWDVB_3_Z8 B_GWDT_3 VDD
+ pch_hvt l=0.07U
+ w=1.4U
M1928 VDD XGWDVB_3_Z7 B_GWDC_3 VDD
+ pch_hvt l=0.07U
+ w=1.4U
M1929 VDD XGWDVB_3_Z7 B_GWDC_3 VDD
+ pch_hvt l=0.07U
+ w=1.4U
M1930 VDD XGWDVB_3_Z7 B_GWDC_3 VDD
+ pch_hvt l=0.07U
+ w=1.4U
M1931 VDD XGWDVB_3_Z7 B_GWDC_3 VDD
+ pch_hvt l=0.07U
+	 w=1.4U
M1932 VDD XGWDVB_3_Z5 XGWDVB_3_Z7 VDD
+ pch_hvt l=0.06U
+	 w=0.56U
M1933 VDD XGWDVB_3_Z5 XGWDVB_3_Z7 VDD
+ pch_hvt l=0.06U
+	 w=0.56U
M1934 XGMXB_3_GRDTB B_GRDT_3 VSS VSS nch
+ l=0.06U
+ w=0.41U
M1935 XGMXB_3_GRDTB B_GRDT_3 VSS VSS
+ nch l=0.06U
+ w=0.41U
M1936 XGMXB_3_Z3 XGMXB_3_Z2 VSS VSS
+ nch l=0.06U
+ w=0.41U
M1937 XGMXB_3_DLRSB B_DLRS VSS VSS nch
+ l=0.06U
+ w=0.41U
M1938 B_QLATCH XGMXB_3_Z1 VSS VSS nch
+ l=0.06U
+ w=0.41U
M1939 B_QLATCH XGMXB_3_Z1 VSS VSS nch
+ l=0.06U
+ w=0.41U
M1940 B_MX XGMXB_3_GRDTB B_MXN VSS nch
+ l=0.06U
+ w=0.6U
M1941 B_MX XGMXB_3_GRDTB B_MXN VSS nch
+ l=0.06U
+ w=0.6U
M1942 B_MX XGMXB_3_GRDTB B_MXN VSS nch
+ l=0.06U
+ w=0.6U
M1943 B_MX XGMXB_3_GRDTB B_MXN VSS nch
+ l=0.06U
+ w=0.6U
M1944 VDD B_GRDT_3 XGMXB_3_GRDTB VDD pch
+ l=0.06U
+ w=1.1U
M1945 VDD B_GRDT_3 XGMXB_3_GRDTB VDD
+ pch l=0.06U
+ w=1.1U
M1946 VDD XGMXB_3_DLRSB B_GRDT_3 VDD pch
+ l=0.06U
+ w=1.14U
M1947 VDD XGMXB_3_DLRSB B_GRDT_3 VDD pch
+ l=0.06U
+ w=1.14U
M1948 VDD XGMXB_3_DLRSB B_GRDT_3 VDD pch
+ l=0.06U
+ w=1.14U
M1949 B_GRDC_3 XGMXB_3_DLRSB VDD VDD pch
+ l=0.06U
+ w=1.14U
M1950 B_GRDC_3 XGMXB_3_DLRSB VDD VDD pch
+ l=0.06U
+ w=1.14U
M1951 B_GRDC_3 XGMXB_3_DLRSB VDD VDD pch
+ l=0.06U
+ w=1.14U
M1952 VDD XGMXB_3_Z2 XGMXB_3_Z3 VDD
+ pch l=0.06U
+ w=0.41U
M1953 B_QLATCH XGMXB_3_Z3 VDD VDD pch
+ l=0.06U
+ w=0.82U
M1954 B_QLATCH XGMXB_3_Z3 VDD VDD pch
+ l=0.06U
+ w=0.82U
M1955 VDD B_DLRS XGMXB_3_DLRSB VDD pch
+ l=0.06U
+ w=0.82U
M1956 B_MX B_GRDC_3 B_MXP VDD pch
+ l=0.06U
+ w=0.75U
M1957 B_MX B_GRDC_3 B_MXP VDD pch
+ l=0.06U
+ w=0.75U
M1958 B_MX B_GRDC_3 B_MXP VDD pch
+ l=0.06U
+ w=0.75U
M1959 B_MX B_GRDC_3 B_MXP VDD pch
+ l=0.06U
+ w=0.75U
M1960 VDD B_GRDT_3 XGMXB_3_Z1 VDD
+ pch l=0.06U
+ w=0.41U
M1961 VDD B_GRDT_3 B_GRDC_3 VDD pch
+ l=0.06U
+ w=0.41U
M1962 B_GRDT_3 B_GRDC_3 VDD VDD pch
+ l=0.06U
+ w=0.41U
M1963 VDD XGMXB_3_Z1 B_GRDT_3 VDD pch_hvt
+ l=0.12U
+ w=0.21U
M1964 XGMXB_3_Z1 B_GRDT_3 VSS VSS
+ nch l=0.06U
+ w=0.21U
M1965 XGWDVB_3_Z1 B_WENB_3 XGWDVB_3_Z2 VSS
+ nch_hvt l=0.06U
+	 w=0.41U
M1966 XGWDVB_3_Z5 XGWDVB_3_Z3 VSS VSS
+ nch_hvt l=0.06U
+	 w=0.41U
M1967 XGWDVB_3_Z4 B_DHT XGWDVB_3_Z2 VSS nch_hvt
+ l=0.06U
+ w=0.41U
M1968 VSS B_BWH XGWDVB_3_Z1 VSS nch_hvt
+ l=0.06U
+ w=0.41U
M1969 XGWDVB_3_Z3 B_DHC XGWDVB_3_Z2 VSS nch_hvt
+ l=0.06U
+ w=0.41U
M1970 VDD B_WENB_3 XGWDVB_3_Z3 VDD pch_hvt
+ l=0.06U
+ w=0.41U
M1971 VDD XGWDVB_3_Z3 XGWDVB_3_Z5 VDD
+ pch_hvt l=0.06U
+	 w=0.41U
M1972 VDD XGWDVB_3_Z3 XGWDVB_3_Z5 VDD
+ pch_hvt l=0.06U
+	 w=0.41U
M1973 VDD B_BWH XGWDVB_3_Z3 VDD pch_hvt
+ l=0.06U
+ w=0.41U
M1974 VDD B_DHC XGWDVB_3_Z3 VDD pch_hvt
+ l=0.06U
+ w=0.41U
M1975 XGWDVB_3_Z7 XGWDVB_3_Z5 VSS VSS
+ nch_hvt l=0.06U
+	 w=0.56U
M1976 XGWDVB_3_Z7 XGWDVB_3_Z5 VSS VSS
+ nch_hvt l=0.06U
+	 w=0.56U
M1977 XGWDVB_3_Z8 XGWDVB_3_Z6 VSS VSS
+ nch_hvt l=0.06U
+	 w=0.56U
M1978 XGWDVB_3_Z8 XGWDVB_3_Z6 VSS VSS
+ nch_hvt l=0.06U
+	 w=0.56U
M1979 B_GWDC_3 XGWDVB_3_Z7 VSS VSS
+ nch_hvt l=0.06U
+ w=0.56U
M1980 B_GWDC_3 XGWDVB_3_Z7 VSS VSS
+ nch_hvt l=0.06U
+	 w=0.56U
M1981 B_GWDC_3 XGWDVB_3_Z7 VSS VSS
+ nch_hvt l=0.06U
+	 w=0.56U
M1982 B_GWDC_3 XGWDVB_3_Z7 VSS VSS
+ nch_hvt l=0.06U
+	 w=0.56U
M1983 B_GWDT_3 XGWDVB_3_Z8 VSS VSS
+ nch_hvt l=0.06U
+ w=0.56U
M1984 B_GWDT_3 XGWDVB_3_Z8 VSS VSS
+ nch_hvt l=0.06U
+	 w=0.56U
M1985 B_GWDT_3 XGWDVB_3_Z8 VSS VSS
+ nch_hvt l=0.06U
+	 w=0.56U
M1986 B_GWDT_3 XGWDVB_3_Z8 VSS VSS
+ nch_hvt l=0.06U
+	 w=0.56U
M1987 B_MX XDOUTB_QCKC XDOUTB_Z2 VSS nch
+ l=0.06U
+ w=0.42U
M1988 VSS XDOUTB_Z7 XDOUTB_Z2 VSS nch
+ l=0.06U
+ w=0.42U
M1989 B_Q B_MX VSS VSS nch
+ l=0.06U
+ w=0.375U
M1990 B_Q B_MX VSS VSS nch
+ l=0.06U
+ w=0.375U
M1991 B_Q B_MX VSS VSS nch
+ l=0.06U
+ w=0.375U
M1992 B_Q B_MX VSS VSS nch
+ l=0.06U
+ w=0.375U
M1993 A_MX XDOUTA_QCKC XDOUTA_Z2 VSS nch
+ l=0.06U
+ w=0.42U
M1994 VSS XDOUTA_Z7 XDOUTA_Z2 VSS nch
+ l=0.06U
+ w=0.42U
M1995 A_Q A_MX VSS VSS nch
+ l=0.06U
+ w=0.375U
M1996 A_Q A_MX VSS VSS nch
+ l=0.06U
+ w=0.375U
M1997 A_Q A_MX VSS VSS nch
+ l=0.06U
+ w=0.375U
M1998 A_Q A_MX VSS VSS nch
+ l=0.06U
+ w=0.375U
M1999 XDOUTB_DLRSB B_DLRS VSS VSS nch_hvt
+ l=0.06U
+ w=0.21U
M2000 XDOUTA_DLRSB A_DLRS VSS VSS nch_hvt
+ l=0.06U
+ w=0.21U
M2001 XGWDVA_2_Z6 XGWDVA_2_Z4 VSS VSS
+ nch_hvt l=0.06U
+	 w=0.41U
M2002 XGWDVB_2_Z6 XGWDVB_2_Z4 VSS VSS
+ nch_hvt l=0.06U
+	 w=0.41U
M2003 XGWDVB_3_Z6 XGWDVB_3_Z4 VSS VSS
+ nch_hvt l=0.06U
+	 w=0.41U
M2004 XGWDVA_3_Z6 XGWDVA_3_Z4 VSS VSS
+ nch_hvt l=0.06U
+	 w=0.41U
M2005 XGWDVA_0_Z6 XGWDVA_0_Z4 VSS VSS
+ nch_hvt l=0.06U
+	 w=0.41U
M2006 XGWDVB_0_Z6 XGWDVB_0_Z4 VSS VSS
+ nch_hvt l=0.06U
+	 w=0.41U
M2007 XGWDVB_1_Z6 XGWDVB_1_Z4 VSS VSS
+ nch_hvt l=0.06U
+	 w=0.41U
M2008 XGWDVA_1_Z6 XGWDVA_1_Z4 VSS VSS
+ nch_hvt l=0.06U
+	 w=0.41U
M2009 XGMXB_2_Z2 B_GRDC_2 VSS VSS
+ nch l=0.06U
+ w=0.21U
M2010 XGMXA_2_Z2 A_GRDC_2 VSS VSS
+ nch l=0.06U
+ w=0.21U
M2011 XGMXA_3_Z2 A_GRDC_3 VSS VSS
+ nch l=0.06U
+ w=0.21U
M2012 XGMXB_3_Z2 B_GRDC_3 VSS VSS
+ nch l=0.06U
+ w=0.21U
M2013 XGMXB_0_Z2 B_GRDC_0 VSS VSS
+ nch l=0.06U
+ w=0.21U
M2014 XGMXA_0_Z2 A_GRDC_0 VSS VSS
+ nch l=0.06U
+ w=0.21U
M2015 XGMXA_1_Z2 A_GRDC_1 VSS VSS
+ nch l=0.06U
+ w=0.21U
M2016 XGMXB_1_Z2 B_GRDC_1 VSS VSS
+ nch l=0.06U
+ w=0.21U
.ENDS
* CLC4A
.SUBCKT SDL400W20S_CLC4A A_GWDC A_GWDT B_GWDC B_GWDT RDL SMPRS_3 SMPRS_2
+	 SMPRS_1 SMPRS_0 SMPRSX SOE WRTL YSEL_7 YSEL_6 YSEL_5 YSEL_4
+	 YSEL_3 YSEL_2 YSEL_1 YSEL_0 A_GRDC A_GRDT BL_3 BL_2 BL_1 BL_0
+	 BLB_3 BLB_2 BLB_1 BLB_0 B_GRDC B_GRDT
M2017 XCLC4_XNR0_0_NET3 XCLC4_WRTLB VDD
+ VDD pch l=0.06U
+ w=0.7U
M2018 XCLC4_WBS_0 XCLC4_WRTLB VSS VSS
+ nch l=0.06U
+ w=0.35U
M2019 VDD XCLC4_YSELB_0 XCLC4_YSELT_0 VDD
+ pch_hvt l=0.06U
+ w=0.465U
M2020 BL_0 XCLC4_YSELT_0 VDD VDD pch
+ l=0.06U
+ w=0.59U
M2021 BL_0 XCLC4_YSELT_0 VDD VDD pch
+ l=0.06U
+ w=0.41U
M2022 XCLC4_YSELT_0 XCLC4_YSELB_0 VSS VSS
+ nch_hvt l=0.06U
+ w=0.41U
M2023 XCLC4_WBS_0 XCLC4_YSELB_0
+ XCLC4_XNR0_0_NET3 VDD pch l=0.06U
+ w=0.7U
M2024 VDD XCLC4_YSELB_0 XCLC4_YSELT_0 VDD
+ pch_hvt l=0.06U
+ w=0.465U
M2025 BL_0 XCLC4_YSELT_0 VDD VDD pch
+ l=0.06U
+ w=0.59U
M2026 BL_0 BLB_0 VDD VDD pch
+ l=0.06U
+ w=0.41U
M2027 XCLC4_WBS_0 XCLC4_YSELB_0 VSS VSS
+ nch l=0.06U
+ w=0.35U
M2028 VDD XCLC4_YSELB_0 XCLC4_YSELT_0 VDD
+ pch_hvt l=0.06U
+	 w=0.465U
M2029 BL_0 XCLC4_YSELT_0 VDD VDD pch
+ l=0.06U
+ w=1.44U
M2030 BL_0 XCLC4_YSELT_0 BLB_0 VDD pch
+ l=0.06U
+ w=1.8U
M2031 BLB_0 XCLC4_WBS_0 XCLC4_WC VSS nch
+ l=0.06U
+ w=0.54U
M2032 BL_0 XCLC4_WBS_0 XCLC4_WT VSS nch
+ l=0.06U
+	 w=0.54U
M2033 VDD YSEL_0 XCLC4_YSELB_0 VDD pch_hvt
+ l=0.06U
+ w=0.5U
M2034 VDD XCLC4_YSELT_0 BLB_0 VDD pch
+ l=0.06U
+ w=1.44U
M2035 BLB_0 XCLC4_WBS_0 XCLC4_WC VSS nch
+ l=0.06U
+ w=0.54U
M2036 BL_0 XCLC4_WBS_0 XCLC4_WT VSS nch
+ l=0.06U
+	 w=0.54U
M2037 VDD XCLC4_YSELT_0 XCLC4_RBS_0 VDD
+ pch_hvt l=0.06U
+	 w=0.41U
M2038 VDD XCLC4_YSELT_0 BLB_0 VDD pch
+ l=0.06U
+ w=0.59U
M2039 VDD BL_0 BLB_0 VDD pch
+ l=0.06U
+ w=0.41U
M2040 BLB_0 XCLC4_WBS_0 XCLC4_WC VSS nch
+ l=0.06U
+ w=0.54U
M2041 BL_0 XCLC4_WBS_0 XCLC4_WT VSS nch
+ l=0.06U
+	 w=0.54U
M2042 VDD XCLC4_RDLB XCLC4_RBS_0 VDD
+ pch_hvt l=0.06U
+	 w=0.41U
M2043 VDD XCLC4_YSELT_0 BLB_0 VDD pch
+ l=0.06U
+ w=0.59U
M2044 VDD XCLC4_YSELT_0 BLB_0 VDD pch
+ l=0.06U
+ w=0.41U
M2045 BLB_0 XCLC4_RBS_0 XCLC4_DC VDD pch
+ l=0.06U
+ w=0.41U
M2046 BLB_0 XCLC4_RBS_0 XCLC4_DC VDD pch
+ l=0.06U
+ w=0.41U
M2047 BL_0 XCLC4_RBS_0 XCLC4_DT VDD pch
+ l=0.06U
+	 w=0.41U
M2048 BL_0 XCLC4_RBS_0 XCLC4_DT VDD pch
+ l=0.06U
+ w=0.41U
M2049 XCLC4_XND0_0_NET9 XCLC4_RDLB
+ XCLC4_RBS_0 VSS nch_hvt l=0.06U
+ w=0.41U
M2050 VSS XCLC4_YSELT_0 XCLC4_XND0_0_NET9
+ VSS nch_hvt l=0.06U
+	 w=0.41U
M2051 XCLC4_YSELB_0 YSEL_0 VSS VSS nch_hvt
+ l=0.06U
+ w=0.5U
M2052 BLB_1 XCLC4_WBS_1 XCLC4_WC VSS nch
+ l=0.06U
+ w=0.54U
M2053 BL_1 XCLC4_WBS_1 XCLC4_WT VSS nch
+ l=0.06U
+	 w=0.54U
M2054 VDD XCLC4_RDLB XCLC4_RBS_1 VDD
+ pch_hvt l=0.06U
+	 w=0.41U
M2055 VDD XCLC4_YSELT_1 BLB_1 VDD pch
+ l=0.06U
+ w=0.59U
M2056 VDD XCLC4_YSELT_1 BLB_1 VDD pch
+ l=0.06U
+ w=0.41U
M2057 BLB_1 XCLC4_WBS_1 XCLC4_WC VSS nch
+ l=0.06U
+ w=0.54U
M2058 BL_1 XCLC4_WBS_1 XCLC4_WT VSS nch
+ l=0.06U
+	 w=0.54U
M2059 VDD XCLC4_YSELT_1 XCLC4_RBS_1 VDD
+ pch_hvt l=0.06U
+	 w=0.41U
M2060 VDD XCLC4_YSELT_1 BLB_1 VDD pch
+ l=0.06U
+ w=0.59U
M2061 VDD BL_1 BLB_1 VDD pch
+ l=0.06U
+ w=0.41U
M2062 BLB_1 XCLC4_WBS_1 XCLC4_WC VSS nch
+ l=0.06U
+ w=0.54U
M2063 BL_1 XCLC4_WBS_1 XCLC4_WT VSS nch
+ l=0.06U
+	 w=0.54U
M2064 VDD YSEL_1 XCLC4_YSELB_1 VDD pch_hvt
+ l=0.06U
+ w=0.5U
M2065 VDD XCLC4_YSELT_1 BLB_1 VDD pch
+ l=0.06U
+ w=1.44U
M2066 BL_1 XCLC4_YSELT_1 BLB_1 VDD pch
+ l=0.06U
+ w=1.8U
M2067 VDD XCLC4_YSELB_1 XCLC4_YSELT_1 VDD
+ pch_hvt l=0.06U
+	 w=0.465U
M2068 BL_1 XCLC4_YSELT_1 VDD VDD pch
+ l=0.06U
+ w=1.44U
M2069 XCLC4_WBS_1 XCLC4_YSELB_1
+ XCLC4_XNR0_1_NET3 VDD pch l=0.06U
+ w=0.7U
M2070 XCLC4_WBS_1 XCLC4_YSELB_1 VSS VSS
+ nch l=0.06U
+ w=0.35U
M2071 VDD XCLC4_YSELB_1 XCLC4_YSELT_1 VDD
+ pch_hvt l=0.06U
+	 w=0.465U
M2072 BL_1 XCLC4_YSELT_1 VDD VDD pch
+ l=0.06U
+ w=0.59U
M2073 BL_1 BLB_1 VDD VDD pch
+ l=0.06U
+ w=0.41U
M2074 XCLC4_XNR0_1_NET3 XCLC4_WRTLB VDD
+ VDD pch l=0.06U
+	 w=0.7U
M2075 XCLC4_WBS_1 XCLC4_WRTLB VSS VSS
+ nch l=0.06U
+ w=0.35U
M2076 XCLC4_YSELT_1 XCLC4_YSELB_1 VSS VSS
+ nch_hvt l=0.06U
+ w=0.41U
M2077 VDD XCLC4_YSELB_1 XCLC4_YSELT_1 VDD
+ pch_hvt l=0.06U
+	 w=0.465U
M2078 BL_1 XCLC4_YSELT_1 VDD VDD pch
+ l=0.06U
+ w=0.59U
M2079 BL_1 XCLC4_YSELT_1 VDD VDD pch
+ l=0.06U
+ w=0.41U
M2080 XCLC4_XNR0_2_NET3 XCLC4_WRTLB VDD
+ VDD pch l=0.06U
+	 w=0.7U
M2081 BLB_1 XCLC4_RBS_1 XCLC4_DC VDD pch
+ l=0.06U
+ w=0.41U
M2082 BLB_1 XCLC4_RBS_1 XCLC4_DC VDD pch
+ l=0.06U
+ w=0.41U
M2083 BL_1 XCLC4_RBS_1 XCLC4_DT VDD pch
+ l=0.06U
+	 w=0.41U
M2084 BL_1 XCLC4_RBS_1 XCLC4_DT VDD pch
+ l=0.06U
+ w=0.41U
M2085 XCLC4_XND0_1_NET9 XCLC4_RDLB
+ XCLC4_RBS_1 VSS nch_hvt l=0.06U
+ w=0.41U
M2086 VSS XCLC4_YSELT_1 XCLC4_XND0_1_NET9
+ VSS nch_hvt l=0.06U
+	 w=0.41U
M2087 XCLC4_YSELB_1 YSEL_1 VSS VSS nch_hvt
+ l=0.06U
+ w=0.5U
M2088 XCLC4_WBS_2 XCLC4_WRTLB VSS VSS
+ nch l=0.06U
+ w=0.35U
M2089 VDD XCLC4_YSELB_2 XCLC4_YSELT_2 VDD
+ pch_hvt l=0.06U
+	 w=0.465U
M2090 BL_2 XCLC4_YSELT_2 VDD VDD pch
+ l=0.06U
+ w=0.59U
M2091 BL_2 XCLC4_YSELT_2 VDD VDD pch
+ l=0.06U
+ w=0.41U
M2092 XCLC4_YSELT_2 XCLC4_YSELB_2 VSS VSS
+ nch_hvt l=0.06U
+ w=0.41U
M2093 XCLC4_WBS_2 XCLC4_YSELB_2
+ XCLC4_XNR0_2_NET3 VDD pch l=0.06U
+ w=0.7U
M2094 VDD XCLC4_YSELB_2 XCLC4_YSELT_2 VDD
+ pch_hvt l=0.06U
+	 w=0.465U
M2095 BL_2 XCLC4_YSELT_2 VDD VDD pch
+ l=0.06U
+ w=0.59U
M2096 BL_2 BLB_2 VDD VDD pch
+ l=0.06U
+ w=0.41U
M2097 XCLC4_WBS_2 XCLC4_YSELB_2 VSS VSS
+ nch l=0.06U
+ w=0.35U
M2098 VDD XCLC4_YSELB_2 XCLC4_YSELT_2 VDD
+ pch_hvt l=0.06U
+	 w=0.465U
M2099 BL_2 XCLC4_YSELT_2 VDD VDD pch
+ l=0.06U
+ w=1.44U
M2100 BL_2 XCLC4_YSELT_2 BLB_2 VDD pch
+ l=0.06U
+ w=1.8U
M2101 BLB_2 XCLC4_WBS_2 XCLC4_WC VSS nch
+ l=0.06U
+ w=0.54U
M2102 BL_2 XCLC4_WBS_2 XCLC4_WT VSS nch
+ l=0.06U
+	 w=0.54U
M2103 VDD YSEL_2 XCLC4_YSELB_2 VDD pch_hvt
+ l=0.06U
+ w=0.5U
M2104 VDD XCLC4_YSELT_2 BLB_2 VDD pch
+ l=0.06U
+ w=1.44U
M2105 BLB_2 XCLC4_WBS_2 XCLC4_WC VSS nch
+ l=0.06U
+ w=0.54U
M2106 BL_2 XCLC4_WBS_2 XCLC4_WT VSS nch
+ l=0.06U
+	 w=0.54U
M2107 VDD XCLC4_YSELT_2 XCLC4_RBS_2 VDD
+ pch_hvt l=0.06U
+	 w=0.41U
M2108 VDD XCLC4_YSELT_2 BLB_2 VDD pch
+ l=0.06U
+ w=0.59U
M2109 VDD BL_2 BLB_2 VDD pch
+ l=0.06U
+ w=0.41U
M2110 BLB_2 XCLC4_WBS_2 XCLC4_WC VSS nch
+ l=0.06U
+ w=0.54U
M2111 BL_2 XCLC4_WBS_2 XCLC4_WT VSS nch
+ l=0.06U
+	 w=0.54U
M2112 VDD XCLC4_RDLB XCLC4_RBS_2 VDD
+ pch_hvt l=0.06U
+	 w=0.41U
M2113 VDD XCLC4_YSELT_2 BLB_2 VDD pch
+ l=0.06U
+ w=0.59U
M2114 VDD XCLC4_YSELT_2 BLB_2 VDD pch
+ l=0.06U
+ w=0.41U
M2115 BLB_2 XCLC4_RBS_2 XCLC4_DC VDD pch
+ l=0.06U
+ w=0.41U
M2116 BLB_2 XCLC4_RBS_2 XCLC4_DC VDD pch
+ l=0.06U
+ w=0.41U
M2117 BL_2 XCLC4_RBS_2 XCLC4_DT VDD pch
+ l=0.06U
+	 w=0.41U
M2118 BL_2 XCLC4_RBS_2 XCLC4_DT VDD pch
+ l=0.06U
+ w=0.41U
M2119 XCLC4_XND0_2_NET9 XCLC4_RDLB
+ XCLC4_RBS_2 VSS nch_hvt l=0.06U
+ w=0.41U
M2120 VSS XCLC4_YSELT_2 XCLC4_XND0_2_NET9
+ VSS nch_hvt l=0.06U
+	 w=0.41U
M2121 XCLC4_YSELB_2 YSEL_2 VSS VSS nch_hvt
+ l=0.06U
+ w=0.5U
M2122 BLB_3 XCLC4_WBS_3 XCLC4_WC VSS nch
+ l=0.06U
+ w=0.54U
M2123 BL_3 XCLC4_WBS_3 XCLC4_WT VSS nch
+ l=0.06U
+	 w=0.54U
M2124 VDD XCLC4_RDLB XCLC4_RBS_3 VDD
+ pch_hvt l=0.06U
+	 w=0.41U
M2125 VDD XCLC4_YSELT_3 BLB_3 VDD pch
+ l=0.06U
+ w=0.59U
M2126 VDD XCLC4_YSELT_3 BLB_3 VDD pch
+ l=0.06U
+ w=0.41U
M2127 BLB_3 XCLC4_WBS_3 XCLC4_WC VSS nch
+ l=0.06U
+ w=0.54U
M2128 BL_3 XCLC4_WBS_3 XCLC4_WT VSS nch
+ l=0.06U
+	 w=0.54U
M2129 VDD XCLC4_YSELT_3 XCLC4_RBS_3 VDD
+ pch_hvt l=0.06U
+	 w=0.41U
M2130 VDD XCLC4_YSELT_3 BLB_3 VDD pch
+ l=0.06U
+ w=0.59U
M2131 VDD BL_3 BLB_3 VDD pch
+ l=0.06U
+ w=0.41U
M2132 BLB_3 XCLC4_WBS_3 XCLC4_WC VSS nch
+ l=0.06U
+ w=0.54U
M2133 BL_3 XCLC4_WBS_3 XCLC4_WT VSS nch
+ l=0.06U
+	 w=0.54U
M2134 VDD YSEL_3 XCLC4_YSELB_3 VDD pch_hvt
+ l=0.06U
+ w=0.5U
M2135 VDD XCLC4_YSELT_3 BLB_3 VDD pch
+ l=0.06U
+ w=1.44U
M2136 BL_3 XCLC4_YSELT_3 BLB_3 VDD pch
+ l=0.06U
+ w=1.8U
M2137 VDD XCLC4_YSELB_3 XCLC4_YSELT_3 VDD
+ pch_hvt l=0.06U
+	 w=0.465U
M2138 BL_3 XCLC4_YSELT_3 VDD VDD pch
+ l=0.06U
+ w=1.44U
M2139 XCLC4_WBS_3 XCLC4_YSELB_3
+ XCLC4_XNR0_3_NET3 VDD pch l=0.06U
+ w=0.7U
M2140 XCLC4_WBS_3 XCLC4_YSELB_3 VSS VSS
+ nch l=0.06U
+ w=0.35U
M2141 VDD XCLC4_YSELB_3 XCLC4_YSELT_3 VDD
+ pch_hvt l=0.06U
+ w=0.465U
M2142 BL_3 XCLC4_YSELT_3 VDD VDD pch
+ l=0.06U
+ w=0.59U
M2143 BL_3 BLB_3 VDD VDD pch
+ l=0.06U
+ w=0.41U
M2144 XCLC4_XNR0_3_NET3 XCLC4_WRTLB VDD
+ VDD pch l=0.06U
+ w=0.7U
M2145 XCLC4_WBS_3 XCLC4_WRTLB VSS VSS
+ nch l=0.06U
+ w=0.35U
M2146 XCLC4_YSELT_3 XCLC4_YSELB_3 VSS VSS
+ nch_hvt l=0.06U
+ w=0.41U
M2147 VDD XCLC4_YSELB_3 XCLC4_YSELT_3 VDD
+ pch_hvt l=0.06U
+ w=0.465U
M2148 BL_3 XCLC4_YSELT_3 VDD VDD pch
+ l=0.06U
+ w=0.59U
M2149 BL_3 XCLC4_YSELT_3 VDD VDD pch
+ l=0.06U
+ w=0.41U
M2150 VDD XCLC4_DT XCLC4_DTB VDD pch
+ l=0.06U
+ w=0.7U
M2151 VDD XCLC4_DT XCLC4_DTB VDD
+ pch l=0.06U
+ w=0.7U
M2152 XCLC4_DT XCLC4_DC VDD VDD pch
+ l=0.12U
+ w=0.41U
M2153 XCLC4_DT XCLC4_DC VDD VDD pch
+ l=0.12U
+ w=0.41U
M2154 VDD XCLC4_SMPRST XCLC4_DT VDD pch
+ l=0.06U
+ w=0.57U
M2155 VDD XCLC4_SMPRST XCLC4_DT VDD pch
+ l=0.06U
+ w=0.57U
M2156 VDD XCLC4_SMPRST XCLC4_DT VDD pch
+ l=0.06U
+ w=0.41U
M2157 VDD XCLC4_DT XCLC4_DC VDD pch
+ l=0.12U
+ w=0.41U
M2158 VDD XCLC4_DT XCLC4_DC VDD pch
+ l=0.12U
+ w=0.41U
M2159 XCLC4_DT XCLC4_SMPRST XCLC4_DC VDD
+ pch l=0.06U
+ w=0.41U
M2160 XCLC4_DC XCLC4_SMPRST VDD VDD pch
+ l=0.06U
+ w=0.57U
M2161 XCLC4_DC XCLC4_SMPRST VDD VDD pch
+ l=0.06U
+ w=0.41U
M2162 XCLC4_DC XCLC4_SMPRST VDD VDD pch
+ l=0.06U
+ w=0.57U
M2163 VDD XCLC4_DC XCLC4_DCB VDD pch
+ l=0.06U
+ w=0.7U
M2164 VDD XCLC4_DC XCLC4_DCB VDD
+ pch l=0.06U
+ w=0.7U
M2165 VDD A_GWDC XCLC4_WC VDD pch
+ l=0.06U
+ w=0.41U
M2166 VDD WRTL XCLC4_WRTLB VDD pch
+ l=0.06U
+ w=0.7U
M2167 VDD A_GWDT XCLC4_WT VDD pch
+ l=0.06U
+ w=0.41U
M2168 VDD RDL XCLC4_RDLB VDD pch
+ l=0.06U
+ w=0.7U
M2169 VDD SMPRSX XCLC4_XNRS_NET3 VDD pch
+ l=0.06U
+ w=0.7U
M2170 VDD SMPRSX XCLC4_SMPRST VDD pch
+ l=0.06U
+ w=0.41U
M2171 VDD SMPRSX XCLC4_SMPRST VDD pch
+ l=0.06U
+ w=0.41U
M2172 XCLC4_XNRS_NET3 SOE XCLC4_SET VDD pch
+ l=0.06U
+ w=0.7U
M2173 XCLC4_SMPRST SMPRSX VSS VSS nch
+ l=0.06U
+ w=0.41U
M2174 XCLC4_SET SMPRSX VSS VSS nch
+ l=0.06U
+ w=0.41U
M2175 XCLC4_SET SOE VSS VSS nch
+ l=0.06U
+ w=0.41U
M2176 XCLC4_WC A_GWDC VSS VSS nch
+ l=0.07U
+ w=1U
M2177 XCLC4_WC A_GWDC VSS VSS nch
+ l=0.07U
+ w=1U
M2178 XCLC4_WRTLB WRTL VSS VSS nch
+ l=0.06U
+ w=0.45U
M2179 XCLC4_DTB XCLC4_DT VSS VSS nch
+ l=0.06U
+ w=0.41U
M2180 XCLC4_NET18 XCLC4_DC XCLC4_DT VSS
+ nch l=0.12U
+ w=0.7U
M2181 XCLC4_NET18 XCLC4_DC XCLC4_DT VSS
+ nch l=0.12U
+ w=0.7U
M2182 A_GRDT XCLC4_DTB VSS VSS nch
+ l=0.06U
+ w=0.8U
M2183 A_GRDT XCLC4_DTB VSS VSS nch
+ l=0.06U
+ w=0.8U
M2184 A_GRDT XCLC4_DTB VSS VSS nch
+ l=0.06U
+ w=0.8U
M2185 A_GRDT XCLC4_DTB VSS VSS nch
+ l=0.06U
+ w=0.8U
M2186 XCLC4_NET18 XCLC4_SET VSS VSS nch
+ l=0.08U
+ w=0.7U
M2187 VSS XCLC4_DCB A_GRDC VSS nch
+ l=0.06U
+ w=0.8U
M2188 VSS XCLC4_DCB A_GRDC VSS nch
+ l=0.06U
+ w=0.8U
M2189 VSS XCLC4_DCB A_GRDC VSS nch
+ l=0.06U
+ w=0.8U
M2190 VSS XCLC4_DCB A_GRDC VSS nch
+ l=0.06U
+ w=0.8U
M2191 XCLC4_DC XCLC4_DT XCLC4_NET18 VSS
+ nch l=0.12U
+ w=0.7U
M2192 XCLC4_DC XCLC4_DT XCLC4_NET18 VSS
+ nch l=0.12U
+ w=0.7U
M2193 XCLC4_NET18 XCLC4_SET VSS VSS nch
+ l=0.08U
+ w=0.7U
M2194 XCLC4_DCB XCLC4_DC VSS VSS nch
+ l=0.06U
+ w=0.41U
M2195 XCLC4_WT A_GWDT VSS VSS nch
+ l=0.07U
+ w=1U
M2196 XCLC4_WT A_GWDT VSS VSS nch
+ l=0.07U
+ w=1U
M2197 XCLC4_RDLB RDL VSS VSS nch
+ l=0.06U
+ w=0.45U
M2198 BLB_3 XCLC4_RBS_3 XCLC4_DC VDD pch
+ l=0.06U
+ w=0.41U
M2199 BLB_3 XCLC4_RBS_3 XCLC4_DC VDD pch
+ l=0.06U
+ w=0.41U
M2200 BL_3 XCLC4_RBS_3 XCLC4_DT VDD pch
+ l=0.06U
+	 w=0.41U
M2201 BL_3 XCLC4_RBS_3 XCLC4_DT VDD pch
+ l=0.06U
+ w=0.41U
M2202 XCLC4_XND0_3_NET9 XCLC4_RDLB
+ XCLC4_RBS_3 VSS nch_hvt l=0.06U
+ w=0.41U
M2203 VSS XCLC4_YSELT_3 XCLC4_XND0_3_NET9
+ VSS nch_hvt l=0.06U
+	 w=0.41U
M2204 XCLC4_YSELB_3 YSEL_3 VSS VSS nch_hvt
+ l=0.06U
+ w=0.5U
.ENDS
* CLC4B
.SUBCKT SDL400W20S_CLC4B A_GWDC A_GWDT B_GWDC B_GWDT RDL SMPRS_3 SMPRS_2
+	 SMPRS_1 SMPRS_0 SMPRSX SOE WRTL YSEL_7 YSEL_6 YSEL_5 YSEL_4
+	 YSEL_3 YSEL_2 YSEL_1 YSEL_0 A_GRDC A_GRDT BL_3 BL_2 BL_1 BL_0
+	 BLB_3 BLB_2 BLB_1 BLB_0 B_GRDC B_GRDT
M2205 XCLC4_XNR0_0_NET3 XCLC4_WRTLB VDD
+ VDD pch l=0.06U
+ w=0.7U
M2206 XCLC4_WBS_0 XCLC4_WRTLB VSS VSS
+ nch l=0.06U
+ w=0.35U
M2207 VDD XCLC4_YSELB_0 XCLC4_YSELT_0 VDD
+ pch_hvt l=0.06U
+ w=0.465U
M2208 BL_0 XCLC4_YSELT_0 VDD VDD pch
+ l=0.06U
+ w=0.59U
M2209 BL_0 XCLC4_YSELT_0 VDD VDD pch
+ l=0.06U
+ w=0.41U
M2210 XCLC4_YSELT_0 XCLC4_YSELB_0 VSS VSS
+ nch_hvt l=0.06U
+ w=0.41U
M2211 XCLC4_WBS_0 XCLC4_YSELB_0
+ XCLC4_XNR0_0_NET3 VDD pch l=0.06U
+ w=0.7U
M2212 VDD XCLC4_YSELB_0 XCLC4_YSELT_0 VDD
+ pch_hvt l=0.06U
+ w=0.465U
M2213 BL_0 XCLC4_YSELT_0 VDD VDD pch
+ l=0.06U
+ w=0.59U
M2214 BL_0 BLB_0 VDD VDD pch
+ l=0.06U
+ w=0.41U
M2215 XCLC4_WBS_0 XCLC4_YSELB_0 VSS VSS
+ nch l=0.06U
+ w=0.35U
M2216 VDD XCLC4_YSELB_0 XCLC4_YSELT_0 VDD
+ pch_hvt l=0.06U
+	 w=0.465U
M2217 BL_0 XCLC4_YSELT_0 VDD VDD pch
+ l=0.06U
+ w=1.44U
M2218 BL_0 XCLC4_YSELT_0 BLB_0 VDD pch
+ l=0.06U
+ w=1.8U
M2219 BLB_0 XCLC4_WBS_0 XCLC4_WC VSS nch
+ l=0.06U
+ w=0.54U
M2220 BL_0 XCLC4_WBS_0 XCLC4_WT VSS nch
+ l=0.06U
+	 w=0.54U
M2221 VDD YSEL_0 XCLC4_YSELB_0 VDD pch_hvt
+ l=0.06U
+ w=0.5U
M2222 VDD XCLC4_YSELT_0 BLB_0 VDD pch
+ l=0.06U
+ w=1.44U
M2223 BLB_0 XCLC4_WBS_0 XCLC4_WC VSS nch
+ l=0.06U
+ w=0.54U
M2224 BL_0 XCLC4_WBS_0 XCLC4_WT VSS nch
+ l=0.06U
+	 w=0.54U
M2225 VDD XCLC4_YSELT_0 XCLC4_RBS_0 VDD
+ pch_hvt l=0.06U
+	 w=0.41U
M2226 VDD XCLC4_YSELT_0 BLB_0 VDD pch
+ l=0.06U
+ w=0.59U
M2227 VDD BL_0 BLB_0 VDD pch
+ l=0.06U
+ w=0.41U
M2228 BLB_0 XCLC4_WBS_0 XCLC4_WC VSS nch
+ l=0.06U
+ w=0.54U
M2229 BL_0 XCLC4_WBS_0 XCLC4_WT VSS nch
+ l=0.06U
+	 w=0.54U
M2230 VDD XCLC4_RDLB XCLC4_RBS_0 VDD
+ pch_hvt l=0.06U
+	 w=0.41U
M2231 VDD XCLC4_YSELT_0 BLB_0 VDD pch
+ l=0.06U
+ w=0.59U
M2232 VDD XCLC4_YSELT_0 BLB_0 VDD pch
+ l=0.06U
+ w=0.41U
M2233 BLB_0 XCLC4_RBS_0 XCLC4_DC VDD pch
+ l=0.06U
+ w=0.41U
M2234 BLB_0 XCLC4_RBS_0 XCLC4_DC VDD pch
+ l=0.06U
+ w=0.41U
M2235 BL_0 XCLC4_RBS_0 XCLC4_DT VDD pch
+ l=0.06U
+	 w=0.41U
M2236 BL_0 XCLC4_RBS_0 XCLC4_DT VDD pch
+ l=0.06U
+ w=0.41U
M2237 XCLC4_XND0_0_NET9 XCLC4_RDLB
+ XCLC4_RBS_0 VSS nch_hvt l=0.06U
+ w=0.41U
M2238 VSS XCLC4_YSELT_0 XCLC4_XND0_0_NET9
+ VSS nch_hvt l=0.06U
+	 w=0.41U
M2239 XCLC4_YSELB_0 YSEL_0 VSS VSS nch_hvt
+ l=0.06U
+ w=0.5U
M2240 BLB_1 XCLC4_WBS_1 XCLC4_WC VSS nch
+ l=0.06U
+ w=0.54U
M2241 BL_1 XCLC4_WBS_1 XCLC4_WT VSS nch
+ l=0.06U
+	 w=0.54U
M2242 VDD XCLC4_RDLB XCLC4_RBS_1 VDD
+ pch_hvt l=0.06U
+	 w=0.41U
M2243 VDD XCLC4_YSELT_1 BLB_1 VDD pch
+ l=0.06U
+ w=0.59U
M2244 VDD XCLC4_YSELT_1 BLB_1 VDD pch
+ l=0.06U
+ w=0.41U
M2245 BLB_1 XCLC4_WBS_1 XCLC4_WC VSS nch
+ l=0.06U
+ w=0.54U
M2246 BL_1 XCLC4_WBS_1 XCLC4_WT VSS nch
+ l=0.06U
+	 w=0.54U
M2247 VDD XCLC4_YSELT_1 XCLC4_RBS_1 VDD
+ pch_hvt l=0.06U
+	 w=0.41U
M2248 VDD XCLC4_YSELT_1 BLB_1 VDD pch
+ l=0.06U
+ w=0.59U
M2249 VDD BL_1 BLB_1 VDD pch
+ l=0.06U
+ w=0.41U
M2250 BLB_1 XCLC4_WBS_1 XCLC4_WC VSS nch
+ l=0.06U
+ w=0.54U
M2251 BL_1 XCLC4_WBS_1 XCLC4_WT VSS nch
+ l=0.06U
+	 w=0.54U
M2252 VDD YSEL_1 XCLC4_YSELB_1 VDD pch_hvt
+ l=0.06U
+ w=0.5U
M2253 VDD XCLC4_YSELT_1 BLB_1 VDD pch
+ l=0.06U
+ w=1.44U
M2254 BL_1 XCLC4_YSELT_1 BLB_1 VDD pch
+ l=0.06U
+ w=1.8U
M2255 VDD XCLC4_YSELB_1 XCLC4_YSELT_1 VDD
+ pch_hvt l=0.06U
+	 w=0.465U
M2256 BL_1 XCLC4_YSELT_1 VDD VDD pch
+ l=0.06U
+ w=1.44U
M2257 XCLC4_WBS_1 XCLC4_YSELB_1
+ XCLC4_XNR0_1_NET3 VDD pch l=0.06U
+ w=0.7U
M2258 XCLC4_WBS_1 XCLC4_YSELB_1 VSS VSS
+ nch l=0.06U
+ w=0.35U
M2259 VDD XCLC4_YSELB_1 XCLC4_YSELT_1 VDD
+ pch_hvt l=0.06U
+	 w=0.465U
M2260 BL_1 XCLC4_YSELT_1 VDD VDD pch
+ l=0.06U
+ w=0.59U
M2261 BL_1 BLB_1 VDD VDD pch
+ l=0.06U
+ w=0.41U
M2262 XCLC4_XNR0_1_NET3 XCLC4_WRTLB VDD
+ VDD pch l=0.06U
+	 w=0.7U
M2263 XCLC4_WBS_1 XCLC4_WRTLB VSS VSS
+ nch l=0.06U
+ w=0.35U
M2264 XCLC4_YSELT_1 XCLC4_YSELB_1 VSS VSS
+ nch_hvt l=0.06U
+ w=0.41U
M2265 VDD XCLC4_YSELB_1 XCLC4_YSELT_1 VDD
+ pch_hvt l=0.06U
+	 w=0.465U
M2266 BL_1 XCLC4_YSELT_1 VDD VDD pch
+ l=0.06U
+ w=0.59U
M2267 BL_1 XCLC4_YSELT_1 VDD VDD pch
+ l=0.06U
+ w=0.41U
M2268 XCLC4_XNR0_2_NET3 XCLC4_WRTLB VDD
+ VDD pch l=0.06U
+	 w=0.7U
M2269 BLB_1 XCLC4_RBS_1 XCLC4_DC VDD pch
+ l=0.06U
+ w=0.41U
M2270 BLB_1 XCLC4_RBS_1 XCLC4_DC VDD pch
+ l=0.06U
+ w=0.41U
M2271 BL_1 XCLC4_RBS_1 XCLC4_DT VDD pch
+ l=0.06U
+	 w=0.41U
M2272 BL_1 XCLC4_RBS_1 XCLC4_DT VDD pch
+ l=0.06U
+ w=0.41U
M2273 XCLC4_XND0_1_NET9 XCLC4_RDLB
+ XCLC4_RBS_1 VSS nch_hvt l=0.06U
+ w=0.41U
M2274 VSS XCLC4_YSELT_1 XCLC4_XND0_1_NET9
+ VSS nch_hvt l=0.06U
+	 w=0.41U
M2275 XCLC4_YSELB_1 YSEL_1 VSS VSS nch_hvt
+ l=0.06U
+ w=0.5U
M2276 XCLC4_WBS_2 XCLC4_WRTLB VSS VSS
+ nch l=0.06U
+ w=0.35U
M2277 VDD XCLC4_YSELB_2 XCLC4_YSELT_2 VDD
+ pch_hvt l=0.06U
+	 w=0.465U
M2278 BL_2 XCLC4_YSELT_2 VDD VDD pch
+ l=0.06U
+ w=0.59U
M2279 BL_2 XCLC4_YSELT_2 VDD VDD pch
+ l=0.06U
+ w=0.41U
M2280 XCLC4_YSELT_2 XCLC4_YSELB_2 VSS VSS
+ nch_hvt l=0.06U
+ w=0.41U
M2281 XCLC4_WBS_2 XCLC4_YSELB_2
+ XCLC4_XNR0_2_NET3 VDD pch l=0.06U
+ w=0.7U
M2282 VDD XCLC4_YSELB_2 XCLC4_YSELT_2 VDD
+ pch_hvt l=0.06U
+	 w=0.465U
M2283 BL_2 XCLC4_YSELT_2 VDD VDD pch
+ l=0.06U
+ w=0.59U
M2284 BL_2 BLB_2 VDD VDD pch
+ l=0.06U
+ w=0.41U
M2285 XCLC4_WBS_2 XCLC4_YSELB_2 VSS VSS
+ nch l=0.06U
+ w=0.35U
M2286 VDD XCLC4_YSELB_2 XCLC4_YSELT_2 VDD
+ pch_hvt l=0.06U
+	 w=0.465U
M2287 BL_2 XCLC4_YSELT_2 VDD VDD pch
+ l=0.06U
+ w=1.44U
M2288 BL_2 XCLC4_YSELT_2 BLB_2 VDD pch
+ l=0.06U
+ w=1.8U
M2289 BLB_2 XCLC4_WBS_2 XCLC4_WC VSS nch
+ l=0.06U
+ w=0.54U
M2290 BL_2 XCLC4_WBS_2 XCLC4_WT VSS nch
+ l=0.06U
+	 w=0.54U
M2291 VDD YSEL_2 XCLC4_YSELB_2 VDD pch_hvt
+ l=0.06U
+ w=0.5U
M2292 VDD XCLC4_YSELT_2 BLB_2 VDD pch
+ l=0.06U
+ w=1.44U
M2293 BLB_2 XCLC4_WBS_2 XCLC4_WC VSS nch
+ l=0.06U
+ w=0.54U
M2294 BL_2 XCLC4_WBS_2 XCLC4_WT VSS nch
+ l=0.06U
+	 w=0.54U
M2295 VDD XCLC4_YSELT_2 XCLC4_RBS_2 VDD
+ pch_hvt l=0.06U
+	 w=0.41U
M2296 VDD XCLC4_YSELT_2 BLB_2 VDD pch
+ l=0.06U
+ w=0.59U
M2297 VDD BL_2 BLB_2 VDD pch
+ l=0.06U
+ w=0.41U
M2298 BLB_2 XCLC4_WBS_2 XCLC4_WC VSS nch
+ l=0.06U
+ w=0.54U
M2299 BL_2 XCLC4_WBS_2 XCLC4_WT VSS nch
+ l=0.06U
+	 w=0.54U
M2300 VDD XCLC4_RDLB XCLC4_RBS_2 VDD
+ pch_hvt l=0.06U
+	 w=0.41U
M2301 VDD XCLC4_YSELT_2 BLB_2 VDD pch
+ l=0.06U
+ w=0.59U
M2302 VDD XCLC4_YSELT_2 BLB_2 VDD pch
+ l=0.06U
+ w=0.41U
M2303 BLB_2 XCLC4_RBS_2 XCLC4_DC VDD pch
+ l=0.06U
+ w=0.41U
M2304 BLB_2 XCLC4_RBS_2 XCLC4_DC VDD pch
+ l=0.06U
+ w=0.41U
M2305 BL_2 XCLC4_RBS_2 XCLC4_DT VDD pch
+ l=0.06U
+	 w=0.41U
M2306 BL_2 XCLC4_RBS_2 XCLC4_DT VDD pch
+ l=0.06U
+ w=0.41U
M2307 XCLC4_XND0_2_NET9 XCLC4_RDLB
+ XCLC4_RBS_2 VSS nch_hvt l=0.06U
+ w=0.41U
M2308 VSS XCLC4_YSELT_2 XCLC4_XND0_2_NET9
+ VSS nch_hvt l=0.06U
+	 w=0.41U
M2309 XCLC4_YSELB_2 YSEL_2 VSS VSS nch_hvt
+ l=0.06U
+ w=0.5U
M2310 BLB_3 XCLC4_WBS_3 XCLC4_WC VSS nch
+ l=0.06U
+ w=0.54U
M2311 BL_3 XCLC4_WBS_3 XCLC4_WT VSS nch
+ l=0.06U
+	 w=0.54U
M2312 VDD XCLC4_RDLB XCLC4_RBS_3 VDD
+ pch_hvt l=0.06U
+	 w=0.41U
M2313 VDD XCLC4_YSELT_3 BLB_3 VDD pch
+ l=0.06U
+ w=0.59U
M2314 VDD XCLC4_YSELT_3 BLB_3 VDD pch
+ l=0.06U
+ w=0.41U
M2315 BLB_3 XCLC4_WBS_3 XCLC4_WC VSS nch
+ l=0.06U
+ w=0.54U
M2316 BL_3 XCLC4_WBS_3 XCLC4_WT VSS nch
+ l=0.06U
+	 w=0.54U
M2317 VDD XCLC4_YSELT_3 XCLC4_RBS_3 VDD
+ pch_hvt l=0.06U
+	 w=0.41U
M2318 VDD XCLC4_YSELT_3 BLB_3 VDD pch
+ l=0.06U
+ w=0.59U
M2319 VDD BL_3 BLB_3 VDD pch
+ l=0.06U
+ w=0.41U
M2320 BLB_3 XCLC4_WBS_3 XCLC4_WC VSS nch
+ l=0.06U
+ w=0.54U
M2321 BL_3 XCLC4_WBS_3 XCLC4_WT VSS nch
+ l=0.06U
+	 w=0.54U
M2322 VDD YSEL_3 XCLC4_YSELB_3 VDD pch_hvt
+ l=0.06U
+ w=0.5U
M2323 VDD XCLC4_YSELT_3 BLB_3 VDD pch
+ l=0.06U
+ w=1.44U
M2324 BL_3 XCLC4_YSELT_3 BLB_3 VDD pch
+ l=0.06U
+ w=1.8U
M2325 VDD XCLC4_YSELB_3 XCLC4_YSELT_3 VDD
+ pch_hvt l=0.06U
+	 w=0.465U
M2326 BL_3 XCLC4_YSELT_3 VDD VDD pch
+ l=0.06U
+ w=1.44U
M2327 XCLC4_WBS_3 XCLC4_YSELB_3
+ XCLC4_XNR0_3_NET3 VDD pch l=0.06U
+ w=0.7U
M2328 XCLC4_WBS_3 XCLC4_YSELB_3 VSS VSS
+ nch l=0.06U
+ w=0.35U
M2329 VDD XCLC4_YSELB_3 XCLC4_YSELT_3 VDD
+ pch_hvt l=0.06U
+ w=0.465U
M2330 BL_3 XCLC4_YSELT_3 VDD VDD pch
+ l=0.06U
+ w=0.59U
M2331 BL_3 BLB_3 VDD VDD pch
+ l=0.06U
+ w=0.41U
M2332 XCLC4_XNR0_3_NET3 XCLC4_WRTLB VDD
+ VDD pch l=0.06U
+ w=0.7U
M2333 XCLC4_WBS_3 XCLC4_WRTLB VSS VSS
+ nch l=0.06U
+ w=0.35U
M2334 XCLC4_YSELT_3 XCLC4_YSELB_3 VSS VSS
+ nch_hvt l=0.06U
+ w=0.41U
M2335 VDD XCLC4_YSELB_3 XCLC4_YSELT_3 VDD
+ pch_hvt l=0.06U
+ w=0.465U
M2336 BL_3 XCLC4_YSELT_3 VDD VDD pch
+ l=0.06U
+ w=0.59U
M2337 BL_3 XCLC4_YSELT_3 VDD VDD pch
+ l=0.06U
+ w=0.41U
M2338 VDD XCLC4_DT XCLC4_DTB VDD pch
+ l=0.06U
+ w=0.7U
M2339 VDD XCLC4_DT XCLC4_DTB VDD
+ pch l=0.06U
+ w=0.7U
M2340 XCLC4_DT XCLC4_DC VDD VDD pch
+ l=0.12U
+ w=0.41U
M2341 XCLC4_DT XCLC4_DC VDD VDD pch
+ l=0.12U
+ w=0.41U
M2342 VDD XCLC4_SMPRST XCLC4_DT VDD pch
+ l=0.06U
+ w=0.57U
M2343 VDD XCLC4_SMPRST XCLC4_DT VDD pch
+ l=0.06U
+ w=0.57U
M2344 VDD XCLC4_SMPRST XCLC4_DT VDD pch
+ l=0.06U
+ w=0.41U
M2345 VDD XCLC4_DT XCLC4_DC VDD pch
+ l=0.12U
+ w=0.41U
M2346 VDD XCLC4_DT XCLC4_DC VDD pch
+ l=0.12U
+ w=0.41U
M2347 XCLC4_DT XCLC4_SMPRST XCLC4_DC VDD
+ pch l=0.06U
+ w=0.41U
M2348 XCLC4_DC XCLC4_SMPRST VDD VDD pch
+ l=0.06U
+ w=0.57U
M2349 XCLC4_DC XCLC4_SMPRST VDD VDD pch
+ l=0.06U
+ w=0.41U
M2350 XCLC4_DC XCLC4_SMPRST VDD VDD pch
+ l=0.06U
+ w=0.57U
M2351 VDD XCLC4_DC XCLC4_DCB VDD pch
+ l=0.06U
+ w=0.7U
M2352 VDD XCLC4_DC XCLC4_DCB VDD
+ pch l=0.06U
+ w=0.7U
M2353 VDD B_GWDC XCLC4_WC VDD pch
+ l=0.06U
+ w=0.41U
M2354 VDD WRTL XCLC4_WRTLB VDD pch
+ l=0.06U
+ w=0.7U
M2355 VDD B_GWDT XCLC4_WT VDD pch
+ l=0.06U
+ w=0.41U
M2356 VDD RDL XCLC4_RDLB VDD pch
+ l=0.06U
+ w=0.7U
M2357 VDD SMPRSX XCLC4_XNRS_NET3 VDD pch
+ l=0.06U
+ w=0.7U
M2358 VDD SMPRSX XCLC4_SMPRST VDD pch
+ l=0.06U
+ w=0.41U
M2359 VDD SMPRSX XCLC4_SMPRST VDD pch
+ l=0.06U
+ w=0.41U
M2360 XCLC4_XNRS_NET3 SOE XCLC4_SET VDD pch
+ l=0.06U
+ w=0.7U
M2361 XCLC4_SMPRST SMPRSX VSS VSS nch
+ l=0.06U
+ w=0.41U
M2362 XCLC4_SET SMPRSX VSS VSS nch
+ l=0.06U
+ w=0.41U
M2363 XCLC4_SET SOE VSS VSS nch
+ l=0.06U
+ w=0.41U
M2364 XCLC4_WC B_GWDC VSS VSS nch
+ l=0.07U
+ w=1U
M2365 XCLC4_WC B_GWDC VSS VSS nch
+ l=0.07U
+ w=1U
M2366 XCLC4_WRTLB WRTL VSS VSS nch
+ l=0.06U
+ w=0.45U
M2367 XCLC4_DTB XCLC4_DT VSS VSS nch
+ l=0.06U
+ w=0.41U
M2368 XCLC4_NET18 XCLC4_DC XCLC4_DT VSS
+ nch l=0.12U
+ w=0.7U
M2369 XCLC4_NET18 XCLC4_DC XCLC4_DT VSS
+ nch l=0.12U
+ w=0.7U
M2370 B_GRDT XCLC4_DTB VSS VSS nch
+ l=0.06U
+ w=0.8U
M2371 B_GRDT XCLC4_DTB VSS VSS nch
+ l=0.06U
+ w=0.8U
M2372 B_GRDT XCLC4_DTB VSS VSS nch
+ l=0.06U
+ w=0.8U
M2373 B_GRDT XCLC4_DTB VSS VSS nch
+ l=0.06U
+ w=0.8U
M2374 XCLC4_NET18 XCLC4_SET VSS VSS nch
+ l=0.08U
+ w=0.7U
M2375 VSS XCLC4_DCB B_GRDC VSS nch
+ l=0.06U
+ w=0.8U
M2376 VSS XCLC4_DCB B_GRDC VSS nch
+ l=0.06U
+ w=0.8U
M2377 VSS XCLC4_DCB B_GRDC VSS nch
+ l=0.06U
+ w=0.8U
M2378 VSS XCLC4_DCB B_GRDC VSS nch
+ l=0.06U
+ w=0.8U
M2379 XCLC4_DC XCLC4_DT XCLC4_NET18 VSS
+ nch l=0.12U
+ w=0.7U
M2380 XCLC4_DC XCLC4_DT XCLC4_NET18 VSS
+ nch l=0.12U
+ w=0.7U
M2381 XCLC4_NET18 XCLC4_SET VSS VSS nch
+ l=0.08U
+ w=0.7U
M2382 XCLC4_DCB XCLC4_DC VSS VSS nch
+ l=0.06U
+ w=0.41U
M2383 XCLC4_WT B_GWDT VSS VSS nch
+ l=0.07U
+ w=1U
M2384 XCLC4_WT B_GWDT VSS VSS nch
+ l=0.07U
+ w=1U
M2385 XCLC4_RDLB RDL VSS VSS nch
+ l=0.06U
+ w=0.45U
M2386 BLB_3 XCLC4_RBS_3 XCLC4_DC VDD pch
+ l=0.06U
+ w=0.41U
M2387 BLB_3 XCLC4_RBS_3 XCLC4_DC VDD pch
+ l=0.06U
+ w=0.41U
M2388 BL_3 XCLC4_RBS_3 XCLC4_DT VDD pch
+ l=0.06U
+	 w=0.41U
M2389 BL_3 XCLC4_RBS_3 XCLC4_DT VDD pch
+ l=0.06U
+ w=0.41U
M2390 XCLC4_XND0_3_NET9 XCLC4_RDLB
+ XCLC4_RBS_3 VSS nch_hvt l=0.06U
+ w=0.41U
M2391 VSS XCLC4_YSELT_3 XCLC4_XND0_3_NET9
+ VSS nch_hvt l=0.06U
+	 w=0.41U
M2392 XCLC4_YSELB_3 YSEL_3 VSS VSS nch_hvt
+ l=0.06U
+ w=0.5U
.ENDS
* CLC4BT
.SUBCKT SDL400W20S_CLC4BT A_GWDC A_GWDT B_GWDC B_GWDT RDL SMPRS_3 SMPRS_2
+	 SMPRS_1 SMPRS_0 SMPRSX SOE WRTL YSEL_7 YSEL_6 YSEL_5 YSEL_4
+	 YSEL_3 YSEL_2 YSEL_1 YSEL_0 A_GRDC A_GRDT BL_3 BL_2 BL_1 BL_0
+	 BLB_3 BLB_2 BLB_1 BLB_0 B_GRDC B_GRDT
M2393 XCLC4_XNR0_0_NET3 XCLC4_WRTLB VDD
+ VDD pch l=0.06U
+ w=0.7U
M2394 XCLC4_WBS_0 XCLC4_WRTLB VSS VSS
+ nch l=0.06U
+ w=0.35U
M2395 VDD XCLC4_YSELB_0 XCLC4_YSELT_0 VDD
+ pch_hvt l=0.06U
+ w=0.465U
M2396 VDD XCLC4_YSELT_0 BLB_0 VDD pch
+ l=0.06U
+ w=0.59U
M2397 VDD XCLC4_YSELT_0 BLB_0 VDD pch
+ l=0.06U
+ w=0.41U
M2398 XCLC4_YSELT_0 XCLC4_YSELB_0 VSS VSS
+ nch_hvt l=0.06U
+ w=0.41U
M2399 XCLC4_WBS_0 XCLC4_YSELB_0
+ XCLC4_XNR0_0_NET3 VDD pch l=0.06U
+ w=0.7U
M2400 VDD XCLC4_YSELB_0 XCLC4_YSELT_0 VDD
+ pch_hvt l=0.06U
+ w=0.465U
M2401 VDD XCLC4_YSELT_0 BLB_0 VDD pch
+ l=0.06U
+ w=0.59U
M2402 VDD BL_0 BLB_0 VDD pch
+ l=0.06U
+ w=0.41U
M2403 XCLC4_WBS_0 XCLC4_YSELB_0 VSS VSS
+ nch l=0.06U
+ w=0.35U
M2404 VDD XCLC4_YSELB_0 XCLC4_YSELT_0 VDD
+ pch_hvt l=0.06U
+	 w=0.465U
M2405 VDD XCLC4_YSELT_0 BLB_0 VDD pch
+ l=0.06U
+ w=1.44U
M2406 BL_0 XCLC4_YSELT_0 BLB_0 VDD pch
+ l=0.06U
+ w=1.8U
M2407 BL_0 XCLC4_WBS_0 XCLC4_WT VSS nch
+ l=0.06U
+ w=0.54U
M2408 BLB_0 XCLC4_WBS_0 XCLC4_WC VSS nch
+ l=0.06U
+	 w=0.54U
M2409 VDD YSEL_0 XCLC4_YSELB_0 VDD pch_hvt
+ l=0.06U
+ w=0.5U
M2410 BL_0 XCLC4_YSELT_0 VDD VDD pch
+ l=0.06U
+ w=1.44U
M2411 BL_0 XCLC4_WBS_0 XCLC4_WT VSS nch
+ l=0.06U
+ w=0.54U
M2412 BLB_0 XCLC4_WBS_0 XCLC4_WC VSS nch
+ l=0.06U
+	 w=0.54U
M2413 VDD XCLC4_YSELT_0 XCLC4_RBS_0 VDD
+ pch_hvt l=0.06U
+	 w=0.41U
M2414 BL_0 XCLC4_YSELT_0 VDD VDD pch
+ l=0.06U
+ w=0.59U
M2415 BL_0 BLB_0 VDD VDD pch
+ l=0.06U
+ w=0.41U
M2416 BL_0 XCLC4_WBS_0 XCLC4_WT VSS nch
+ l=0.06U
+ w=0.54U
M2417 BLB_0 XCLC4_WBS_0 XCLC4_WC VSS nch
+ l=0.06U
+	 w=0.54U
M2418 VDD XCLC4_RDLB XCLC4_RBS_0 VDD
+ pch_hvt l=0.06U
+	 w=0.41U
M2419 BL_0 XCLC4_YSELT_0 VDD VDD pch
+ l=0.06U
+ w=0.59U
M2420 BL_0 XCLC4_YSELT_0 VDD VDD pch
+ l=0.06U
+ w=0.41U
M2421 BL_0 XCLC4_RBS_0 XCLC4_DT VDD pch
+ l=0.06U
+ w=0.41U
M2422 BL_0 XCLC4_RBS_0 XCLC4_DT VDD pch
+ l=0.06U
+ w=0.41U
M2423 BLB_0 XCLC4_RBS_0 XCLC4_DC VDD pch
+ l=0.06U
+	 w=0.41U
M2424 BLB_0 XCLC4_RBS_0 XCLC4_DC VDD pch
+ l=0.06U
+ w=0.41U
M2425 XCLC4_XND0_0_NET9 XCLC4_RDLB
+ XCLC4_RBS_0 VSS nch_hvt l=0.06U
+ w=0.41U
M2426 VSS XCLC4_YSELT_0 XCLC4_XND0_0_NET9
+ VSS nch_hvt l=0.06U
+	 w=0.41U
M2427 XCLC4_YSELB_0 YSEL_0 VSS VSS nch_hvt
+ l=0.06U
+ w=0.5U
M2428 BL_1 XCLC4_WBS_1 XCLC4_WT VSS nch
+ l=0.06U
+ w=0.54U
M2429 BLB_1 XCLC4_WBS_1 XCLC4_WC VSS nch
+ l=0.06U
+	 w=0.54U
M2430 VDD XCLC4_RDLB XCLC4_RBS_1 VDD
+ pch_hvt l=0.06U
+	 w=0.41U
M2431 BL_1 XCLC4_YSELT_1 VDD VDD pch
+ l=0.06U
+ w=0.59U
M2432 BL_1 XCLC4_YSELT_1 VDD VDD pch
+ l=0.06U
+ w=0.41U
M2433 BL_1 XCLC4_WBS_1 XCLC4_WT VSS nch
+ l=0.06U
+ w=0.54U
M2434 BLB_1 XCLC4_WBS_1 XCLC4_WC VSS nch
+ l=0.06U
+	 w=0.54U
M2435 VDD XCLC4_YSELT_1 XCLC4_RBS_1 VDD
+ pch_hvt l=0.06U
+	 w=0.41U
M2436 BL_1 XCLC4_YSELT_1 VDD VDD pch
+ l=0.06U
+ w=0.59U
M2437 BL_1 BLB_1 VDD VDD pch
+ l=0.06U
+ w=0.41U
M2438 BL_1 XCLC4_WBS_1 XCLC4_WT VSS nch
+ l=0.06U
+ w=0.54U
M2439 BLB_1 XCLC4_WBS_1 XCLC4_WC VSS nch
+ l=0.06U
+	 w=0.54U
M2440 VDD YSEL_1 XCLC4_YSELB_1 VDD pch_hvt
+ l=0.06U
+ w=0.5U
M2441 BL_1 XCLC4_YSELT_1 VDD VDD pch
+ l=0.06U
+ w=1.44U
M2442 BL_1 XCLC4_YSELT_1 BLB_1 VDD pch
+ l=0.06U
+ w=1.8U
M2443 VDD XCLC4_YSELB_1 XCLC4_YSELT_1 VDD
+ pch_hvt l=0.06U
+	 w=0.465U
M2444 VDD XCLC4_YSELT_1 BLB_1 VDD pch
+ l=0.06U
+ w=1.44U
M2445 XCLC4_WBS_1 XCLC4_YSELB_1
+ XCLC4_XNR0_1_NET3 VDD pch l=0.06U
+ w=0.7U
M2446 XCLC4_WBS_1 XCLC4_YSELB_1 VSS VSS
+ nch l=0.06U
+ w=0.35U
M2447 VDD XCLC4_YSELB_1 XCLC4_YSELT_1 VDD
+ pch_hvt l=0.06U
+	 w=0.465U
M2448 VDD XCLC4_YSELT_1 BLB_1 VDD pch
+ l=0.06U
+ w=0.59U
M2449 VDD BL_1 BLB_1 VDD pch
+ l=0.06U
+ w=0.41U
M2450 XCLC4_XNR0_1_NET3 XCLC4_WRTLB VDD
+ VDD pch l=0.06U
+	 w=0.7U
M2451 XCLC4_WBS_1 XCLC4_WRTLB VSS VSS
+ nch l=0.06U
+ w=0.35U
M2452 XCLC4_YSELT_1 XCLC4_YSELB_1 VSS VSS
+ nch_hvt l=0.06U
+ w=0.41U
M2453 VDD XCLC4_YSELB_1 XCLC4_YSELT_1 VDD
+ pch_hvt l=0.06U
+	 w=0.465U
M2454 VDD XCLC4_YSELT_1 BLB_1 VDD pch
+ l=0.06U
+ w=0.59U
M2455 VDD XCLC4_YSELT_1 BLB_1 VDD pch
+ l=0.06U
+ w=0.41U
M2456 XCLC4_XNR0_2_NET3 XCLC4_WRTLB VDD
+ VDD pch l=0.06U
+	 w=0.7U
M2457 BL_1 XCLC4_RBS_1 XCLC4_DT VDD pch
+ l=0.06U
+ w=0.41U
M2458 BL_1 XCLC4_RBS_1 XCLC4_DT VDD pch
+ l=0.06U
+ w=0.41U
M2459 BLB_1 XCLC4_RBS_1 XCLC4_DC VDD pch
+ l=0.06U
+	 w=0.41U
M2460 BLB_1 XCLC4_RBS_1 XCLC4_DC VDD pch
+ l=0.06U
+ w=0.41U
M2461 XCLC4_XND0_1_NET9 XCLC4_RDLB
+ XCLC4_RBS_1 VSS nch_hvt l=0.06U
+ w=0.41U
M2462 VSS XCLC4_YSELT_1 XCLC4_XND0_1_NET9
+ VSS nch_hvt l=0.06U
+	 w=0.41U
M2463 XCLC4_YSELB_1 YSEL_1 VSS VSS nch_hvt
+ l=0.06U
+ w=0.5U
M2464 XCLC4_WBS_2 XCLC4_WRTLB VSS VSS
+ nch l=0.06U
+ w=0.35U
M2465 VDD XCLC4_YSELB_2 XCLC4_YSELT_2 VDD
+ pch_hvt l=0.06U
+	 w=0.465U
M2466 VDD XCLC4_YSELT_2 BLB_2 VDD pch
+ l=0.06U
+ w=0.59U
M2467 VDD XCLC4_YSELT_2 BLB_2 VDD pch
+ l=0.06U
+ w=0.41U
M2468 XCLC4_YSELT_2 XCLC4_YSELB_2 VSS VSS
+ nch_hvt l=0.06U
+ w=0.41U
M2469 XCLC4_WBS_2 XCLC4_YSELB_2
+ XCLC4_XNR0_2_NET3 VDD pch l=0.06U
+ w=0.7U
M2470 VDD XCLC4_YSELB_2 XCLC4_YSELT_2 VDD
+ pch_hvt l=0.06U
+	 w=0.465U
M2471 VDD XCLC4_YSELT_2 BLB_2 VDD pch
+ l=0.06U
+ w=0.59U
M2472 VDD BL_2 BLB_2 VDD pch
+ l=0.06U
+ w=0.41U
M2473 XCLC4_WBS_2 XCLC4_YSELB_2 VSS VSS
+ nch l=0.06U
+ w=0.35U
M2474 VDD XCLC4_YSELB_2 XCLC4_YSELT_2 VDD
+ pch_hvt l=0.06U
+	 w=0.465U
M2475 VDD XCLC4_YSELT_2 BLB_2 VDD pch
+ l=0.06U
+ w=1.44U
M2476 BL_2 XCLC4_YSELT_2 BLB_2 VDD pch
+ l=0.06U
+ w=1.8U
M2477 BL_2 XCLC4_WBS_2 XCLC4_WT VSS nch
+ l=0.06U
+ w=0.54U
M2478 BLB_2 XCLC4_WBS_2 XCLC4_WC VSS nch
+ l=0.06U
+	 w=0.54U
M2479 VDD YSEL_2 XCLC4_YSELB_2 VDD pch_hvt
+ l=0.06U
+ w=0.5U
M2480 BL_2 XCLC4_YSELT_2 VDD VDD pch
+ l=0.06U
+ w=1.44U
M2481 BL_2 XCLC4_WBS_2 XCLC4_WT VSS nch
+ l=0.06U
+ w=0.54U
M2482 BLB_2 XCLC4_WBS_2 XCLC4_WC VSS nch
+ l=0.06U
+	 w=0.54U
M2483 VDD XCLC4_YSELT_2 XCLC4_RBS_2 VDD
+ pch_hvt l=0.06U
+	 w=0.41U
M2484 BL_2 XCLC4_YSELT_2 VDD VDD pch
+ l=0.06U
+ w=0.59U
M2485 BL_2 BLB_2 VDD VDD pch
+ l=0.06U
+ w=0.41U
M2486 BL_2 XCLC4_WBS_2 XCLC4_WT VSS nch
+ l=0.06U
+ w=0.54U
M2487 BLB_2 XCLC4_WBS_2 XCLC4_WC VSS nch
+ l=0.06U
+	 w=0.54U
M2488 VDD XCLC4_RDLB XCLC4_RBS_2 VDD
+ pch_hvt l=0.06U
+	 w=0.41U
M2489 BL_2 XCLC4_YSELT_2 VDD VDD pch
+ l=0.06U
+ w=0.59U
M2490 BL_2 XCLC4_YSELT_2 VDD VDD pch
+ l=0.06U
+ w=0.41U
M2491 BL_2 XCLC4_RBS_2 XCLC4_DT VDD pch
+ l=0.06U
+ w=0.41U
M2492 BL_2 XCLC4_RBS_2 XCLC4_DT VDD pch
+ l=0.06U
+ w=0.41U
M2493 BLB_2 XCLC4_RBS_2 XCLC4_DC VDD pch
+ l=0.06U
+	 w=0.41U
M2494 BLB_2 XCLC4_RBS_2 XCLC4_DC VDD pch
+ l=0.06U
+ w=0.41U
M2495 XCLC4_XND0_2_NET9 XCLC4_RDLB
+ XCLC4_RBS_2 VSS nch_hvt l=0.06U
+ w=0.41U
M2496 VSS XCLC4_YSELT_2 XCLC4_XND0_2_NET9
+ VSS nch_hvt l=0.06U
+	 w=0.41U
M2497 XCLC4_YSELB_2 YSEL_2 VSS VSS nch_hvt
+ l=0.06U
+ w=0.5U
M2498 BL_3 XCLC4_WBS_3 XCLC4_WT VSS nch
+ l=0.06U
+ w=0.54U
M2499 BLB_3 XCLC4_WBS_3 XCLC4_WC VSS nch
+ l=0.06U
+	 w=0.54U
M2500 VDD XCLC4_RDLB XCLC4_RBS_3 VDD
+ pch_hvt l=0.06U
+	 w=0.41U
M2501 BL_3 XCLC4_YSELT_3 VDD VDD pch
+ l=0.06U
+ w=0.59U
M2502 BL_3 XCLC4_YSELT_3 VDD VDD pch
+ l=0.06U
+ w=0.41U
M2503 BL_3 XCLC4_WBS_3 XCLC4_WT VSS nch
+ l=0.06U
+ w=0.54U
M2504 BLB_3 XCLC4_WBS_3 XCLC4_WC VSS nch
+ l=0.06U
+	 w=0.54U
M2505 VDD XCLC4_YSELT_3 XCLC4_RBS_3 VDD
+ pch_hvt l=0.06U
+	 w=0.41U
M2506 BL_3 XCLC4_YSELT_3 VDD VDD pch
+ l=0.06U
+ w=0.59U
M2507 BL_3 BLB_3 VDD VDD pch
+ l=0.06U
+ w=0.41U
M2508 BL_3 XCLC4_WBS_3 XCLC4_WT VSS nch
+ l=0.06U
+ w=0.54U
M2509 BLB_3 XCLC4_WBS_3 XCLC4_WC VSS nch
+ l=0.06U
+	 w=0.54U
M2510 VDD YSEL_3 XCLC4_YSELB_3 VDD pch_hvt
+ l=0.06U
+ w=0.5U
M2511 BL_3 XCLC4_YSELT_3 VDD VDD pch
+ l=0.06U
+ w=1.44U
M2512 BL_3 XCLC4_YSELT_3 BLB_3 VDD pch
+ l=0.06U
+ w=1.8U
M2513 VDD XCLC4_YSELB_3 XCLC4_YSELT_3 VDD
+ pch_hvt l=0.06U
+	 w=0.465U
M2514 VDD XCLC4_YSELT_3 BLB_3 VDD pch
+ l=0.06U
+ w=1.44U
M2515 XCLC4_WBS_3 XCLC4_YSELB_3
+ XCLC4_XNR0_3_NET3 VDD pch l=0.06U
+ w=0.7U
M2516 XCLC4_WBS_3 XCLC4_YSELB_3 VSS VSS
+ nch l=0.06U
+ w=0.35U
M2517 VDD XCLC4_YSELB_3 XCLC4_YSELT_3 VDD
+ pch_hvt l=0.06U
+ w=0.465U
M2518 VDD XCLC4_YSELT_3 BLB_3 VDD pch
+ l=0.06U
+ w=0.59U
M2519 VDD BL_3 BLB_3 VDD pch
+ l=0.06U
+ w=0.41U
M2520 XCLC4_XNR0_3_NET3 XCLC4_WRTLB VDD
+ VDD pch l=0.06U
+ w=0.7U
M2521 XCLC4_WBS_3 XCLC4_WRTLB VSS VSS
+ nch l=0.06U
+ w=0.35U
M2522 XCLC4_YSELT_3 XCLC4_YSELB_3 VSS VSS
+ nch_hvt l=0.06U
+ w=0.41U
M2523 VDD XCLC4_YSELB_3 XCLC4_YSELT_3 VDD
+ pch_hvt l=0.06U
+ w=0.465U
M2524 VDD XCLC4_YSELT_3 BLB_3 VDD pch
+ l=0.06U
+ w=0.59U
M2525 VDD XCLC4_YSELT_3 BLB_3 VDD pch
+ l=0.06U
+ w=0.41U
M2526 VDD XCLC4_DT XCLC4_DTB VDD pch
+ l=0.06U
+ w=0.7U
M2527 VDD XCLC4_DT XCLC4_DTB VDD
+ pch l=0.06U
+ w=0.7U
M2528 XCLC4_DT XCLC4_DC VDD VDD pch
+ l=0.12U
+ w=0.41U
M2529 XCLC4_DT XCLC4_DC VDD VDD pch
+ l=0.12U
+ w=0.41U
M2530 VDD XCLC4_SMPRST XCLC4_DT VDD pch
+ l=0.06U
+ w=0.57U
M2531 VDD XCLC4_SMPRST XCLC4_DT VDD pch
+ l=0.06U
+ w=0.57U
M2532 VDD XCLC4_SMPRST XCLC4_DT VDD pch
+ l=0.06U
+ w=0.41U
M2533 VDD XCLC4_DT XCLC4_DC VDD pch
+ l=0.12U
+ w=0.41U
M2534 VDD XCLC4_DT XCLC4_DC VDD pch
+ l=0.12U
+ w=0.41U
M2535 XCLC4_DT XCLC4_SMPRST XCLC4_DC VDD
+ pch l=0.06U
+ w=0.41U
M2536 XCLC4_DC XCLC4_SMPRST VDD VDD pch
+ l=0.06U
+ w=0.57U
M2537 XCLC4_DC XCLC4_SMPRST VDD VDD pch
+ l=0.06U
+ w=0.41U
M2538 XCLC4_DC XCLC4_SMPRST VDD VDD pch
+ l=0.06U
+ w=0.57U
M2539 VDD XCLC4_DC XCLC4_DCB VDD pch
+ l=0.06U
+ w=0.7U
M2540 VDD XCLC4_DC XCLC4_DCB VDD
+ pch l=0.06U
+ w=0.7U
M2541 VDD B_GWDC XCLC4_WC VDD pch
+ l=0.06U
+ w=0.41U
M2542 VDD WRTL XCLC4_WRTLB VDD pch
+ l=0.06U
+ w=0.7U
M2543 VDD B_GWDT XCLC4_WT VDD pch
+ l=0.06U
+ w=0.41U
M2544 VDD RDL XCLC4_RDLB VDD pch
+ l=0.06U
+ w=0.7U
M2545 VDD SMPRSX XCLC4_XNRS_NET3 VDD pch
+ l=0.06U
+ w=0.7U
M2546 VDD SMPRSX XCLC4_SMPRST VDD pch
+ l=0.06U
+ w=0.41U
M2547 VDD SMPRSX XCLC4_SMPRST VDD pch
+ l=0.06U
+ w=0.41U
M2548 XCLC4_XNRS_NET3 SOE XCLC4_SET VDD pch
+ l=0.06U
+ w=0.7U
M2549 XCLC4_SMPRST SMPRSX VSS VSS nch
+ l=0.06U
+ w=0.41U
M2550 XCLC4_SET SMPRSX VSS VSS nch
+ l=0.06U
+ w=0.41U
M2551 XCLC4_SET SOE VSS VSS nch
+ l=0.06U
+ w=0.41U
M2552 XCLC4_WC B_GWDC VSS VSS nch
+ l=0.07U
+ w=1U
M2553 XCLC4_WC B_GWDC VSS VSS nch
+ l=0.07U
+ w=1U
M2554 XCLC4_WRTLB WRTL VSS VSS nch
+ l=0.06U
+ w=0.45U
M2555 XCLC4_DTB XCLC4_DT VSS VSS nch
+ l=0.06U
+ w=0.41U
M2556 XCLC4_NET18 XCLC4_DC XCLC4_DT VSS
+ nch l=0.12U
+ w=0.7U
M2557 XCLC4_NET18 XCLC4_DC XCLC4_DT VSS
+ nch l=0.12U
+ w=0.7U
M2558 B_GRDT XCLC4_DTB VSS VSS nch
+ l=0.06U
+ w=0.8U
M2559 B_GRDT XCLC4_DTB VSS VSS nch
+ l=0.06U
+ w=0.8U
M2560 B_GRDT XCLC4_DTB VSS VSS nch
+ l=0.06U
+ w=0.8U
M2561 B_GRDT XCLC4_DTB VSS VSS nch
+ l=0.06U
+ w=0.8U
M2562 XCLC4_NET18 XCLC4_SET VSS VSS nch
+ l=0.08U
+ w=0.7U
M2563 VSS XCLC4_DCB B_GRDC VSS nch
+ l=0.06U
+ w=0.8U
M2564 VSS XCLC4_DCB B_GRDC VSS nch
+ l=0.06U
+ w=0.8U
M2565 VSS XCLC4_DCB B_GRDC VSS nch
+ l=0.06U
+ w=0.8U
M2566 VSS XCLC4_DCB B_GRDC VSS nch
+ l=0.06U
+ w=0.8U
M2567 XCLC4_DC XCLC4_DT XCLC4_NET18 VSS
+ nch l=0.12U
+ w=0.7U
M2568 XCLC4_DC XCLC4_DT XCLC4_NET18 VSS
+ nch l=0.12U
+ w=0.7U
M2569 XCLC4_NET18 XCLC4_SET VSS VSS nch
+ l=0.08U
+ w=0.7U
M2570 XCLC4_DCB XCLC4_DC VSS VSS nch
+ l=0.06U
+ w=0.41U
M2571 XCLC4_WT B_GWDT VSS VSS nch
+ l=0.07U
+ w=1U
M2572 XCLC4_WT B_GWDT VSS VSS nch
+ l=0.07U
+ w=1U
M2573 XCLC4_RDLB RDL VSS VSS nch
+ l=0.06U
+ w=0.45U
M2574 BL_3 XCLC4_RBS_3 XCLC4_DT VDD pch
+ l=0.06U
+ w=0.41U
M2575 BL_3 XCLC4_RBS_3 XCLC4_DT VDD pch
+ l=0.06U
+ w=0.41U
M2576 BLB_3 XCLC4_RBS_3 XCLC4_DC VDD pch
+ l=0.06U
+	 w=0.41U
M2577 BLB_3 XCLC4_RBS_3 XCLC4_DC VDD pch
+ l=0.06U
+ w=0.41U
M2578 XCLC4_XND0_3_NET9 XCLC4_RDLB
+ XCLC4_RBS_3 VSS nch_hvt l=0.06U
+ w=0.41U
M2579 VSS XCLC4_YSELT_3 XCLC4_XND0_3_NET9
+ VSS nch_hvt l=0.06U
+	 w=0.41U
M2580 XCLC4_YSELB_3 YSEL_3 VSS VSS nch_hvt
+ l=0.06U
+ w=0.5U
.ENDS
* CLC8A
.SUBCKT SDL400W20S_CLC8A A_GWDC A_GWDT B_GWDC B_GWDT RDL SMPRS_3 SMPRS_2
+	 SMPRS_1 SMPRS_0 SMPRSX SOE WRTL YSEL_7 YSEL_6 YSEL_5 YSEL_4
+	 YSEL_3 YSEL_2 YSEL_1 YSEL_0 A_GRDC A_GRDT BL_7 BL_6 BL_5 BL_4
+	 BL_3 BL_2 BL_1 BL_0 BLB_7 BLB_6 BLB_5 BLB_4 BLB_3 BLB_2 BLB_1
+	 BLB_0 B_GRDC B_GRDT
M2581 XCLC8_XNR0_0_NET3 XCLC8_WRTLB VDD
+ VDD pch l=0.06U
+ w=0.7U
M2582 XCLC8_WBS_0 XCLC8_WRTLB VSS VSS
+ nch l=0.06U
+ w=0.35U
M2583 VDD XCLC8_YSELB_0 XCLC8_YSELT_0 VDD
+ pch_hvt l=0.06U
+ w=0.465U
M2584 BL_0 XCLC8_YSELT_0 VDD VDD pch
+ l=0.06U
+ w=0.59U
M2585 BL_0 XCLC8_YSELT_0 VDD VDD pch
+ l=0.06U
+ w=0.41U
M2586 XCLC8_YSELT_0 XCLC8_YSELB_0 VSS VSS
+ nch_hvt l=0.06U
+ w=0.41U
M2587 XCLC8_WBS_0 XCLC8_YSELB_0
+ XCLC8_XNR0_0_NET3 VDD pch l=0.06U
+ w=0.7U
M2588 VDD XCLC8_YSELB_0 XCLC8_YSELT_0 VDD
+ pch_hvt l=0.06U
+ w=0.465U
M2589 BL_0 XCLC8_YSELT_0 VDD VDD pch
+ l=0.06U
+ w=0.59U
M2590 BL_0 BLB_0 VDD VDD pch
+ l=0.06U
+ w=0.41U
M2591 XCLC8_WBS_0 XCLC8_YSELB_0 VSS VSS
+ nch l=0.06U
+ w=0.35U
M2592 VDD XCLC8_YSELB_0 XCLC8_YSELT_0 VDD
+ pch_hvt l=0.06U
+	 w=0.465U
M2593 BL_0 XCLC8_YSELT_0 VDD VDD pch
+ l=0.06U
+ w=1.44U
M2594 BL_0 XCLC8_YSELT_0 BLB_0 VDD pch
+ l=0.06U
+ w=1.8U
M2595 BLB_0 XCLC8_WBS_0 XCLC8_WC VSS nch
+ l=0.06U
+ w=0.54U
M2596 BL_0 XCLC8_WBS_0 XCLC8_WT VSS nch
+ l=0.06U
+	 w=0.54U
M2597 VDD YSEL_0 XCLC8_YSELB_0 VDD pch_hvt
+ l=0.06U
+ w=0.5U
M2598 VDD XCLC8_YSELT_0 BLB_0 VDD pch
+ l=0.06U
+ w=1.44U
M2599 BLB_0 XCLC8_WBS_0 XCLC8_WC VSS nch
+ l=0.06U
+ w=0.54U
M2600 BL_0 XCLC8_WBS_0 XCLC8_WT VSS nch
+ l=0.06U
+	 w=0.54U
M2601 VDD XCLC8_YSELT_0 XCLC8_RBS_0 VDD
+ pch_hvt l=0.06U
+	 w=0.41U
M2602 VDD XCLC8_YSELT_0 BLB_0 VDD pch
+ l=0.06U
+ w=0.59U
M2603 VDD BL_0 BLB_0 VDD pch
+ l=0.06U
+ w=0.41U
M2604 BLB_0 XCLC8_WBS_0 XCLC8_WC VSS nch
+ l=0.06U
+ w=0.54U
M2605 BL_0 XCLC8_WBS_0 XCLC8_WT VSS nch
+ l=0.06U
+	 w=0.54U
M2606 VDD XCLC8_RDLB XCLC8_RBS_0 VDD
+ pch_hvt l=0.06U
+	 w=0.41U
M2607 VDD XCLC8_YSELT_0 BLB_0 VDD pch
+ l=0.06U
+ w=0.59U
M2608 VDD XCLC8_YSELT_0 BLB_0 VDD pch
+ l=0.06U
+ w=0.41U
M2609 BLB_0 XCLC8_RBS_0 XCLC8_DC VDD pch
+ l=0.06U
+ w=0.41U
M2610 BLB_0 XCLC8_RBS_0 XCLC8_DC VDD pch
+ l=0.06U
+ w=0.41U
M2611 BL_0 XCLC8_RBS_0 XCLC8_DT VDD pch
+ l=0.06U
+	 w=0.41U
M2612 BL_0 XCLC8_RBS_0 XCLC8_DT VDD pch
+ l=0.06U
+ w=0.41U
M2613 XCLC8_XND0_0_NET9 XCLC8_RDLB
+ XCLC8_RBS_0 VSS nch_hvt l=0.06U
+ w=0.41U
M2614 VSS XCLC8_YSELT_0 XCLC8_XND0_0_NET9
+ VSS nch_hvt l=0.06U
+	 w=0.41U
M2615 XCLC8_YSELB_0 YSEL_0 VSS VSS nch_hvt
+ l=0.06U
+ w=0.5U
M2616 BLB_1 XCLC8_WBS_1 XCLC8_WC VSS nch
+ l=0.06U
+ w=0.54U
M2617 BL_1 XCLC8_WBS_1 XCLC8_WT VSS nch
+ l=0.06U
+	 w=0.54U
M2618 VDD XCLC8_RDLB XCLC8_RBS_1 VDD
+ pch_hvt l=0.06U
+	 w=0.41U
M2619 VDD XCLC8_YSELT_1 BLB_1 VDD pch
+ l=0.06U
+ w=0.59U
M2620 VDD XCLC8_YSELT_1 BLB_1 VDD pch
+ l=0.06U
+ w=0.41U
M2621 BLB_1 XCLC8_WBS_1 XCLC8_WC VSS nch
+ l=0.06U
+ w=0.54U
M2622 BL_1 XCLC8_WBS_1 XCLC8_WT VSS nch
+ l=0.06U
+	 w=0.54U
M2623 VDD XCLC8_YSELT_1 XCLC8_RBS_1 VDD
+ pch_hvt l=0.06U
+	 w=0.41U
M2624 VDD XCLC8_YSELT_1 BLB_1 VDD pch
+ l=0.06U
+ w=0.59U
M2625 VDD BL_1 BLB_1 VDD pch
+ l=0.06U
+ w=0.41U
M2626 BLB_1 XCLC8_WBS_1 XCLC8_WC VSS nch
+ l=0.06U
+ w=0.54U
M2627 BL_1 XCLC8_WBS_1 XCLC8_WT VSS nch
+ l=0.06U
+	 w=0.54U
M2628 VDD YSEL_1 XCLC8_YSELB_1 VDD pch_hvt
+ l=0.06U
+ w=0.5U
M2629 VDD XCLC8_YSELT_1 BLB_1 VDD pch
+ l=0.06U
+ w=1.44U
M2630 BL_1 XCLC8_YSELT_1 BLB_1 VDD pch
+ l=0.06U
+ w=1.8U
M2631 VDD XCLC8_YSELB_1 XCLC8_YSELT_1 VDD
+ pch_hvt l=0.06U
+	 w=0.465U
M2632 BL_1 XCLC8_YSELT_1 VDD VDD pch
+ l=0.06U
+ w=1.44U
M2633 XCLC8_WBS_1 XCLC8_YSELB_1
+ XCLC8_XNR0_1_NET3 VDD pch l=0.06U
+ w=0.7U
M2634 XCLC8_WBS_1 XCLC8_YSELB_1 VSS VSS
+ nch l=0.06U
+ w=0.35U
M2635 VDD XCLC8_YSELB_1 XCLC8_YSELT_1 VDD
+ pch_hvt l=0.06U
+	 w=0.465U
M2636 BL_1 XCLC8_YSELT_1 VDD VDD pch
+ l=0.06U
+ w=0.59U
M2637 BL_1 BLB_1 VDD VDD pch
+ l=0.06U
+ w=0.41U
M2638 XCLC8_XNR0_1_NET3 XCLC8_WRTLB VDD
+ VDD pch l=0.06U
+	 w=0.7U
M2639 XCLC8_WBS_1 XCLC8_WRTLB VSS VSS
+ nch l=0.06U
+ w=0.35U
M2640 XCLC8_YSELT_1 XCLC8_YSELB_1 VSS VSS
+ nch_hvt l=0.06U
+ w=0.41U
M2641 VDD XCLC8_YSELB_1 XCLC8_YSELT_1 VDD
+ pch_hvt l=0.06U
+	 w=0.465U
M2642 BL_1 XCLC8_YSELT_1 VDD VDD pch
+ l=0.06U
+ w=0.59U
M2643 BL_1 XCLC8_YSELT_1 VDD VDD pch
+ l=0.06U
+ w=0.41U
M2644 XCLC8_XNR0_2_NET3 XCLC8_WRTLB VDD
+ VDD pch l=0.06U
+	 w=0.7U
M2645 BLB_1 XCLC8_RBS_1 XCLC8_DC VDD pch
+ l=0.06U
+ w=0.41U
M2646 BLB_1 XCLC8_RBS_1 XCLC8_DC VDD pch
+ l=0.06U
+ w=0.41U
M2647 BL_1 XCLC8_RBS_1 XCLC8_DT VDD pch
+ l=0.06U
+	 w=0.41U
M2648 BL_1 XCLC8_RBS_1 XCLC8_DT VDD pch
+ l=0.06U
+ w=0.41U
M2649 XCLC8_XND0_1_NET9 XCLC8_RDLB
+ XCLC8_RBS_1 VSS nch_hvt l=0.06U
+ w=0.41U
M2650 VSS XCLC8_YSELT_1 XCLC8_XND0_1_NET9
+ VSS nch_hvt l=0.06U
+	 w=0.41U
M2651 XCLC8_YSELB_1 YSEL_1 VSS VSS nch_hvt
+ l=0.06U
+ w=0.5U
M2652 XCLC8_WBS_2 XCLC8_WRTLB VSS VSS
+ nch l=0.06U
+ w=0.35U
M2653 VDD XCLC8_YSELB_2 XCLC8_YSELT_2 VDD
+ pch_hvt l=0.06U
+	 w=0.465U
M2654 BL_2 XCLC8_YSELT_2 VDD VDD pch
+ l=0.06U
+ w=0.59U
M2655 BL_2 XCLC8_YSELT_2 VDD VDD pch
+ l=0.06U
+ w=0.41U
M2656 XCLC8_YSELT_2 XCLC8_YSELB_2 VSS VSS
+ nch_hvt l=0.06U
+	 w=0.41U
M2657 XCLC8_WBS_2 XCLC8_YSELB_2
+ XCLC8_XNR0_2_NET3 VDD pch l=0.06U
+ w=0.7U
M2658 VDD XCLC8_YSELB_2 XCLC8_YSELT_2 VDD
+ pch_hvt l=0.06U
+	 w=0.465U
M2659 BL_2 XCLC8_YSELT_2 VDD VDD pch
+ l=0.06U
+ w=0.59U
M2660 BL_2 BLB_2 VDD VDD pch
+ l=0.06U
+ w=0.41U
M2661 XCLC8_WBS_2 XCLC8_YSELB_2 VSS VSS
+ nch l=0.06U
+ w=0.35U
M2662 VDD XCLC8_YSELB_2 XCLC8_YSELT_2 VDD
+ pch_hvt l=0.06U
+	 w=0.465U
M2663 BL_2 XCLC8_YSELT_2 VDD VDD pch
+ l=0.06U
+ w=1.44U
M2664 BL_2 XCLC8_YSELT_2 BLB_2 VDD pch
+ l=0.06U
+ w=1.8U
M2665 BLB_2 XCLC8_WBS_2 XCLC8_WC VSS nch
+ l=0.06U
+ w=0.54U
M2666 BL_2 XCLC8_WBS_2 XCLC8_WT VSS nch
+ l=0.06U
+	 w=0.54U
M2667 VDD YSEL_2 XCLC8_YSELB_2 VDD pch_hvt
+ l=0.06U
+ w=0.5U
M2668 VDD XCLC8_YSELT_2 BLB_2 VDD pch
+ l=0.06U
+ w=1.44U
M2669 BLB_2 XCLC8_WBS_2 XCLC8_WC VSS nch
+ l=0.06U
+ w=0.54U
M2670 BL_2 XCLC8_WBS_2 XCLC8_WT VSS nch
+ l=0.06U
+	 w=0.54U
M2671 VDD XCLC8_YSELT_2 XCLC8_RBS_2 VDD
+ pch_hvt l=0.06U
+	 w=0.41U
M2672 VDD XCLC8_YSELT_2 BLB_2 VDD pch
+ l=0.06U
+ w=0.59U
M2673 VDD BL_2 BLB_2 VDD pch
+ l=0.06U
+ w=0.41U
M2674 BLB_2 XCLC8_WBS_2 XCLC8_WC VSS nch
+ l=0.06U
+ w=0.54U
M2675 BL_2 XCLC8_WBS_2 XCLC8_WT VSS nch
+ l=0.06U
+	 w=0.54U
M2676 VDD XCLC8_RDLB XCLC8_RBS_2 VDD
+ pch_hvt l=0.06U
+	 w=0.41U
M2677 VDD XCLC8_YSELT_2 BLB_2 VDD pch
+ l=0.06U
+ w=0.59U
M2678 VDD XCLC8_YSELT_2 BLB_2 VDD pch
+ l=0.06U
+ w=0.41U
M2679 BLB_2 XCLC8_RBS_2 XCLC8_DC VDD pch
+ l=0.06U
+ w=0.41U
M2680 BLB_2 XCLC8_RBS_2 XCLC8_DC VDD pch
+ l=0.06U
+ w=0.41U
M2681 BL_2 XCLC8_RBS_2 XCLC8_DT VDD pch
+ l=0.06U
+	 w=0.41U
M2682 BL_2 XCLC8_RBS_2 XCLC8_DT VDD pch
+ l=0.06U
+ w=0.41U
M2683 XCLC8_XND0_2_NET9 XCLC8_RDLB
+ XCLC8_RBS_2 VSS nch_hvt l=0.06U
+ w=0.41U
M2684 VSS XCLC8_YSELT_2 XCLC8_XND0_2_NET9
+ VSS nch_hvt l=0.06U
+	 w=0.41U
M2685 XCLC8_YSELB_2 YSEL_2 VSS VSS nch_hvt
+ l=0.06U
+ w=0.5U
M2686 BLB_3 XCLC8_WBS_3 XCLC8_WC VSS nch
+ l=0.06U
+ w=0.54U
M2687 BL_3 XCLC8_WBS_3 XCLC8_WT VSS nch
+ l=0.06U
+	 w=0.54U
M2688 VDD XCLC8_RDLB XCLC8_RBS_3 VDD
+ pch_hvt l=0.06U
+	 w=0.41U
M2689 VDD XCLC8_YSELT_3 BLB_3 VDD pch
+ l=0.06U
+ w=0.59U
M2690 VDD XCLC8_YSELT_3 BLB_3 VDD pch
+ l=0.06U
+ w=0.41U
M2691 BLB_3 XCLC8_WBS_3 XCLC8_WC VSS nch
+ l=0.06U
+ w=0.54U
M2692 BL_3 XCLC8_WBS_3 XCLC8_WT VSS nch
+ l=0.06U
+	 w=0.54U
M2693 VDD XCLC8_YSELT_3 XCLC8_RBS_3 VDD
+ pch_hvt l=0.06U
+	 w=0.41U
M2694 VDD XCLC8_YSELT_3 BLB_3 VDD pch
+ l=0.06U
+ w=0.59U
M2695 VDD BL_3 BLB_3 VDD pch
+ l=0.06U
+ w=0.41U
M2696 BLB_3 XCLC8_WBS_3 XCLC8_WC VSS nch
+ l=0.06U
+ w=0.54U
M2697 BL_3 XCLC8_WBS_3 XCLC8_WT VSS nch
+ l=0.06U
+	 w=0.54U
M2698 VDD YSEL_3 XCLC8_YSELB_3 VDD pch_hvt
+ l=0.06U
+ w=0.5U
M2699 VDD XCLC8_YSELT_3 BLB_3 VDD pch
+ l=0.06U
+ w=1.44U
M2700 BL_3 XCLC8_YSELT_3 BLB_3 VDD pch
+ l=0.06U
+ w=1.8U
M2701 VDD XCLC8_YSELB_3 XCLC8_YSELT_3 VDD
+ pch_hvt l=0.06U
+	 w=0.465U
M2702 BL_3 XCLC8_YSELT_3 VDD VDD pch
+ l=0.06U
+ w=1.44U
M2703 XCLC8_WBS_3 XCLC8_YSELB_3
+ XCLC8_XNR0_3_NET3 VDD pch l=0.06U
+ w=0.7U
M2704 XCLC8_WBS_3 XCLC8_YSELB_3 VSS VSS
+ nch l=0.06U
+ w=0.35U
M2705 VDD XCLC8_YSELB_3 XCLC8_YSELT_3 VDD
+ pch_hvt l=0.06U
+	 w=0.465U
M2706 BL_3 XCLC8_YSELT_3 VDD VDD pch
+ l=0.06U
+ w=0.59U
M2707 BL_3 BLB_3 VDD VDD pch
+ l=0.06U
+ w=0.41U
M2708 XCLC8_XNR0_3_NET3 XCLC8_WRTLB VDD
+ VDD pch l=0.06U
+	 w=0.7U
M2709 XCLC8_WBS_3 XCLC8_WRTLB VSS VSS
+ nch l=0.06U
+ w=0.35U
M2710 XCLC8_YSELT_3 XCLC8_YSELB_3 VSS VSS
+ nch_hvt l=0.06U
+ w=0.41U
M2711 VDD XCLC8_YSELB_3 XCLC8_YSELT_3 VDD
+ pch_hvt l=0.06U
+	 w=0.465U
M2712 BL_3 XCLC8_YSELT_3 VDD VDD pch
+ l=0.06U
+ w=0.59U
M2713 BL_3 XCLC8_YSELT_3 VDD VDD pch
+ l=0.06U
+ w=0.41U
M2714 XCLC8_XNR0_4_NET3 XCLC8_WRTLB VDD
+ VDD pch l=0.06U
+	 w=0.7U
M2715 BLB_3 XCLC8_RBS_3 XCLC8_DC VDD pch
+ l=0.06U
+ w=0.41U
M2716 BLB_3 XCLC8_RBS_3 XCLC8_DC VDD pch
+ l=0.06U
+ w=0.41U
M2717 BL_3 XCLC8_RBS_3 XCLC8_DT VDD pch
+ l=0.06U
+	 w=0.41U
M2718 BL_3 XCLC8_RBS_3 XCLC8_DT VDD pch
+ l=0.06U
+ w=0.41U
M2719 XCLC8_XND0_3_NET9 XCLC8_RDLB
+ XCLC8_RBS_3 VSS nch_hvt l=0.06U
+ w=0.41U
M2720 VSS XCLC8_YSELT_3 XCLC8_XND0_3_NET9
+ VSS nch_hvt l=0.06U
+	 w=0.41U
M2721 XCLC8_YSELB_3 YSEL_3 VSS VSS nch_hvt
+ l=0.06U
+ w=0.5U
M2722 XCLC8_WBS_4 XCLC8_WRTLB VSS VSS
+ nch l=0.06U
+ w=0.35U
M2723 VDD XCLC8_YSELB_4 XCLC8_YSELT_4 VDD
+ pch_hvt l=0.06U
+	 w=0.465U
M2724 BL_4 XCLC8_YSELT_4 VDD VDD pch
+ l=0.06U
+ w=0.59U
M2725 BL_4 XCLC8_YSELT_4 VDD VDD pch
+ l=0.06U
+ w=0.41U
M2726 XCLC8_YSELT_4 XCLC8_YSELB_4 VSS VSS
+ nch_hvt l=0.06U
+ w=0.41U
M2727 XCLC8_WBS_4 XCLC8_YSELB_4
+ XCLC8_XNR0_4_NET3 VDD pch l=0.06U
+ w=0.7U
M2728 VDD XCLC8_YSELB_4 XCLC8_YSELT_4 VDD
+ pch_hvt l=0.06U
+	 w=0.465U
M2729 BL_4 XCLC8_YSELT_4 VDD VDD pch
+ l=0.06U
+ w=0.59U
M2730 BL_4 BLB_4 VDD VDD pch
+ l=0.06U
+ w=0.41U
M2731 XCLC8_WBS_4 XCLC8_YSELB_4 VSS VSS
+ nch l=0.06U
+ w=0.35U
M2732 VDD XCLC8_YSELB_4 XCLC8_YSELT_4 VDD
+ pch_hvt l=0.06U
+	 w=0.465U
M2733 BL_4 XCLC8_YSELT_4 VDD VDD pch
+ l=0.06U
+ w=1.44U
M2734 BL_4 XCLC8_YSELT_4 BLB_4 VDD pch
+ l=0.06U
+ w=1.8U
M2735 BLB_4 XCLC8_WBS_4 XCLC8_WC VSS nch
+ l=0.06U
+ w=0.54U
M2736 BL_4 XCLC8_WBS_4 XCLC8_WT VSS nch
+ l=0.06U
+	 w=0.54U
M2737 VDD YSEL_4 XCLC8_YSELB_4 VDD pch_hvt
+ l=0.06U
+ w=0.5U
M2738 VDD XCLC8_YSELT_4 BLB_4 VDD pch
+ l=0.06U
+ w=1.44U
M2739 BLB_4 XCLC8_WBS_4 XCLC8_WC VSS nch
+ l=0.06U
+ w=0.54U
M2740 BL_4 XCLC8_WBS_4 XCLC8_WT VSS nch
+ l=0.06U
+	 w=0.54U
M2741 VDD XCLC8_YSELT_4 XCLC8_RBS_4 VDD
+ pch_hvt l=0.06U
+	 w=0.41U
M2742 VDD XCLC8_YSELT_4 BLB_4 VDD pch
+ l=0.06U
+ w=0.59U
M2743 VDD BL_4 BLB_4 VDD pch
+ l=0.06U
+ w=0.41U
M2744 BLB_4 XCLC8_WBS_4 XCLC8_WC VSS nch
+ l=0.06U
+ w=0.54U
M2745 BL_4 XCLC8_WBS_4 XCLC8_WT VSS nch
+ l=0.06U
+	 w=0.54U
M2746 VDD XCLC8_RDLB XCLC8_RBS_4 VDD
+ pch_hvt l=0.06U
+	 w=0.41U
M2747 VDD XCLC8_YSELT_4 BLB_4 VDD pch
+ l=0.06U
+ w=0.59U
M2748 VDD XCLC8_YSELT_4 BLB_4 VDD pch
+ l=0.06U
+ w=0.41U
M2749 BLB_4 XCLC8_RBS_4 XCLC8_DC VDD pch
+ l=0.06U
+ w=0.41U
M2750 BLB_4 XCLC8_RBS_4 XCLC8_DC VDD pch
+ l=0.06U
+ w=0.41U
M2751 BL_4 XCLC8_RBS_4 XCLC8_DT VDD pch
+ l=0.06U
+	 w=0.41U
M2752 BL_4 XCLC8_RBS_4 XCLC8_DT VDD pch
+ l=0.06U
+ w=0.41U
M2753 XCLC8_XND0_4_NET9 XCLC8_RDLB
+ XCLC8_RBS_4 VSS nch_hvt l=0.06U
+ w=0.41U
M2754 VSS XCLC8_YSELT_4 XCLC8_XND0_4_NET9
+ VSS nch_hvt l=0.06U
+	 w=0.41U
M2755 XCLC8_YSELB_4 YSEL_4 VSS VSS nch_hvt
+ l=0.06U
+ w=0.5U
M2756 BLB_5 XCLC8_WBS_5 XCLC8_WC VSS nch
+ l=0.06U
+ w=0.54U
M2757 BL_5 XCLC8_WBS_5 XCLC8_WT VSS nch
+ l=0.06U
+	 w=0.54U
M2758 VDD XCLC8_RDLB XCLC8_RBS_5 VDD
+ pch_hvt l=0.06U
+	 w=0.41U
M2759 VDD XCLC8_YSELT_5 BLB_5 VDD pch
+ l=0.06U
+ w=0.59U
M2760 VDD XCLC8_YSELT_5 BLB_5 VDD pch
+ l=0.06U
+ w=0.41U
M2761 BLB_5 XCLC8_WBS_5 XCLC8_WC VSS nch
+ l=0.06U
+ w=0.54U
M2762 BL_5 XCLC8_WBS_5 XCLC8_WT VSS nch
+ l=0.06U
+	 w=0.54U
M2763 VDD XCLC8_YSELT_5 XCLC8_RBS_5 VDD
+ pch_hvt l=0.06U
+	 w=0.41U
M2764 VDD XCLC8_YSELT_5 BLB_5 VDD pch
+ l=0.06U
+ w=0.59U
M2765 VDD BL_5 BLB_5 VDD pch
+ l=0.06U
+ w=0.41U
M2766 BLB_5 XCLC8_WBS_5 XCLC8_WC VSS nch
+ l=0.06U
+ w=0.54U
M2767 BL_5 XCLC8_WBS_5 XCLC8_WT VSS nch
+ l=0.06U
+	 w=0.54U
M2768 VDD YSEL_5 XCLC8_YSELB_5 VDD pch_hvt
+ l=0.06U
+ w=0.5U
M2769 VDD XCLC8_YSELT_5 BLB_5 VDD pch
+ l=0.06U
+ w=1.44U
M2770 BL_5 XCLC8_YSELT_5 BLB_5 VDD pch
+ l=0.06U
+ w=1.8U
M2771 VDD XCLC8_YSELB_5 XCLC8_YSELT_5 VDD
+ pch_hvt l=0.06U
+	 w=0.465U
M2772 BL_5 XCLC8_YSELT_5 VDD VDD pch
+ l=0.06U
+ w=1.44U
M2773 XCLC8_WBS_5 XCLC8_YSELB_5
+ XCLC8_XNR0_5_NET3 VDD pch l=0.06U
+ w=0.7U
M2774 XCLC8_WBS_5 XCLC8_YSELB_5 VSS VSS
+ nch l=0.06U
+ w=0.35U
M2775 VDD XCLC8_YSELB_5 XCLC8_YSELT_5 VDD
+ pch_hvt l=0.06U
+	 w=0.465U
M2776 BL_5 XCLC8_YSELT_5 VDD VDD pch
+ l=0.06U
+ w=0.59U
M2777 BL_5 BLB_5 VDD VDD pch
+ l=0.06U
+ w=0.41U
M2778 XCLC8_XNR0_5_NET3 XCLC8_WRTLB VDD
+ VDD pch l=0.06U
+	 w=0.7U
M2779 XCLC8_WBS_5 XCLC8_WRTLB VSS VSS
+ nch l=0.06U
+ w=0.35U
M2780 XCLC8_YSELT_5 XCLC8_YSELB_5 VSS VSS
+ nch_hvt l=0.06U
+	 w=0.41U
M2781 VDD XCLC8_YSELB_5 XCLC8_YSELT_5 VDD
+ pch_hvt l=0.06U
+	 w=0.465U
M2782 BL_5 XCLC8_YSELT_5 VDD VDD pch
+ l=0.06U
+ w=0.59U
M2783 BL_5 XCLC8_YSELT_5 VDD VDD pch
+ l=0.06U
+ w=0.41U
M2784 VDD A_GWDT XCLC8_WT VDD pch
+ l=0.06U
+ w=0.41U
M2785 VDD RDL XCLC8_RDLB VDD pch
+ l=0.06U
+ w=0.7U
M2786 VDD XCLC8_DT XCLC8_DTB VDD pch
+ l=0.06U
+ w=0.7U
M2787 VDD XCLC8_DT XCLC8_DTB VDD
+ pch l=0.06U
+ w=0.7U
M2788 VDD XCLC8_SMPRST XCLC8_DT VDD pch
+ l=0.06U
+ w=0.57U
M2789 VDD XCLC8_SMPRST XCLC8_DT VDD pch
+ l=0.06U
+ w=0.57U
M2790 VDD XCLC8_SMPRST XCLC8_DT VDD pch
+ l=0.06U
+ w=0.41U
M2791 XCLC8_DT XCLC8_DC VDD VDD pch
+ l=0.12U
+ w=0.41U
M2792 XCLC8_DT XCLC8_DC VDD VDD pch
+ l=0.12U
+ w=0.41U
M2793 VDD XCLC8_DT XCLC8_DC VDD pch
+ l=0.12U
+ w=0.41U
M2794 VDD XCLC8_DT XCLC8_DC VDD pch
+ l=0.12U
+ w=0.41U
M2795 XCLC8_DT XCLC8_SMPRST XCLC8_DC VDD
+ pch l=0.06U
+ w=0.41U
M2796 XCLC8_DC XCLC8_SMPRST VDD VDD pch
+ l=0.06U
+ w=0.41U
M2797 XCLC8_DC XCLC8_SMPRST VDD VDD pch
+ l=0.06U
+ w=0.57U
M2798 XCLC8_DC XCLC8_SMPRST VDD VDD pch
+ l=0.06U
+ w=0.57U
M2799 VDD XCLC8_DC XCLC8_DCB VDD pch
+ l=0.06U
+ w=0.7U
M2800 VDD XCLC8_DC XCLC8_DCB VDD
+ pch l=0.06U
+ w=0.7U
M2801 VDD A_GWDC XCLC8_WC VDD pch
+ l=0.06U
+ w=0.41U
M2802 VDD WRTL XCLC8_WRTLB VDD pch
+ l=0.06U
+ w=0.7U
M2803 VDD SMPRSX XCLC8_XNRS_NET3 VDD pch
+ l=0.06U
+ w=0.7U
M2804 VDD SMPRSX XCLC8_SMPRST VDD pch
+ l=0.06U
+ w=0.41U
M2805 VDD SMPRSX XCLC8_SMPRST VDD pch
+ l=0.06U
+ w=0.41U
M2806 XCLC8_XNRS_NET3 SOE XCLC8_SET VDD pch
+ l=0.06U
+ w=0.7U
M2807 XCLC8_XNR0_6_NET3 XCLC8_WRTLB VDD
+ VDD pch l=0.06U
+	 w=0.7U
M2808 BLB_5 XCLC8_RBS_5 XCLC8_DC VDD pch
+ l=0.06U
+ w=0.41U
M2809 BLB_5 XCLC8_RBS_5 XCLC8_DC VDD pch
+ l=0.06U
+ w=0.41U
M2810 BL_5 XCLC8_RBS_5 XCLC8_DT VDD pch
+ l=0.06U
+	 w=0.41U
M2811 BL_5 XCLC8_RBS_5 XCLC8_DT VDD pch
+ l=0.06U
+ w=0.41U
M2812 XCLC8_XND0_5_NET9 XCLC8_RDLB
+ XCLC8_RBS_5 VSS nch_hvt l=0.06U
+ w=0.41U
M2813 VSS XCLC8_YSELT_5 XCLC8_XND0_5_NET9
+ VSS nch_hvt l=0.06U
+	 w=0.41U
M2814 XCLC8_YSELB_5 YSEL_5 VSS VSS nch_hvt
+ l=0.06U
+ w=0.5U
M2815 XCLC8_WBS_6 XCLC8_WRTLB VSS VSS
+ nch l=0.06U
+ w=0.35U
M2816 VDD XCLC8_YSELB_6 XCLC8_YSELT_6 VDD
+ pch_hvt l=0.06U
+	 w=0.465U
M2817 BL_6 XCLC8_YSELT_6 VDD VDD pch
+ l=0.06U
+ w=0.59U
M2818 BL_6 XCLC8_YSELT_6 VDD VDD pch
+ l=0.06U
+ w=0.41U
M2819 XCLC8_YSELT_6 XCLC8_YSELB_6 VSS VSS
+ nch_hvt l=0.06U
+ w=0.41U
M2820 XCLC8_WBS_6 XCLC8_YSELB_6
+ XCLC8_XNR0_6_NET3 VDD pch l=0.06U
+ w=0.7U
M2821 VDD XCLC8_YSELB_6 XCLC8_YSELT_6 VDD
+ pch_hvt l=0.06U
+	 w=0.465U
M2822 BL_6 XCLC8_YSELT_6 VDD VDD pch
+ l=0.06U
+ w=0.59U
M2823 BL_6 BLB_6 VDD VDD pch
+ l=0.06U
+ w=0.41U
M2824 XCLC8_WBS_6 XCLC8_YSELB_6 VSS VSS
+ nch l=0.06U
+ w=0.35U
M2825 VDD XCLC8_YSELB_6 XCLC8_YSELT_6 VDD
+ pch_hvt l=0.06U
+	 w=0.465U
M2826 BL_6 XCLC8_YSELT_6 VDD VDD pch
+ l=0.06U
+ w=1.44U
M2827 BL_6 XCLC8_YSELT_6 BLB_6 VDD pch
+ l=0.06U
+ w=1.8U
M2828 BLB_6 XCLC8_WBS_6 XCLC8_WC VSS nch
+ l=0.06U
+ w=0.54U
M2829 BL_6 XCLC8_WBS_6 XCLC8_WT VSS nch
+ l=0.06U
+	 w=0.54U
M2830 VDD YSEL_6 XCLC8_YSELB_6 VDD pch_hvt
+ l=0.06U
+ w=0.5U
M2831 VDD XCLC8_YSELT_6 BLB_6 VDD pch
+ l=0.06U
+ w=1.44U
M2832 BLB_6 XCLC8_WBS_6 XCLC8_WC VSS nch
+ l=0.06U
+ w=0.54U
M2833 BL_6 XCLC8_WBS_6 XCLC8_WT VSS nch
+ l=0.06U
+	 w=0.54U
M2834 VDD XCLC8_YSELT_6 XCLC8_RBS_6 VDD
+ pch_hvt l=0.06U
+	 w=0.41U
M2835 VDD XCLC8_YSELT_6 BLB_6 VDD pch
+ l=0.06U
+ w=0.59U
M2836 VDD BL_6 BLB_6 VDD pch
+ l=0.06U
+ w=0.41U
M2837 BLB_6 XCLC8_WBS_6 XCLC8_WC VSS nch
+ l=0.06U
+ w=0.54U
M2838 BL_6 XCLC8_WBS_6 XCLC8_WT VSS nch
+ l=0.06U
+	 w=0.54U
M2839 VDD XCLC8_RDLB XCLC8_RBS_6 VDD
+ pch_hvt l=0.06U
+	 w=0.41U
M2840 VDD XCLC8_YSELT_6 BLB_6 VDD pch
+ l=0.06U
+ w=0.59U
M2841 VDD XCLC8_YSELT_6 BLB_6 VDD pch
+ l=0.06U
+ w=0.41U
M2842 BLB_6 XCLC8_RBS_6 XCLC8_DC VDD pch
+ l=0.06U
+ w=0.41U
M2843 BLB_6 XCLC8_RBS_6 XCLC8_DC VDD pch
+ l=0.06U
+ w=0.41U
M2844 BL_6 XCLC8_RBS_6 XCLC8_DT VDD pch
+ l=0.06U
+	 w=0.41U
M2845 BL_6 XCLC8_RBS_6 XCLC8_DT VDD pch
+ l=0.06U
+ w=0.41U
M2846 XCLC8_XND0_6_NET9 XCLC8_RDLB
+ XCLC8_RBS_6 VSS nch_hvt l=0.06U
+ w=0.41U
M2847 VSS XCLC8_YSELT_6 XCLC8_XND0_6_NET9
+ VSS nch_hvt l=0.06U
+	 w=0.41U
M2848 XCLC8_YSELB_6 YSEL_6 VSS VSS nch_hvt
+ l=0.06U
+ w=0.5U
M2849 BLB_7 XCLC8_WBS_7 XCLC8_WC VSS nch
+ l=0.06U
+ w=0.54U
M2850 BL_7 XCLC8_WBS_7 XCLC8_WT VSS nch
+ l=0.06U
+	 w=0.54U
M2851 VDD XCLC8_RDLB XCLC8_RBS_7 VDD
+ pch_hvt l=0.06U
+	 w=0.41U
M2852 VDD XCLC8_YSELT_7 BLB_7 VDD pch
+ l=0.06U
+ w=0.59U
M2853 VDD XCLC8_YSELT_7 BLB_7 VDD pch
+ l=0.06U
+ w=0.41U
M2854 BLB_7 XCLC8_WBS_7 XCLC8_WC VSS nch
+ l=0.06U
+ w=0.54U
M2855 BL_7 XCLC8_WBS_7 XCLC8_WT VSS nch
+ l=0.06U
+	 w=0.54U
M2856 VDD XCLC8_YSELT_7 XCLC8_RBS_7 VDD
+ pch_hvt l=0.06U
+	 w=0.41U
M2857 VDD XCLC8_YSELT_7 BLB_7 VDD pch
+ l=0.06U
+ w=0.59U
M2858 VDD BL_7 BLB_7 VDD pch
+ l=0.06U
+ w=0.41U
M2859 BLB_7 XCLC8_WBS_7 XCLC8_WC VSS nch
+ l=0.06U
+ w=0.54U
M2860 BL_7 XCLC8_WBS_7 XCLC8_WT VSS nch
+ l=0.06U
+	 w=0.54U
M2861 VDD YSEL_7 XCLC8_YSELB_7 VDD pch_hvt
+ l=0.06U
+ w=0.5U
M2862 VDD XCLC8_YSELT_7 BLB_7 VDD pch
+ l=0.06U
+ w=1.44U
M2863 BL_7 XCLC8_YSELT_7 BLB_7 VDD pch
+ l=0.06U
+ w=1.8U
M2864 VDD XCLC8_YSELB_7 XCLC8_YSELT_7 VDD
+ pch_hvt l=0.06U
+	 w=0.465U
M2865 BL_7 XCLC8_YSELT_7 VDD VDD pch
+ l=0.06U
+ w=1.44U
M2866 XCLC8_WBS_7 XCLC8_YSELB_7
+ XCLC8_XNR0_7_NET3 VDD pch l=0.06U
+ w=0.7U
M2867 XCLC8_WBS_7 XCLC8_YSELB_7 VSS VSS
+ nch l=0.06U
+ w=0.35U
M2868 VDD XCLC8_YSELB_7 XCLC8_YSELT_7 VDD
+ pch_hvt l=0.06U
+ w=0.465U
M2869 BL_7 XCLC8_YSELT_7 VDD VDD pch
+ l=0.06U
+ w=0.59U
M2870 BL_7 BLB_7 VDD VDD pch
+ l=0.06U
+ w=0.41U
M2871 XCLC8_XNR0_7_NET3 XCLC8_WRTLB VDD
+ VDD pch l=0.06U
+ w=0.7U
M2872 XCLC8_WBS_7 XCLC8_WRTLB VSS VSS
+ nch l=0.06U
+ w=0.35U
M2873 XCLC8_YSELT_7 XCLC8_YSELB_7 VSS VSS
+ nch_hvt l=0.06U
+ w=0.41U
M2874 VDD XCLC8_YSELB_7 XCLC8_YSELT_7 VDD
+ pch_hvt l=0.06U
+ w=0.465U
M2875 BL_7 XCLC8_YSELT_7 VDD VDD pch
+ l=0.06U
+ w=0.59U
M2876 BL_7 XCLC8_YSELT_7 VDD VDD pch
+ l=0.06U
+ w=0.41U
M2877 XCLC8_WT A_GWDT VSS VSS nch
+ l=0.07U
+ w=1U
M2878 XCLC8_WT A_GWDT VSS VSS nch
+ l=0.07U
+ w=1U
M2879 XCLC8_RDLB RDL VSS VSS nch
+ l=0.06U
+ w=0.45U
M2880 VSS XCLC8_DCB A_GRDC VSS nch
+ l=0.06U
+ w=0.8U
M2881 VSS XCLC8_DCB A_GRDC VSS nch
+ l=0.06U
+ w=0.8U
M2882 XCLC8_DCB XCLC8_DC VSS VSS nch
+ l=0.06U
+ w=0.41U
M2883 XCLC8_DTB XCLC8_DT VSS VSS nch
+ l=0.06U
+ w=0.41U
M2884 A_GRDT XCLC8_DTB VSS VSS nch
+ l=0.06U
+ w=0.8U
M2885 A_GRDT XCLC8_DTB VSS VSS nch
+ l=0.06U
+ w=0.8U
M2886 A_GRDT XCLC8_DTB VSS VSS nch
+ l=0.06U
+ w=0.8U
M2887 A_GRDT XCLC8_DTB VSS VSS nch
+ l=0.06U
+ w=0.8U
M2888 XCLC8_NET18 XCLC8_DC XCLC8_DT VSS
+ nch l=0.12U
+ w=0.7U
M2889 XCLC8_NET18 XCLC8_DC XCLC8_DT VSS
+ nch l=0.12U
+ w=0.7U
M2890 XCLC8_NET18 XCLC8_SET VSS VSS nch
+ l=0.08U
+ w=0.7U
M2891 VSS XCLC8_DCB A_GRDC VSS nch
+ l=0.06U
+ w=0.8U
M2892 XCLC8_DC XCLC8_DT XCLC8_NET18 VSS
+ nch l=0.12U
+ w=0.7U
M2893 XCLC8_DC XCLC8_DT XCLC8_NET18 VSS
+ nch l=0.12U
+ w=0.7U
M2894 XCLC8_NET18 XCLC8_SET VSS VSS nch
+ l=0.08U
+ w=0.7U
M2895 VSS XCLC8_DCB A_GRDC VSS nch
+ l=0.06U
+ w=0.8U
M2896 XCLC8_WRTLB WRTL VSS VSS nch
+ l=0.06U
+ w=0.45U
M2897 XCLC8_SMPRST SMPRSX VSS VSS nch
+ l=0.06U
+ w=0.41U
M2898 XCLC8_SET SMPRSX VSS VSS nch
+ l=0.06U
+ w=0.41U
M2899 XCLC8_SET SOE VSS VSS nch
+ l=0.06U
+ w=0.41U
M2900 XCLC8_WC A_GWDC VSS VSS nch
+ l=0.07U
+ w=1U
M2901 XCLC8_WC A_GWDC VSS VSS nch
+ l=0.07U
+ w=1U
M2902 BLB_7 XCLC8_RBS_7 XCLC8_DC VDD pch
+ l=0.06U
+ w=0.41U
M2903 BLB_7 XCLC8_RBS_7 XCLC8_DC VDD pch
+ l=0.06U
+ w=0.41U
M2904 BL_7 XCLC8_RBS_7 XCLC8_DT VDD pch
+ l=0.06U
+	 w=0.41U
M2905 BL_7 XCLC8_RBS_7 XCLC8_DT VDD pch
+ l=0.06U
+ w=0.41U
M2906 XCLC8_XND0_7_NET9 XCLC8_RDLB
+ XCLC8_RBS_7 VSS nch_hvt l=0.06U
+ w=0.41U
M2907 VSS XCLC8_YSELT_7 XCLC8_XND0_7_NET9
+ VSS nch_hvt l=0.06U
+	 w=0.41U
M2908 XCLC8_YSELB_7 YSEL_7 VSS VSS nch_hvt
+ l=0.06U
+ w=0.5U
.ENDS
* CLC8B
.SUBCKT SDL400W20S_CLC8B A_GWDC A_GWDT B_GWDC B_GWDT RDL SMPRS_3 SMPRS_2
+	 SMPRS_1 SMPRS_0 SMPRSX SOE WRTL YSEL_7 YSEL_6 YSEL_5 YSEL_4
+	 YSEL_3 YSEL_2 YSEL_1 YSEL_0 A_GRDC A_GRDT BL_7 BL_6 BL_5 BL_4
+	 BL_3 BL_2 BL_1 BL_0 BLB_7 BLB_6 BLB_5 BLB_4 BLB_3 BLB_2 BLB_1
+	 BLB_0 B_GRDC B_GRDT
M2909 XCLC8_XNR0_0_NET3 XCLC8_WRTLB VDD
+ VDD pch l=0.06U
+ w=0.7U
M2910 XCLC8_WBS_0 XCLC8_WRTLB VSS VSS
+ nch l=0.06U
+ w=0.35U
M2911 VDD XCLC8_YSELB_0 XCLC8_YSELT_0 VDD
+ pch_hvt l=0.06U
+ w=0.465U
M2912 BL_0 XCLC8_YSELT_0 VDD VDD pch
+ l=0.06U
+ w=0.59U
M2913 BL_0 XCLC8_YSELT_0 VDD VDD pch
+ l=0.06U
+ w=0.41U
M2914 XCLC8_YSELT_0 XCLC8_YSELB_0 VSS VSS
+ nch_hvt l=0.06U
+ w=0.41U
M2915 XCLC8_WBS_0 XCLC8_YSELB_0
+ XCLC8_XNR0_0_NET3 VDD pch l=0.06U
+ w=0.7U
M2916 VDD XCLC8_YSELB_0 XCLC8_YSELT_0 VDD
+ pch_hvt l=0.06U
+ w=0.465U
M2917 BL_0 XCLC8_YSELT_0 VDD VDD pch
+ l=0.06U
+ w=0.59U
M2918 BL_0 BLB_0 VDD VDD pch
+ l=0.06U
+ w=0.41U
M2919 XCLC8_WBS_0 XCLC8_YSELB_0 VSS VSS
+ nch l=0.06U
+ w=0.35U
M2920 VDD XCLC8_YSELB_0 XCLC8_YSELT_0 VDD
+ pch_hvt l=0.06U
+	 w=0.465U
M2921 BL_0 XCLC8_YSELT_0 VDD VDD pch
+ l=0.06U
+ w=1.44U
M2922 BL_0 XCLC8_YSELT_0 BLB_0 VDD pch
+ l=0.06U
+ w=1.8U
M2923 BLB_0 XCLC8_WBS_0 XCLC8_WC VSS nch
+ l=0.06U
+ w=0.54U
M2924 BL_0 XCLC8_WBS_0 XCLC8_WT VSS nch
+ l=0.06U
+	 w=0.54U
M2925 VDD YSEL_0 XCLC8_YSELB_0 VDD pch_hvt
+ l=0.06U
+ w=0.5U
M2926 VDD XCLC8_YSELT_0 BLB_0 VDD pch
+ l=0.06U
+ w=1.44U
M2927 BLB_0 XCLC8_WBS_0 XCLC8_WC VSS nch
+ l=0.06U
+ w=0.54U
M2928 BL_0 XCLC8_WBS_0 XCLC8_WT VSS nch
+ l=0.06U
+	 w=0.54U
M2929 VDD XCLC8_YSELT_0 XCLC8_RBS_0 VDD
+ pch_hvt l=0.06U
+	 w=0.41U
M2930 VDD XCLC8_YSELT_0 BLB_0 VDD pch
+ l=0.06U
+ w=0.59U
M2931 VDD BL_0 BLB_0 VDD pch
+ l=0.06U
+ w=0.41U
M2932 BLB_0 XCLC8_WBS_0 XCLC8_WC VSS nch
+ l=0.06U
+ w=0.54U
M2933 BL_0 XCLC8_WBS_0 XCLC8_WT VSS nch
+ l=0.06U
+	 w=0.54U
M2934 VDD XCLC8_RDLB XCLC8_RBS_0 VDD
+ pch_hvt l=0.06U
+	 w=0.41U
M2935 VDD XCLC8_YSELT_0 BLB_0 VDD pch
+ l=0.06U
+ w=0.59U
M2936 VDD XCLC8_YSELT_0 BLB_0 VDD pch
+ l=0.06U
+ w=0.41U
M2937 BLB_0 XCLC8_RBS_0 XCLC8_DC VDD pch
+ l=0.06U
+ w=0.41U
M2938 BLB_0 XCLC8_RBS_0 XCLC8_DC VDD pch
+ l=0.06U
+ w=0.41U
M2939 BL_0 XCLC8_RBS_0 XCLC8_DT VDD pch
+ l=0.06U
+	 w=0.41U
M2940 BL_0 XCLC8_RBS_0 XCLC8_DT VDD pch
+ l=0.06U
+ w=0.41U
M2941 XCLC8_XND0_0_NET9 XCLC8_RDLB
+ XCLC8_RBS_0 VSS nch_hvt l=0.06U
+ w=0.41U
M2942 VSS XCLC8_YSELT_0 XCLC8_XND0_0_NET9
+ VSS nch_hvt l=0.06U
+	 w=0.41U
M2943 XCLC8_YSELB_0 YSEL_0 VSS VSS nch_hvt
+ l=0.06U
+ w=0.5U
M2944 BLB_1 XCLC8_WBS_1 XCLC8_WC VSS nch
+ l=0.06U
+ w=0.54U
M2945 BL_1 XCLC8_WBS_1 XCLC8_WT VSS nch
+ l=0.06U
+	 w=0.54U
M2946 VDD XCLC8_RDLB XCLC8_RBS_1 VDD
+ pch_hvt l=0.06U
+	 w=0.41U
M2947 VDD XCLC8_YSELT_1 BLB_1 VDD pch
+ l=0.06U
+ w=0.59U
M2948 VDD XCLC8_YSELT_1 BLB_1 VDD pch
+ l=0.06U
+ w=0.41U
M2949 BLB_1 XCLC8_WBS_1 XCLC8_WC VSS nch
+ l=0.06U
+ w=0.54U
M2950 BL_1 XCLC8_WBS_1 XCLC8_WT VSS nch
+ l=0.06U
+	 w=0.54U
M2951 VDD XCLC8_YSELT_1 XCLC8_RBS_1 VDD
+ pch_hvt l=0.06U
+	 w=0.41U
M2952 VDD XCLC8_YSELT_1 BLB_1 VDD pch
+ l=0.06U
+ w=0.59U
M2953 VDD BL_1 BLB_1 VDD pch
+ l=0.06U
+ w=0.41U
M2954 BLB_1 XCLC8_WBS_1 XCLC8_WC VSS nch
+ l=0.06U
+ w=0.54U
M2955 BL_1 XCLC8_WBS_1 XCLC8_WT VSS nch
+ l=0.06U
+	 w=0.54U
M2956 VDD YSEL_1 XCLC8_YSELB_1 VDD pch_hvt
+ l=0.06U
+ w=0.5U
M2957 VDD XCLC8_YSELT_1 BLB_1 VDD pch
+ l=0.06U
+ w=1.44U
M2958 BL_1 XCLC8_YSELT_1 BLB_1 VDD pch
+ l=0.06U
+ w=1.8U
M2959 VDD XCLC8_YSELB_1 XCLC8_YSELT_1 VDD
+ pch_hvt l=0.06U
+	 w=0.465U
M2960 BL_1 XCLC8_YSELT_1 VDD VDD pch
+ l=0.06U
+ w=1.44U
M2961 XCLC8_WBS_1 XCLC8_YSELB_1
+ XCLC8_XNR0_1_NET3 VDD pch l=0.06U
+ w=0.7U
M2962 XCLC8_WBS_1 XCLC8_YSELB_1 VSS VSS
+ nch l=0.06U
+ w=0.35U
M2963 VDD XCLC8_YSELB_1 XCLC8_YSELT_1 VDD
+ pch_hvt l=0.06U
+	 w=0.465U
M2964 BL_1 XCLC8_YSELT_1 VDD VDD pch
+ l=0.06U
+ w=0.59U
M2965 BL_1 BLB_1 VDD VDD pch
+ l=0.06U
+ w=0.41U
M2966 XCLC8_XNR0_1_NET3 XCLC8_WRTLB VDD
+ VDD pch l=0.06U
+	 w=0.7U
M2967 XCLC8_WBS_1 XCLC8_WRTLB VSS VSS
+ nch l=0.06U
+ w=0.35U
M2968 XCLC8_YSELT_1 XCLC8_YSELB_1 VSS VSS
+ nch_hvt l=0.06U
+ w=0.41U
M2969 VDD XCLC8_YSELB_1 XCLC8_YSELT_1 VDD
+ pch_hvt l=0.06U
+	 w=0.465U
M2970 BL_1 XCLC8_YSELT_1 VDD VDD pch
+ l=0.06U
+ w=0.59U
M2971 BL_1 XCLC8_YSELT_1 VDD VDD pch
+ l=0.06U
+ w=0.41U
M2972 XCLC8_XNR0_2_NET3 XCLC8_WRTLB VDD
+ VDD pch l=0.06U
+	 w=0.7U
M2973 BLB_1 XCLC8_RBS_1 XCLC8_DC VDD pch
+ l=0.06U
+ w=0.41U
M2974 BLB_1 XCLC8_RBS_1 XCLC8_DC VDD pch
+ l=0.06U
+ w=0.41U
M2975 BL_1 XCLC8_RBS_1 XCLC8_DT VDD pch
+ l=0.06U
+	 w=0.41U
M2976 BL_1 XCLC8_RBS_1 XCLC8_DT VDD pch
+ l=0.06U
+ w=0.41U
M2977 XCLC8_XND0_1_NET9 XCLC8_RDLB
+ XCLC8_RBS_1 VSS nch_hvt l=0.06U
+ w=0.41U
M2978 VSS XCLC8_YSELT_1 XCLC8_XND0_1_NET9
+ VSS nch_hvt l=0.06U
+	 w=0.41U
M2979 XCLC8_YSELB_1 YSEL_1 VSS VSS nch_hvt
+ l=0.06U
+ w=0.5U
M2980 XCLC8_WBS_2 XCLC8_WRTLB VSS VSS
+ nch l=0.06U
+ w=0.35U
M2981 VDD XCLC8_YSELB_2 XCLC8_YSELT_2 VDD
+ pch_hvt l=0.06U
+	 w=0.465U
M2982 BL_2 XCLC8_YSELT_2 VDD VDD pch
+ l=0.06U
+ w=0.59U
M2983 BL_2 XCLC8_YSELT_2 VDD VDD pch
+ l=0.06U
+ w=0.41U
M2984 XCLC8_YSELT_2 XCLC8_YSELB_2 VSS VSS
+ nch_hvt l=0.06U
+	 w=0.41U
M2985 XCLC8_WBS_2 XCLC8_YSELB_2
+ XCLC8_XNR0_2_NET3 VDD pch l=0.06U
+ w=0.7U
M2986 VDD XCLC8_YSELB_2 XCLC8_YSELT_2 VDD
+ pch_hvt l=0.06U
+	 w=0.465U
M2987 BL_2 XCLC8_YSELT_2 VDD VDD pch
+ l=0.06U
+ w=0.59U
M2988 BL_2 BLB_2 VDD VDD pch
+ l=0.06U
+ w=0.41U
M2989 XCLC8_WBS_2 XCLC8_YSELB_2 VSS VSS
+ nch l=0.06U
+ w=0.35U
M2990 VDD XCLC8_YSELB_2 XCLC8_YSELT_2 VDD
+ pch_hvt l=0.06U
+	 w=0.465U
M2991 BL_2 XCLC8_YSELT_2 VDD VDD pch
+ l=0.06U
+ w=1.44U
M2992 BL_2 XCLC8_YSELT_2 BLB_2 VDD pch
+ l=0.06U
+ w=1.8U
M2993 BLB_2 XCLC8_WBS_2 XCLC8_WC VSS nch
+ l=0.06U
+ w=0.54U
M2994 BL_2 XCLC8_WBS_2 XCLC8_WT VSS nch
+ l=0.06U
+	 w=0.54U
M2995 VDD YSEL_2 XCLC8_YSELB_2 VDD pch_hvt
+ l=0.06U
+ w=0.5U
M2996 VDD XCLC8_YSELT_2 BLB_2 VDD pch
+ l=0.06U
+ w=1.44U
M2997 BLB_2 XCLC8_WBS_2 XCLC8_WC VSS nch
+ l=0.06U
+ w=0.54U
M2998 BL_2 XCLC8_WBS_2 XCLC8_WT VSS nch
+ l=0.06U
+	 w=0.54U
M2999 VDD XCLC8_YSELT_2 XCLC8_RBS_2 VDD
+ pch_hvt l=0.06U
+	 w=0.41U
M3000 VDD XCLC8_YSELT_2 BLB_2 VDD pch
+ l=0.06U
+ w=0.59U
M3001 VDD BL_2 BLB_2 VDD pch
+ l=0.06U
+ w=0.41U
M3002 BLB_2 XCLC8_WBS_2 XCLC8_WC VSS nch
+ l=0.06U
+ w=0.54U
M3003 BL_2 XCLC8_WBS_2 XCLC8_WT VSS nch
+ l=0.06U
+	 w=0.54U
M3004 VDD XCLC8_RDLB XCLC8_RBS_2 VDD
+ pch_hvt l=0.06U
+	 w=0.41U
M3005 VDD XCLC8_YSELT_2 BLB_2 VDD pch
+ l=0.06U
+ w=0.59U
M3006 VDD XCLC8_YSELT_2 BLB_2 VDD pch
+ l=0.06U
+ w=0.41U
M3007 BLB_2 XCLC8_RBS_2 XCLC8_DC VDD pch
+ l=0.06U
+ w=0.41U
M3008 BLB_2 XCLC8_RBS_2 XCLC8_DC VDD pch
+ l=0.06U
+ w=0.41U
M3009 BL_2 XCLC8_RBS_2 XCLC8_DT VDD pch
+ l=0.06U
+	 w=0.41U
M3010 BL_2 XCLC8_RBS_2 XCLC8_DT VDD pch
+ l=0.06U
+ w=0.41U
M3011 XCLC8_XND0_2_NET9 XCLC8_RDLB
+ XCLC8_RBS_2 VSS nch_hvt l=0.06U
+ w=0.41U
M3012 VSS XCLC8_YSELT_2 XCLC8_XND0_2_NET9
+ VSS nch_hvt l=0.06U
+	 w=0.41U
M3013 XCLC8_YSELB_2 YSEL_2 VSS VSS nch_hvt
+ l=0.06U
+ w=0.5U
M3014 BLB_3 XCLC8_WBS_3 XCLC8_WC VSS nch
+ l=0.06U
+ w=0.54U
M3015 BL_3 XCLC8_WBS_3 XCLC8_WT VSS nch
+ l=0.06U
+	 w=0.54U
M3016 VDD XCLC8_RDLB XCLC8_RBS_3 VDD
+ pch_hvt l=0.06U
+	 w=0.41U
M3017 VDD XCLC8_YSELT_3 BLB_3 VDD pch
+ l=0.06U
+ w=0.59U
M3018 VDD XCLC8_YSELT_3 BLB_3 VDD pch
+ l=0.06U
+ w=0.41U
M3019 BLB_3 XCLC8_WBS_3 XCLC8_WC VSS nch
+ l=0.06U
+ w=0.54U
M3020 BL_3 XCLC8_WBS_3 XCLC8_WT VSS nch
+ l=0.06U
+	 w=0.54U
M3021 VDD XCLC8_YSELT_3 XCLC8_RBS_3 VDD
+ pch_hvt l=0.06U
+	 w=0.41U
M3022 VDD XCLC8_YSELT_3 BLB_3 VDD pch
+ l=0.06U
+ w=0.59U
M3023 VDD BL_3 BLB_3 VDD pch
+ l=0.06U
+ w=0.41U
M3024 BLB_3 XCLC8_WBS_3 XCLC8_WC VSS nch
+ l=0.06U
+ w=0.54U
M3025 BL_3 XCLC8_WBS_3 XCLC8_WT VSS nch
+ l=0.06U
+	 w=0.54U
M3026 VDD YSEL_3 XCLC8_YSELB_3 VDD pch_hvt
+ l=0.06U
+ w=0.5U
M3027 VDD XCLC8_YSELT_3 BLB_3 VDD pch
+ l=0.06U
+ w=1.44U
M3028 BL_3 XCLC8_YSELT_3 BLB_3 VDD pch
+ l=0.06U
+ w=1.8U
M3029 VDD XCLC8_YSELB_3 XCLC8_YSELT_3 VDD
+ pch_hvt l=0.06U
+	 w=0.465U
M3030 BL_3 XCLC8_YSELT_3 VDD VDD pch
+ l=0.06U
+ w=1.44U
M3031 XCLC8_WBS_3 XCLC8_YSELB_3
+ XCLC8_XNR0_3_NET3 VDD pch l=0.06U
+ w=0.7U
M3032 XCLC8_WBS_3 XCLC8_YSELB_3 VSS VSS
+ nch l=0.06U
+ w=0.35U
M3033 VDD XCLC8_YSELB_3 XCLC8_YSELT_3 VDD
+ pch_hvt l=0.06U
+	 w=0.465U
M3034 BL_3 XCLC8_YSELT_3 VDD VDD pch
+ l=0.06U
+ w=0.59U
M3035 BL_3 BLB_3 VDD VDD pch
+ l=0.06U
+ w=0.41U
M3036 XCLC8_XNR0_3_NET3 XCLC8_WRTLB VDD
+ VDD pch l=0.06U
+	 w=0.7U
M3037 XCLC8_WBS_3 XCLC8_WRTLB VSS VSS
+ nch l=0.06U
+ w=0.35U
M3038 XCLC8_YSELT_3 XCLC8_YSELB_3 VSS VSS
+ nch_hvt l=0.06U
+ w=0.41U
M3039 VDD XCLC8_YSELB_3 XCLC8_YSELT_3 VDD
+ pch_hvt l=0.06U
+	 w=0.465U
M3040 BL_3 XCLC8_YSELT_3 VDD VDD pch
+ l=0.06U
+ w=0.59U
M3041 BL_3 XCLC8_YSELT_3 VDD VDD pch
+ l=0.06U
+ w=0.41U
M3042 XCLC8_XNR0_4_NET3 XCLC8_WRTLB VDD
+ VDD pch l=0.06U
+	 w=0.7U
M3043 BLB_3 XCLC8_RBS_3 XCLC8_DC VDD pch
+ l=0.06U
+ w=0.41U
M3044 BLB_3 XCLC8_RBS_3 XCLC8_DC VDD pch
+ l=0.06U
+ w=0.41U
M3045 BL_3 XCLC8_RBS_3 XCLC8_DT VDD pch
+ l=0.06U
+	 w=0.41U
M3046 BL_3 XCLC8_RBS_3 XCLC8_DT VDD pch
+ l=0.06U
+ w=0.41U
M3047 XCLC8_XND0_3_NET9 XCLC8_RDLB
+ XCLC8_RBS_3 VSS nch_hvt l=0.06U
+ w=0.41U
M3048 VSS XCLC8_YSELT_3 XCLC8_XND0_3_NET9
+ VSS nch_hvt l=0.06U
+	 w=0.41U
M3049 XCLC8_YSELB_3 YSEL_3 VSS VSS nch_hvt
+ l=0.06U
+ w=0.5U
M3050 XCLC8_WBS_4 XCLC8_WRTLB VSS VSS
+ nch l=0.06U
+ w=0.35U
M3051 VDD XCLC8_YSELB_4 XCLC8_YSELT_4 VDD
+ pch_hvt l=0.06U
+	 w=0.465U
M3052 BL_4 XCLC8_YSELT_4 VDD VDD pch
+ l=0.06U
+ w=0.59U
M3053 BL_4 XCLC8_YSELT_4 VDD VDD pch
+ l=0.06U
+ w=0.41U
M3054 XCLC8_YSELT_4 XCLC8_YSELB_4 VSS VSS
+ nch_hvt l=0.06U
+ w=0.41U
M3055 XCLC8_WBS_4 XCLC8_YSELB_4
+ XCLC8_XNR0_4_NET3 VDD pch l=0.06U
+ w=0.7U
M3056 VDD XCLC8_YSELB_4 XCLC8_YSELT_4 VDD
+ pch_hvt l=0.06U
+	 w=0.465U
M3057 BL_4 XCLC8_YSELT_4 VDD VDD pch
+ l=0.06U
+ w=0.59U
M3058 BL_4 BLB_4 VDD VDD pch
+ l=0.06U
+ w=0.41U
M3059 XCLC8_WBS_4 XCLC8_YSELB_4 VSS VSS
+ nch l=0.06U
+ w=0.35U
M3060 VDD XCLC8_YSELB_4 XCLC8_YSELT_4 VDD
+ pch_hvt l=0.06U
+	 w=0.465U
M3061 BL_4 XCLC8_YSELT_4 VDD VDD pch
+ l=0.06U
+ w=1.44U
M3062 BL_4 XCLC8_YSELT_4 BLB_4 VDD pch
+ l=0.06U
+ w=1.8U
M3063 BLB_4 XCLC8_WBS_4 XCLC8_WC VSS nch
+ l=0.06U
+ w=0.54U
M3064 BL_4 XCLC8_WBS_4 XCLC8_WT VSS nch
+ l=0.06U
+	 w=0.54U
M3065 VDD YSEL_4 XCLC8_YSELB_4 VDD pch_hvt
+ l=0.06U
+ w=0.5U
M3066 VDD XCLC8_YSELT_4 BLB_4 VDD pch
+ l=0.06U
+ w=1.44U
M3067 BLB_4 XCLC8_WBS_4 XCLC8_WC VSS nch
+ l=0.06U
+ w=0.54U
M3068 BL_4 XCLC8_WBS_4 XCLC8_WT VSS nch
+ l=0.06U
+	 w=0.54U
M3069 VDD XCLC8_YSELT_4 XCLC8_RBS_4 VDD
+ pch_hvt l=0.06U
+	 w=0.41U
M3070 VDD XCLC8_YSELT_4 BLB_4 VDD pch
+ l=0.06U
+ w=0.59U
M3071 VDD BL_4 BLB_4 VDD pch
+ l=0.06U
+ w=0.41U
M3072 BLB_4 XCLC8_WBS_4 XCLC8_WC VSS nch
+ l=0.06U
+ w=0.54U
M3073 BL_4 XCLC8_WBS_4 XCLC8_WT VSS nch
+ l=0.06U
+	 w=0.54U
M3074 VDD XCLC8_RDLB XCLC8_RBS_4 VDD
+ pch_hvt l=0.06U
+	 w=0.41U
M3075 VDD XCLC8_YSELT_4 BLB_4 VDD pch
+ l=0.06U
+ w=0.59U
M3076 VDD XCLC8_YSELT_4 BLB_4 VDD pch
+ l=0.06U
+ w=0.41U
M3077 BLB_4 XCLC8_RBS_4 XCLC8_DC VDD pch
+ l=0.06U
+ w=0.41U
M3078 BLB_4 XCLC8_RBS_4 XCLC8_DC VDD pch
+ l=0.06U
+ w=0.41U
M3079 BL_4 XCLC8_RBS_4 XCLC8_DT VDD pch
+ l=0.06U
+	 w=0.41U
M3080 BL_4 XCLC8_RBS_4 XCLC8_DT VDD pch
+ l=0.06U
+ w=0.41U
M3081 XCLC8_XND0_4_NET9 XCLC8_RDLB
+ XCLC8_RBS_4 VSS nch_hvt l=0.06U
+ w=0.41U
M3082 VSS XCLC8_YSELT_4 XCLC8_XND0_4_NET9
+ VSS nch_hvt l=0.06U
+	 w=0.41U
M3083 XCLC8_YSELB_4 YSEL_4 VSS VSS nch_hvt
+ l=0.06U
+ w=0.5U
M3084 BLB_5 XCLC8_WBS_5 XCLC8_WC VSS nch
+ l=0.06U
+ w=0.54U
M3085 BL_5 XCLC8_WBS_5 XCLC8_WT VSS nch
+ l=0.06U
+	 w=0.54U
M3086 VDD XCLC8_RDLB XCLC8_RBS_5 VDD
+ pch_hvt l=0.06U
+	 w=0.41U
M3087 VDD XCLC8_YSELT_5 BLB_5 VDD pch
+ l=0.06U
+ w=0.59U
M3088 VDD XCLC8_YSELT_5 BLB_5 VDD pch
+ l=0.06U
+ w=0.41U
M3089 BLB_5 XCLC8_WBS_5 XCLC8_WC VSS nch
+ l=0.06U
+ w=0.54U
M3090 BL_5 XCLC8_WBS_5 XCLC8_WT VSS nch
+ l=0.06U
+	 w=0.54U
M3091 VDD XCLC8_YSELT_5 XCLC8_RBS_5 VDD
+ pch_hvt l=0.06U
+	 w=0.41U
M3092 VDD XCLC8_YSELT_5 BLB_5 VDD pch
+ l=0.06U
+ w=0.59U
M3093 VDD BL_5 BLB_5 VDD pch
+ l=0.06U
+ w=0.41U
M3094 BLB_5 XCLC8_WBS_5 XCLC8_WC VSS nch
+ l=0.06U
+ w=0.54U
M3095 BL_5 XCLC8_WBS_5 XCLC8_WT VSS nch
+ l=0.06U
+	 w=0.54U
M3096 VDD YSEL_5 XCLC8_YSELB_5 VDD pch_hvt
+ l=0.06U
+ w=0.5U
M3097 VDD XCLC8_YSELT_5 BLB_5 VDD pch
+ l=0.06U
+ w=1.44U
M3098 BL_5 XCLC8_YSELT_5 BLB_5 VDD pch
+ l=0.06U
+ w=1.8U
M3099 VDD XCLC8_YSELB_5 XCLC8_YSELT_5 VDD
+ pch_hvt l=0.06U
+	 w=0.465U
M3100 BL_5 XCLC8_YSELT_5 VDD VDD pch
+ l=0.06U
+ w=1.44U
M3101 XCLC8_WBS_5 XCLC8_YSELB_5
+ XCLC8_XNR0_5_NET3 VDD pch l=0.06U
+ w=0.7U
M3102 XCLC8_WBS_5 XCLC8_YSELB_5 VSS VSS
+ nch l=0.06U
+ w=0.35U
M3103 VDD XCLC8_YSELB_5 XCLC8_YSELT_5 VDD
+ pch_hvt l=0.06U
+	 w=0.465U
M3104 BL_5 XCLC8_YSELT_5 VDD VDD pch
+ l=0.06U
+ w=0.59U
M3105 BL_5 BLB_5 VDD VDD pch
+ l=0.06U
+ w=0.41U
M3106 XCLC8_XNR0_5_NET3 XCLC8_WRTLB VDD
+ VDD pch l=0.06U
+	 w=0.7U
M3107 XCLC8_WBS_5 XCLC8_WRTLB VSS VSS
+ nch l=0.06U
+ w=0.35U
M3108 XCLC8_YSELT_5 XCLC8_YSELB_5 VSS VSS
+ nch_hvt l=0.06U
+	 w=0.41U
M3109 VDD XCLC8_YSELB_5 XCLC8_YSELT_5 VDD
+ pch_hvt l=0.06U
+	 w=0.465U
M3110 BL_5 XCLC8_YSELT_5 VDD VDD pch
+ l=0.06U
+ w=0.59U
M3111 BL_5 XCLC8_YSELT_5 VDD VDD pch
+ l=0.06U
+ w=0.41U
M3112 VDD B_GWDT XCLC8_WT VDD pch
+ l=0.06U
+ w=0.41U
M3113 VDD RDL XCLC8_RDLB VDD pch
+ l=0.06U
+ w=0.7U
M3114 VDD XCLC8_DT XCLC8_DTB VDD pch
+ l=0.06U
+ w=0.7U
M3115 VDD XCLC8_DT XCLC8_DTB VDD
+ pch l=0.06U
+ w=0.7U
M3116 VDD XCLC8_SMPRST XCLC8_DT VDD pch
+ l=0.06U
+ w=0.57U
M3117 VDD XCLC8_SMPRST XCLC8_DT VDD pch
+ l=0.06U
+ w=0.57U
M3118 VDD XCLC8_SMPRST XCLC8_DT VDD pch
+ l=0.06U
+ w=0.41U
M3119 XCLC8_DT XCLC8_DC VDD VDD pch
+ l=0.12U
+ w=0.41U
M3120 XCLC8_DT XCLC8_DC VDD VDD pch
+ l=0.12U
+ w=0.41U
M3121 VDD XCLC8_DT XCLC8_DC VDD pch
+ l=0.12U
+ w=0.41U
M3122 VDD XCLC8_DT XCLC8_DC VDD pch
+ l=0.12U
+ w=0.41U
M3123 XCLC8_DT XCLC8_SMPRST XCLC8_DC VDD
+ pch l=0.06U
+ w=0.41U
M3124 XCLC8_DC XCLC8_SMPRST VDD VDD pch
+ l=0.06U
+ w=0.41U
M3125 XCLC8_DC XCLC8_SMPRST VDD VDD pch
+ l=0.06U
+ w=0.57U
M3126 XCLC8_DC XCLC8_SMPRST VDD VDD pch
+ l=0.06U
+ w=0.57U
M3127 VDD XCLC8_DC XCLC8_DCB VDD pch
+ l=0.06U
+ w=0.7U
M3128 VDD XCLC8_DC XCLC8_DCB VDD
+ pch l=0.06U
+ w=0.7U
M3129 VDD B_GWDC XCLC8_WC VDD pch
+ l=0.06U
+ w=0.41U
M3130 VDD WRTL XCLC8_WRTLB VDD pch
+ l=0.06U
+ w=0.7U
M3131 VDD SMPRSX XCLC8_XNRS_NET3 VDD pch
+ l=0.06U
+ w=0.7U
M3132 VDD SMPRSX XCLC8_SMPRST VDD pch
+ l=0.06U
+ w=0.41U
M3133 VDD SMPRSX XCLC8_SMPRST VDD pch
+ l=0.06U
+ w=0.41U
M3134 XCLC8_XNRS_NET3 SOE XCLC8_SET VDD pch
+ l=0.06U
+ w=0.7U
M3135 XCLC8_XNR0_6_NET3 XCLC8_WRTLB VDD
+ VDD pch l=0.06U
+	 w=0.7U
M3136 BLB_5 XCLC8_RBS_5 XCLC8_DC VDD pch
+ l=0.06U
+ w=0.41U
M3137 BLB_5 XCLC8_RBS_5 XCLC8_DC VDD pch
+ l=0.06U
+ w=0.41U
M3138 BL_5 XCLC8_RBS_5 XCLC8_DT VDD pch
+ l=0.06U
+	 w=0.41U
M3139 BL_5 XCLC8_RBS_5 XCLC8_DT VDD pch
+ l=0.06U
+ w=0.41U
M3140 XCLC8_XND0_5_NET9 XCLC8_RDLB
+ XCLC8_RBS_5 VSS nch_hvt l=0.06U
+ w=0.41U
M3141 VSS XCLC8_YSELT_5 XCLC8_XND0_5_NET9
+ VSS nch_hvt l=0.06U
+	 w=0.41U
M3142 XCLC8_YSELB_5 YSEL_5 VSS VSS nch_hvt
+ l=0.06U
+ w=0.5U
M3143 XCLC8_WBS_6 XCLC8_WRTLB VSS VSS
+ nch l=0.06U
+ w=0.35U
M3144 VDD XCLC8_YSELB_6 XCLC8_YSELT_6 VDD
+ pch_hvt l=0.06U
+	 w=0.465U
M3145 BL_6 XCLC8_YSELT_6 VDD VDD pch
+ l=0.06U
+ w=0.59U
M3146 BL_6 XCLC8_YSELT_6 VDD VDD pch
+ l=0.06U
+ w=0.41U
M3147 XCLC8_YSELT_6 XCLC8_YSELB_6 VSS VSS
+ nch_hvt l=0.06U
+ w=0.41U
M3148 XCLC8_WBS_6 XCLC8_YSELB_6
+ XCLC8_XNR0_6_NET3 VDD pch l=0.06U
+ w=0.7U
M3149 VDD XCLC8_YSELB_6 XCLC8_YSELT_6 VDD
+ pch_hvt l=0.06U
+	 w=0.465U
M3150 BL_6 XCLC8_YSELT_6 VDD VDD pch
+ l=0.06U
+ w=0.59U
M3151 BL_6 BLB_6 VDD VDD pch
+ l=0.06U
+ w=0.41U
M3152 XCLC8_WBS_6 XCLC8_YSELB_6 VSS VSS
+ nch l=0.06U
+ w=0.35U
M3153 VDD XCLC8_YSELB_6 XCLC8_YSELT_6 VDD
+ pch_hvt l=0.06U
+	 w=0.465U
M3154 BL_6 XCLC8_YSELT_6 VDD VDD pch
+ l=0.06U
+ w=1.44U
M3155 BL_6 XCLC8_YSELT_6 BLB_6 VDD pch
+ l=0.06U
+ w=1.8U
M3156 BLB_6 XCLC8_WBS_6 XCLC8_WC VSS nch
+ l=0.06U
+ w=0.54U
M3157 BL_6 XCLC8_WBS_6 XCLC8_WT VSS nch
+ l=0.06U
+	 w=0.54U
M3158 VDD YSEL_6 XCLC8_YSELB_6 VDD pch_hvt
+ l=0.06U
+ w=0.5U
M3159 VDD XCLC8_YSELT_6 BLB_6 VDD pch
+ l=0.06U
+ w=1.44U
M3160 BLB_6 XCLC8_WBS_6 XCLC8_WC VSS nch
+ l=0.06U
+ w=0.54U
M3161 BL_6 XCLC8_WBS_6 XCLC8_WT VSS nch
+ l=0.06U
+	 w=0.54U
M3162 VDD XCLC8_YSELT_6 XCLC8_RBS_6 VDD
+ pch_hvt l=0.06U
+	 w=0.41U
M3163 VDD XCLC8_YSELT_6 BLB_6 VDD pch
+ l=0.06U
+ w=0.59U
M3164 VDD BL_6 BLB_6 VDD pch
+ l=0.06U
+ w=0.41U
M3165 BLB_6 XCLC8_WBS_6 XCLC8_WC VSS nch
+ l=0.06U
+ w=0.54U
M3166 BL_6 XCLC8_WBS_6 XCLC8_WT VSS nch
+ l=0.06U
+	 w=0.54U
M3167 VDD XCLC8_RDLB XCLC8_RBS_6 VDD
+ pch_hvt l=0.06U
+	 w=0.41U
M3168 VDD XCLC8_YSELT_6 BLB_6 VDD pch
+ l=0.06U
+ w=0.59U
M3169 VDD XCLC8_YSELT_6 BLB_6 VDD pch
+ l=0.06U
+ w=0.41U
M3170 BLB_6 XCLC8_RBS_6 XCLC8_DC VDD pch
+ l=0.06U
+ w=0.41U
M3171 BLB_6 XCLC8_RBS_6 XCLC8_DC VDD pch
+ l=0.06U
+ w=0.41U
M3172 BL_6 XCLC8_RBS_6 XCLC8_DT VDD pch
+ l=0.06U
+	 w=0.41U
M3173 BL_6 XCLC8_RBS_6 XCLC8_DT VDD pch
+ l=0.06U
+ w=0.41U
M3174 XCLC8_XND0_6_NET9 XCLC8_RDLB
+ XCLC8_RBS_6 VSS nch_hvt l=0.06U
+ w=0.41U
M3175 VSS XCLC8_YSELT_6 XCLC8_XND0_6_NET9
+ VSS nch_hvt l=0.06U
+	 w=0.41U
M3176 XCLC8_YSELB_6 YSEL_6 VSS VSS nch_hvt
+ l=0.06U
+ w=0.5U
M3177 BLB_7 XCLC8_WBS_7 XCLC8_WC VSS nch
+ l=0.06U
+ w=0.54U
M3178 BL_7 XCLC8_WBS_7 XCLC8_WT VSS nch
+ l=0.06U
+	 w=0.54U
M3179 VDD XCLC8_RDLB XCLC8_RBS_7 VDD
+ pch_hvt l=0.06U
+	 w=0.41U
M3180 VDD XCLC8_YSELT_7 BLB_7 VDD pch
+ l=0.06U
+ w=0.59U
M3181 VDD XCLC8_YSELT_7 BLB_7 VDD pch
+ l=0.06U
+ w=0.41U
M3182 BLB_7 XCLC8_WBS_7 XCLC8_WC VSS nch
+ l=0.06U
+ w=0.54U
M3183 BL_7 XCLC8_WBS_7 XCLC8_WT VSS nch
+ l=0.06U
+	 w=0.54U
M3184 VDD XCLC8_YSELT_7 XCLC8_RBS_7 VDD
+ pch_hvt l=0.06U
+	 w=0.41U
M3185 VDD XCLC8_YSELT_7 BLB_7 VDD pch
+ l=0.06U
+ w=0.59U
M3186 VDD BL_7 BLB_7 VDD pch
+ l=0.06U
+ w=0.41U
M3187 BLB_7 XCLC8_WBS_7 XCLC8_WC VSS nch
+ l=0.06U
+ w=0.54U
M3188 BL_7 XCLC8_WBS_7 XCLC8_WT VSS nch
+ l=0.06U
+	 w=0.54U
M3189 VDD YSEL_7 XCLC8_YSELB_7 VDD pch_hvt
+ l=0.06U
+ w=0.5U
M3190 VDD XCLC8_YSELT_7 BLB_7 VDD pch
+ l=0.06U
+ w=1.44U
M3191 BL_7 XCLC8_YSELT_7 BLB_7 VDD pch
+ l=0.06U
+ w=1.8U
M3192 VDD XCLC8_YSELB_7 XCLC8_YSELT_7 VDD
+ pch_hvt l=0.06U
+	 w=0.465U
M3193 BL_7 XCLC8_YSELT_7 VDD VDD pch
+ l=0.06U
+ w=1.44U
M3194 XCLC8_WBS_7 XCLC8_YSELB_7
+ XCLC8_XNR0_7_NET3 VDD pch l=0.06U
+ w=0.7U
M3195 XCLC8_WBS_7 XCLC8_YSELB_7 VSS VSS
+ nch l=0.06U
+ w=0.35U
M3196 VDD XCLC8_YSELB_7 XCLC8_YSELT_7 VDD
+ pch_hvt l=0.06U
+ w=0.465U
M3197 BL_7 XCLC8_YSELT_7 VDD VDD pch
+ l=0.06U
+ w=0.59U
M3198 BL_7 BLB_7 VDD VDD pch
+ l=0.06U
+ w=0.41U
M3199 XCLC8_XNR0_7_NET3 XCLC8_WRTLB VDD
+ VDD pch l=0.06U
+ w=0.7U
M3200 XCLC8_WBS_7 XCLC8_WRTLB VSS VSS
+ nch l=0.06U
+ w=0.35U
M3201 XCLC8_YSELT_7 XCLC8_YSELB_7 VSS VSS
+ nch_hvt l=0.06U
+ w=0.41U
M3202 VDD XCLC8_YSELB_7 XCLC8_YSELT_7 VDD
+ pch_hvt l=0.06U
+ w=0.465U
M3203 BL_7 XCLC8_YSELT_7 VDD VDD pch
+ l=0.06U
+ w=0.59U
M3204 BL_7 XCLC8_YSELT_7 VDD VDD pch
+ l=0.06U
+ w=0.41U
M3205 XCLC8_WT B_GWDT VSS VSS nch
+ l=0.07U
+ w=1U
M3206 XCLC8_WT B_GWDT VSS VSS nch
+ l=0.07U
+ w=1U
M3207 XCLC8_RDLB RDL VSS VSS nch
+ l=0.06U
+ w=0.45U
M3208 VSS XCLC8_DCB B_GRDC VSS nch
+ l=0.06U
+ w=0.8U
M3209 VSS XCLC8_DCB B_GRDC VSS nch
+ l=0.06U
+ w=0.8U
M3210 XCLC8_DCB XCLC8_DC VSS VSS nch
+ l=0.06U
+ w=0.41U
M3211 XCLC8_DTB XCLC8_DT VSS VSS nch
+ l=0.06U
+ w=0.41U
M3212 B_GRDT XCLC8_DTB VSS VSS nch
+ l=0.06U
+ w=0.8U
M3213 B_GRDT XCLC8_DTB VSS VSS nch
+ l=0.06U
+ w=0.8U
M3214 B_GRDT XCLC8_DTB VSS VSS nch
+ l=0.06U
+ w=0.8U
M3215 B_GRDT XCLC8_DTB VSS VSS nch
+ l=0.06U
+ w=0.8U
M3216 XCLC8_NET18 XCLC8_DC XCLC8_DT VSS
+ nch l=0.12U
+ w=0.7U
M3217 XCLC8_NET18 XCLC8_DC XCLC8_DT VSS
+ nch l=0.12U
+ w=0.7U
M3218 XCLC8_NET18 XCLC8_SET VSS VSS nch
+ l=0.08U
+ w=0.7U
M3219 VSS XCLC8_DCB B_GRDC VSS nch
+ l=0.06U
+ w=0.8U
M3220 XCLC8_DC XCLC8_DT XCLC8_NET18 VSS
+ nch l=0.12U
+ w=0.7U
M3221 XCLC8_DC XCLC8_DT XCLC8_NET18 VSS
+ nch l=0.12U
+ w=0.7U
M3222 XCLC8_NET18 XCLC8_SET VSS VSS nch
+ l=0.08U
+ w=0.7U
M3223 VSS XCLC8_DCB B_GRDC VSS nch
+ l=0.06U
+ w=0.8U
M3224 XCLC8_WRTLB WRTL VSS VSS nch
+ l=0.06U
+ w=0.45U
M3225 XCLC8_SMPRST SMPRSX VSS VSS nch
+ l=0.06U
+ w=0.41U
M3226 XCLC8_SET SMPRSX VSS VSS nch
+ l=0.06U
+ w=0.41U
M3227 XCLC8_SET SOE VSS VSS nch
+ l=0.06U
+ w=0.41U
M3228 XCLC8_WC B_GWDC VSS VSS nch
+ l=0.07U
+ w=1U
M3229 XCLC8_WC B_GWDC VSS VSS nch
+ l=0.07U
+ w=1U
M3230 BLB_7 XCLC8_RBS_7 XCLC8_DC VDD pch
+ l=0.06U
+ w=0.41U
M3231 BLB_7 XCLC8_RBS_7 XCLC8_DC VDD pch
+ l=0.06U
+ w=0.41U
M3232 BL_7 XCLC8_RBS_7 XCLC8_DT VDD pch
+ l=0.06U
+	 w=0.41U
M3233 BL_7 XCLC8_RBS_7 XCLC8_DT VDD pch
+ l=0.06U
+ w=0.41U
M3234 XCLC8_XND0_7_NET9 XCLC8_RDLB
+ XCLC8_RBS_7 VSS nch_hvt l=0.06U
+ w=0.41U
M3235 VSS XCLC8_YSELT_7 XCLC8_XND0_7_NET9
+ VSS nch_hvt l=0.06U
+	 w=0.41U
M3236 XCLC8_YSELB_7 YSEL_7 VSS VSS nch_hvt
+ l=0.06U
+ w=0.5U
.ENDS
* CLC8BT
.SUBCKT SDL400W20S_CLC8BT A_GWDC A_GWDT B_GWDC B_GWDT RDL SMPRS_3 SMPRS_2
+	 SMPRS_1 SMPRS_0 SMPRSX SOE WRTL YSEL_7 YSEL_6 YSEL_5 YSEL_4
+	 YSEL_3 YSEL_2 YSEL_1 YSEL_0 A_GRDC A_GRDT BL_7 BL_6 BL_5 BL_4
+	 BL_3 BL_2 BL_1 BL_0 BLB_7 BLB_6 BLB_5 BLB_4 BLB_3 BLB_2 BLB_1
+	 BLB_0 B_GRDC B_GRDT
M3237 XCLC8_XNR0_0_NET3 XCLC8_WRTLB VDD
+ VDD pch l=0.06U
+ w=0.7U
M3238 XCLC8_WBS_0 XCLC8_WRTLB VSS VSS
+ nch l=0.06U
+ w=0.35U
M3239 VDD XCLC8_YSELB_0 XCLC8_YSELT_0 VDD
+ pch_hvt l=0.06U
+ w=0.465U
M3240 VDD XCLC8_YSELT_0 BLB_0 VDD pch
+ l=0.06U
+ w=0.59U
M3241 VDD XCLC8_YSELT_0 BLB_0 VDD pch
+ l=0.06U
+ w=0.41U
M3242 XCLC8_YSELT_0 XCLC8_YSELB_0 VSS VSS
+ nch_hvt l=0.06U
+ w=0.41U
M3243 XCLC8_WBS_0 XCLC8_YSELB_0
+ XCLC8_XNR0_0_NET3 VDD pch l=0.06U
+ w=0.7U
M3244 VDD XCLC8_YSELB_0 XCLC8_YSELT_0 VDD
+ pch_hvt l=0.06U
+ w=0.465U
M3245 VDD XCLC8_YSELT_0 BLB_0 VDD pch
+ l=0.06U
+ w=0.59U
M3246 VDD BL_0 BLB_0 VDD pch
+ l=0.06U
+ w=0.41U
M3247 XCLC8_WBS_0 XCLC8_YSELB_0 VSS VSS
+ nch l=0.06U
+ w=0.35U
M3248 VDD XCLC8_YSELB_0 XCLC8_YSELT_0 VDD
+ pch_hvt l=0.06U
+	 w=0.465U
M3249 VDD XCLC8_YSELT_0 BLB_0 VDD pch
+ l=0.06U
+ w=1.44U
M3250 BL_0 XCLC8_YSELT_0 BLB_0 VDD pch
+ l=0.06U
+ w=1.8U
M3251 BL_0 XCLC8_WBS_0 XCLC8_WT VSS nch
+ l=0.06U
+ w=0.54U
M3252 BLB_0 XCLC8_WBS_0 XCLC8_WC VSS nch
+ l=0.06U
+	 w=0.54U
M3253 VDD YSEL_0 XCLC8_YSELB_0 VDD pch_hvt
+ l=0.06U
+ w=0.5U
M3254 BL_0 XCLC8_YSELT_0 VDD VDD pch
+ l=0.06U
+ w=1.44U
M3255 BL_0 XCLC8_WBS_0 XCLC8_WT VSS nch
+ l=0.06U
+ w=0.54U
M3256 BLB_0 XCLC8_WBS_0 XCLC8_WC VSS nch
+ l=0.06U
+	 w=0.54U
M3257 VDD XCLC8_YSELT_0 XCLC8_RBS_0 VDD
+ pch_hvt l=0.06U
+	 w=0.41U
M3258 BL_0 XCLC8_YSELT_0 VDD VDD pch
+ l=0.06U
+ w=0.59U
M3259 BL_0 BLB_0 VDD VDD pch
+ l=0.06U
+ w=0.41U
M3260 BL_0 XCLC8_WBS_0 XCLC8_WT VSS nch
+ l=0.06U
+ w=0.54U
M3261 BLB_0 XCLC8_WBS_0 XCLC8_WC VSS nch
+ l=0.06U
+	 w=0.54U
M3262 VDD XCLC8_RDLB XCLC8_RBS_0 VDD
+ pch_hvt l=0.06U
+	 w=0.41U
M3263 BL_0 XCLC8_YSELT_0 VDD VDD pch
+ l=0.06U
+ w=0.59U
M3264 BL_0 XCLC8_YSELT_0 VDD VDD pch
+ l=0.06U
+ w=0.41U
M3265 BL_0 XCLC8_RBS_0 XCLC8_DT VDD pch
+ l=0.06U
+ w=0.41U
M3266 BL_0 XCLC8_RBS_0 XCLC8_DT VDD pch
+ l=0.06U
+ w=0.41U
M3267 BLB_0 XCLC8_RBS_0 XCLC8_DC VDD pch
+ l=0.06U
+	 w=0.41U
M3268 BLB_0 XCLC8_RBS_0 XCLC8_DC VDD pch
+ l=0.06U
+ w=0.41U
M3269 XCLC8_XND0_0_NET9 XCLC8_RDLB
+ XCLC8_RBS_0 VSS nch_hvt l=0.06U
+ w=0.41U
M3270 VSS XCLC8_YSELT_0 XCLC8_XND0_0_NET9
+ VSS nch_hvt l=0.06U
+	 w=0.41U
M3271 XCLC8_YSELB_0 YSEL_0 VSS VSS nch_hvt
+ l=0.06U
+ w=0.5U
M3272 BL_1 XCLC8_WBS_1 XCLC8_WT VSS nch
+ l=0.06U
+ w=0.54U
M3273 BLB_1 XCLC8_WBS_1 XCLC8_WC VSS nch
+ l=0.06U
+	 w=0.54U
M3274 VDD XCLC8_RDLB XCLC8_RBS_1 VDD
+ pch_hvt l=0.06U
+	 w=0.41U
M3275 BL_1 XCLC8_YSELT_1 VDD VDD pch
+ l=0.06U
+ w=0.59U
M3276 BL_1 XCLC8_YSELT_1 VDD VDD pch
+ l=0.06U
+ w=0.41U
M3277 BL_1 XCLC8_WBS_1 XCLC8_WT VSS nch
+ l=0.06U
+ w=0.54U
M3278 BLB_1 XCLC8_WBS_1 XCLC8_WC VSS nch
+ l=0.06U
+	 w=0.54U
M3279 VDD XCLC8_YSELT_1 XCLC8_RBS_1 VDD
+ pch_hvt l=0.06U
+	 w=0.41U
M3280 BL_1 XCLC8_YSELT_1 VDD VDD pch
+ l=0.06U
+ w=0.59U
M3281 BL_1 BLB_1 VDD VDD pch
+ l=0.06U
+ w=0.41U
M3282 BL_1 XCLC8_WBS_1 XCLC8_WT VSS nch
+ l=0.06U
+ w=0.54U
M3283 BLB_1 XCLC8_WBS_1 XCLC8_WC VSS nch
+ l=0.06U
+	 w=0.54U
M3284 VDD YSEL_1 XCLC8_YSELB_1 VDD pch_hvt
+ l=0.06U
+ w=0.5U
M3285 BL_1 XCLC8_YSELT_1 VDD VDD pch
+ l=0.06U
+ w=1.44U
M3286 BL_1 XCLC8_YSELT_1 BLB_1 VDD pch
+ l=0.06U
+ w=1.8U
M3287 VDD XCLC8_YSELB_1 XCLC8_YSELT_1 VDD
+ pch_hvt l=0.06U
+	 w=0.465U
M3288 VDD XCLC8_YSELT_1 BLB_1 VDD pch
+ l=0.06U
+ w=1.44U
M3289 XCLC8_WBS_1 XCLC8_YSELB_1
+ XCLC8_XNR0_1_NET3 VDD pch l=0.06U
+ w=0.7U
M3290 XCLC8_WBS_1 XCLC8_YSELB_1 VSS VSS
+ nch l=0.06U
+ w=0.35U
M3291 VDD XCLC8_YSELB_1 XCLC8_YSELT_1 VDD
+ pch_hvt l=0.06U
+	 w=0.465U
M3292 VDD XCLC8_YSELT_1 BLB_1 VDD pch
+ l=0.06U
+ w=0.59U
M3293 VDD BL_1 BLB_1 VDD pch
+ l=0.06U
+ w=0.41U
M3294 XCLC8_XNR0_1_NET3 XCLC8_WRTLB VDD
+ VDD pch l=0.06U
+	 w=0.7U
M3295 XCLC8_WBS_1 XCLC8_WRTLB VSS VSS
+ nch l=0.06U
+ w=0.35U
M3296 XCLC8_YSELT_1 XCLC8_YSELB_1 VSS VSS
+ nch_hvt l=0.06U
+ w=0.41U
M3297 VDD XCLC8_YSELB_1 XCLC8_YSELT_1 VDD
+ pch_hvt l=0.06U
+	 w=0.465U
M3298 VDD XCLC8_YSELT_1 BLB_1 VDD pch
+ l=0.06U
+ w=0.59U
M3299 VDD XCLC8_YSELT_1 BLB_1 VDD pch
+ l=0.06U
+ w=0.41U
M3300 XCLC8_XNR0_2_NET3 XCLC8_WRTLB VDD
+ VDD pch l=0.06U
+	 w=0.7U
M3301 BL_1 XCLC8_RBS_1 XCLC8_DT VDD pch
+ l=0.06U
+ w=0.41U
M3302 BL_1 XCLC8_RBS_1 XCLC8_DT VDD pch
+ l=0.06U
+ w=0.41U
M3303 BLB_1 XCLC8_RBS_1 XCLC8_DC VDD pch
+ l=0.06U
+	 w=0.41U
M3304 BLB_1 XCLC8_RBS_1 XCLC8_DC VDD pch
+ l=0.06U
+ w=0.41U
M3305 XCLC8_XND0_1_NET9 XCLC8_RDLB
+ XCLC8_RBS_1 VSS nch_hvt l=0.06U
+ w=0.41U
M3306 VSS XCLC8_YSELT_1 XCLC8_XND0_1_NET9
+ VSS nch_hvt l=0.06U
+	 w=0.41U
M3307 XCLC8_YSELB_1 YSEL_1 VSS VSS nch_hvt
+ l=0.06U
+ w=0.5U
M3308 XCLC8_WBS_2 XCLC8_WRTLB VSS VSS
+ nch l=0.06U
+ w=0.35U
M3309 VDD XCLC8_YSELB_2 XCLC8_YSELT_2 VDD
+ pch_hvt l=0.06U
+	 w=0.465U
M3310 VDD XCLC8_YSELT_2 BLB_2 VDD pch
+ l=0.06U
+ w=0.59U
M3311 VDD XCLC8_YSELT_2 BLB_2 VDD pch
+ l=0.06U
+ w=0.41U
M3312 XCLC8_YSELT_2 XCLC8_YSELB_2 VSS VSS
+ nch_hvt l=0.06U
+	 w=0.41U
M3313 XCLC8_WBS_2 XCLC8_YSELB_2
+ XCLC8_XNR0_2_NET3 VDD pch l=0.06U
+ w=0.7U
M3314 VDD XCLC8_YSELB_2 XCLC8_YSELT_2 VDD
+ pch_hvt l=0.06U
+	 w=0.465U
M3315 VDD XCLC8_YSELT_2 BLB_2 VDD pch
+ l=0.06U
+ w=0.59U
M3316 VDD BL_2 BLB_2 VDD pch
+ l=0.06U
+ w=0.41U
M3317 XCLC8_WBS_2 XCLC8_YSELB_2 VSS VSS
+ nch l=0.06U
+ w=0.35U
M3318 VDD XCLC8_YSELB_2 XCLC8_YSELT_2 VDD
+ pch_hvt l=0.06U
+	 w=0.465U
M3319 VDD XCLC8_YSELT_2 BLB_2 VDD pch
+ l=0.06U
+ w=1.44U
M3320 BL_2 XCLC8_YSELT_2 BLB_2 VDD pch
+ l=0.06U
+ w=1.8U
M3321 BL_2 XCLC8_WBS_2 XCLC8_WT VSS nch
+ l=0.06U
+ w=0.54U
M3322 BLB_2 XCLC8_WBS_2 XCLC8_WC VSS nch
+ l=0.06U
+	 w=0.54U
M3323 VDD YSEL_2 XCLC8_YSELB_2 VDD pch_hvt
+ l=0.06U
+ w=0.5U
M3324 BL_2 XCLC8_YSELT_2 VDD VDD pch
+ l=0.06U
+ w=1.44U
M3325 BL_2 XCLC8_WBS_2 XCLC8_WT VSS nch
+ l=0.06U
+ w=0.54U
M3326 BLB_2 XCLC8_WBS_2 XCLC8_WC VSS nch
+ l=0.06U
+	 w=0.54U
M3327 VDD XCLC8_YSELT_2 XCLC8_RBS_2 VDD
+ pch_hvt l=0.06U
+	 w=0.41U
M3328 BL_2 XCLC8_YSELT_2 VDD VDD pch
+ l=0.06U
+ w=0.59U
M3329 BL_2 BLB_2 VDD VDD pch
+ l=0.06U
+ w=0.41U
M3330 BL_2 XCLC8_WBS_2 XCLC8_WT VSS nch
+ l=0.06U
+ w=0.54U
M3331 BLB_2 XCLC8_WBS_2 XCLC8_WC VSS nch
+ l=0.06U
+	 w=0.54U
M3332 VDD XCLC8_RDLB XCLC8_RBS_2 VDD
+ pch_hvt l=0.06U
+	 w=0.41U
M3333 BL_2 XCLC8_YSELT_2 VDD VDD pch
+ l=0.06U
+ w=0.59U
M3334 BL_2 XCLC8_YSELT_2 VDD VDD pch
+ l=0.06U
+ w=0.41U
M3335 BL_2 XCLC8_RBS_2 XCLC8_DT VDD pch
+ l=0.06U
+ w=0.41U
M3336 BL_2 XCLC8_RBS_2 XCLC8_DT VDD pch
+ l=0.06U
+ w=0.41U
M3337 BLB_2 XCLC8_RBS_2 XCLC8_DC VDD pch
+ l=0.06U
+	 w=0.41U
M3338 BLB_2 XCLC8_RBS_2 XCLC8_DC VDD pch
+ l=0.06U
+ w=0.41U
M3339 XCLC8_XND0_2_NET9 XCLC8_RDLB
+ XCLC8_RBS_2 VSS nch_hvt l=0.06U
+ w=0.41U
M3340 VSS XCLC8_YSELT_2 XCLC8_XND0_2_NET9
+ VSS nch_hvt l=0.06U
+	 w=0.41U
M3341 XCLC8_YSELB_2 YSEL_2 VSS VSS nch_hvt
+ l=0.06U
+ w=0.5U
M3342 BL_3 XCLC8_WBS_3 XCLC8_WT VSS nch
+ l=0.06U
+ w=0.54U
M3343 BLB_3 XCLC8_WBS_3 XCLC8_WC VSS nch
+ l=0.06U
+	 w=0.54U
M3344 VDD XCLC8_RDLB XCLC8_RBS_3 VDD
+ pch_hvt l=0.06U
+	 w=0.41U
M3345 BL_3 XCLC8_YSELT_3 VDD VDD pch
+ l=0.06U
+ w=0.59U
M3346 BL_3 XCLC8_YSELT_3 VDD VDD pch
+ l=0.06U
+ w=0.41U
M3347 BL_3 XCLC8_WBS_3 XCLC8_WT VSS nch
+ l=0.06U
+ w=0.54U
M3348 BLB_3 XCLC8_WBS_3 XCLC8_WC VSS nch
+ l=0.06U
+	 w=0.54U
M3349 VDD XCLC8_YSELT_3 XCLC8_RBS_3 VDD
+ pch_hvt l=0.06U
+	 w=0.41U
M3350 BL_3 XCLC8_YSELT_3 VDD VDD pch
+ l=0.06U
+ w=0.59U
M3351 BL_3 BLB_3 VDD VDD pch
+ l=0.06U
+ w=0.41U
M3352 BL_3 XCLC8_WBS_3 XCLC8_WT VSS nch
+ l=0.06U
+ w=0.54U
M3353 BLB_3 XCLC8_WBS_3 XCLC8_WC VSS nch
+ l=0.06U
+	 w=0.54U
M3354 VDD YSEL_3 XCLC8_YSELB_3 VDD pch_hvt
+ l=0.06U
+ w=0.5U
M3355 BL_3 XCLC8_YSELT_3 VDD VDD pch
+ l=0.06U
+ w=1.44U
M3356 BL_3 XCLC8_YSELT_3 BLB_3 VDD pch
+ l=0.06U
+ w=1.8U
M3357 VDD XCLC8_YSELB_3 XCLC8_YSELT_3 VDD
+ pch_hvt l=0.06U
+	 w=0.465U
M3358 VDD XCLC8_YSELT_3 BLB_3 VDD pch
+ l=0.06U
+ w=1.44U
M3359 XCLC8_WBS_3 XCLC8_YSELB_3
+ XCLC8_XNR0_3_NET3 VDD pch l=0.06U
+ w=0.7U
M3360 XCLC8_WBS_3 XCLC8_YSELB_3 VSS VSS
+ nch l=0.06U
+ w=0.35U
M3361 VDD XCLC8_YSELB_3 XCLC8_YSELT_3 VDD
+ pch_hvt l=0.06U
+	 w=0.465U
M3362 VDD XCLC8_YSELT_3 BLB_3 VDD pch
+ l=0.06U
+ w=0.59U
M3363 VDD BL_3 BLB_3 VDD pch
+ l=0.06U
+ w=0.41U
M3364 XCLC8_XNR0_3_NET3 XCLC8_WRTLB VDD
+ VDD pch l=0.06U
+	 w=0.7U
M3365 XCLC8_WBS_3 XCLC8_WRTLB VSS VSS
+ nch l=0.06U
+ w=0.35U
M3366 XCLC8_YSELT_3 XCLC8_YSELB_3 VSS VSS
+ nch_hvt l=0.06U
+ w=0.41U
M3367 VDD XCLC8_YSELB_3 XCLC8_YSELT_3 VDD
+ pch_hvt l=0.06U
+	 w=0.465U
M3368 VDD XCLC8_YSELT_3 BLB_3 VDD pch
+ l=0.06U
+ w=0.59U
M3369 VDD XCLC8_YSELT_3 BLB_3 VDD pch
+ l=0.06U
+ w=0.41U
M3370 XCLC8_XNR0_4_NET3 XCLC8_WRTLB VDD
+ VDD pch l=0.06U
+	 w=0.7U
M3371 BL_3 XCLC8_RBS_3 XCLC8_DT VDD pch
+ l=0.06U
+ w=0.41U
M3372 BL_3 XCLC8_RBS_3 XCLC8_DT VDD pch
+ l=0.06U
+ w=0.41U
M3373 BLB_3 XCLC8_RBS_3 XCLC8_DC VDD pch
+ l=0.06U
+	 w=0.41U
M3374 BLB_3 XCLC8_RBS_3 XCLC8_DC VDD pch
+ l=0.06U
+ w=0.41U
M3375 XCLC8_XND0_3_NET9 XCLC8_RDLB
+ XCLC8_RBS_3 VSS nch_hvt l=0.06U
+ w=0.41U
M3376 VSS XCLC8_YSELT_3 XCLC8_XND0_3_NET9
+ VSS nch_hvt l=0.06U
+	 w=0.41U
M3377 XCLC8_YSELB_3 YSEL_3 VSS VSS nch_hvt
+ l=0.06U
+ w=0.5U
M3378 XCLC8_WBS_4 XCLC8_WRTLB VSS VSS
+ nch l=0.06U
+ w=0.35U
M3379 VDD XCLC8_YSELB_4 XCLC8_YSELT_4 VDD
+ pch_hvt l=0.06U
+	 w=0.465U
M3380 VDD XCLC8_YSELT_4 BLB_4 VDD pch
+ l=0.06U
+ w=0.59U
M3381 VDD XCLC8_YSELT_4 BLB_4 VDD pch
+ l=0.06U
+ w=0.41U
M3382 XCLC8_YSELT_4 XCLC8_YSELB_4 VSS VSS
+ nch_hvt l=0.06U
+ w=0.41U
M3383 XCLC8_WBS_4 XCLC8_YSELB_4
+ XCLC8_XNR0_4_NET3 VDD pch l=0.06U
+ w=0.7U
M3384 VDD XCLC8_YSELB_4 XCLC8_YSELT_4 VDD
+ pch_hvt l=0.06U
+	 w=0.465U
M3385 VDD XCLC8_YSELT_4 BLB_4 VDD pch
+ l=0.06U
+ w=0.59U
M3386 VDD BL_4 BLB_4 VDD pch
+ l=0.06U
+ w=0.41U
M3387 XCLC8_WBS_4 XCLC8_YSELB_4 VSS VSS
+ nch l=0.06U
+ w=0.35U
M3388 VDD XCLC8_YSELB_4 XCLC8_YSELT_4 VDD
+ pch_hvt l=0.06U
+	 w=0.465U
M3389 VDD XCLC8_YSELT_4 BLB_4 VDD pch
+ l=0.06U
+ w=1.44U
M3390 BL_4 XCLC8_YSELT_4 BLB_4 VDD pch
+ l=0.06U
+ w=1.8U
M3391 BL_4 XCLC8_WBS_4 XCLC8_WT VSS nch
+ l=0.06U
+ w=0.54U
M3392 BLB_4 XCLC8_WBS_4 XCLC8_WC VSS nch
+ l=0.06U
+	 w=0.54U
M3393 VDD YSEL_4 XCLC8_YSELB_4 VDD pch_hvt
+ l=0.06U
+ w=0.5U
M3394 BL_4 XCLC8_YSELT_4 VDD VDD pch
+ l=0.06U
+ w=1.44U
M3395 BL_4 XCLC8_WBS_4 XCLC8_WT VSS nch
+ l=0.06U
+ w=0.54U
M3396 BLB_4 XCLC8_WBS_4 XCLC8_WC VSS nch
+ l=0.06U
+	 w=0.54U
M3397 VDD XCLC8_YSELT_4 XCLC8_RBS_4 VDD
+ pch_hvt l=0.06U
+	 w=0.41U
M3398 BL_4 XCLC8_YSELT_4 VDD VDD pch
+ l=0.06U
+ w=0.59U
M3399 BL_4 BLB_4 VDD VDD pch
+ l=0.06U
+ w=0.41U
M3400 BL_4 XCLC8_WBS_4 XCLC8_WT VSS nch
+ l=0.06U
+ w=0.54U
M3401 BLB_4 XCLC8_WBS_4 XCLC8_WC VSS nch
+ l=0.06U
+	 w=0.54U
M3402 VDD XCLC8_RDLB XCLC8_RBS_4 VDD
+ pch_hvt l=0.06U
+	 w=0.41U
M3403 BL_4 XCLC8_YSELT_4 VDD VDD pch
+ l=0.06U
+ w=0.59U
M3404 BL_4 XCLC8_YSELT_4 VDD VDD pch
+ l=0.06U
+ w=0.41U
M3405 BL_4 XCLC8_RBS_4 XCLC8_DT VDD pch
+ l=0.06U
+ w=0.41U
M3406 BL_4 XCLC8_RBS_4 XCLC8_DT VDD pch
+ l=0.06U
+ w=0.41U
M3407 BLB_4 XCLC8_RBS_4 XCLC8_DC VDD pch
+ l=0.06U
+	 w=0.41U
M3408 BLB_4 XCLC8_RBS_4 XCLC8_DC VDD pch
+ l=0.06U
+ w=0.41U
M3409 XCLC8_XND0_4_NET9 XCLC8_RDLB
+ XCLC8_RBS_4 VSS nch_hvt l=0.06U
+ w=0.41U
M3410 VSS XCLC8_YSELT_4 XCLC8_XND0_4_NET9
+ VSS nch_hvt l=0.06U
+	 w=0.41U
M3411 XCLC8_YSELB_4 YSEL_4 VSS VSS nch_hvt
+ l=0.06U
+ w=0.5U
M3412 BL_5 XCLC8_WBS_5 XCLC8_WT VSS nch
+ l=0.06U
+ w=0.54U
M3413 BLB_5 XCLC8_WBS_5 XCLC8_WC VSS nch
+ l=0.06U
+	 w=0.54U
M3414 VDD XCLC8_RDLB XCLC8_RBS_5 VDD
+ pch_hvt l=0.06U
+	 w=0.41U
M3415 BL_5 XCLC8_YSELT_5 VDD VDD pch
+ l=0.06U
+ w=0.59U
M3416 BL_5 XCLC8_YSELT_5 VDD VDD pch
+ l=0.06U
+ w=0.41U
M3417 BL_5 XCLC8_WBS_5 XCLC8_WT VSS nch
+ l=0.06U
+ w=0.54U
M3418 BLB_5 XCLC8_WBS_5 XCLC8_WC VSS nch
+ l=0.06U
+	 w=0.54U
M3419 VDD XCLC8_YSELT_5 XCLC8_RBS_5 VDD
+ pch_hvt l=0.06U
+	 w=0.41U
M3420 BL_5 XCLC8_YSELT_5 VDD VDD pch
+ l=0.06U
+ w=0.59U
M3421 BL_5 BLB_5 VDD VDD pch
+ l=0.06U
+ w=0.41U
M3422 BL_5 XCLC8_WBS_5 XCLC8_WT VSS nch
+ l=0.06U
+ w=0.54U
M3423 BLB_5 XCLC8_WBS_5 XCLC8_WC VSS nch
+ l=0.06U
+	 w=0.54U
M3424 VDD YSEL_5 XCLC8_YSELB_5 VDD pch_hvt
+ l=0.06U
+ w=0.5U
M3425 BL_5 XCLC8_YSELT_5 VDD VDD pch
+ l=0.06U
+ w=1.44U
M3426 BL_5 XCLC8_YSELT_5 BLB_5 VDD pch
+ l=0.06U
+ w=1.8U
M3427 VDD XCLC8_YSELB_5 XCLC8_YSELT_5 VDD
+ pch_hvt l=0.06U
+	 w=0.465U
M3428 VDD XCLC8_YSELT_5 BLB_5 VDD pch
+ l=0.06U
+ w=1.44U
M3429 XCLC8_WBS_5 XCLC8_YSELB_5
+ XCLC8_XNR0_5_NET3 VDD pch l=0.06U
+ w=0.7U
M3430 XCLC8_WBS_5 XCLC8_YSELB_5 VSS VSS
+ nch l=0.06U
+ w=0.35U
M3431 VDD XCLC8_YSELB_5 XCLC8_YSELT_5 VDD
+ pch_hvt l=0.06U
+	 w=0.465U
M3432 VDD XCLC8_YSELT_5 BLB_5 VDD pch
+ l=0.06U
+ w=0.59U
M3433 VDD BL_5 BLB_5 VDD pch
+ l=0.06U
+ w=0.41U
M3434 XCLC8_XNR0_5_NET3 XCLC8_WRTLB VDD
+ VDD pch l=0.06U
+	 w=0.7U
M3435 XCLC8_WBS_5 XCLC8_WRTLB VSS VSS
+ nch l=0.06U
+ w=0.35U
M3436 XCLC8_YSELT_5 XCLC8_YSELB_5 VSS VSS
+ nch_hvt l=0.06U
+	 w=0.41U
M3437 VDD XCLC8_YSELB_5 XCLC8_YSELT_5 VDD
+ pch_hvt l=0.06U
+	 w=0.465U
M3438 VDD XCLC8_YSELT_5 BLB_5 VDD pch
+ l=0.06U
+ w=0.59U
M3439 VDD XCLC8_YSELT_5 BLB_5 VDD pch
+ l=0.06U
+ w=0.41U
M3440 VDD B_GWDT XCLC8_WT VDD pch
+ l=0.06U
+ w=0.41U
M3441 VDD RDL XCLC8_RDLB VDD pch
+ l=0.06U
+ w=0.7U
M3442 VDD XCLC8_DT XCLC8_DTB VDD pch
+ l=0.06U
+ w=0.7U
M3443 VDD XCLC8_DT XCLC8_DTB VDD
+ pch l=0.06U
+ w=0.7U
M3444 VDD XCLC8_SMPRST XCLC8_DT VDD pch
+ l=0.06U
+ w=0.57U
M3445 VDD XCLC8_SMPRST XCLC8_DT VDD pch
+ l=0.06U
+ w=0.57U
M3446 VDD XCLC8_SMPRST XCLC8_DT VDD pch
+ l=0.06U
+ w=0.41U
M3447 XCLC8_DT XCLC8_DC VDD VDD pch
+ l=0.12U
+ w=0.41U
M3448 XCLC8_DT XCLC8_DC VDD VDD pch
+ l=0.12U
+ w=0.41U
M3449 VDD XCLC8_DT XCLC8_DC VDD pch
+ l=0.12U
+ w=0.41U
M3450 VDD XCLC8_DT XCLC8_DC VDD pch
+ l=0.12U
+ w=0.41U
M3451 XCLC8_DT XCLC8_SMPRST XCLC8_DC VDD
+ pch l=0.06U
+ w=0.41U
M3452 XCLC8_DC XCLC8_SMPRST VDD VDD pch
+ l=0.06U
+ w=0.41U
M3453 XCLC8_DC XCLC8_SMPRST VDD VDD pch
+ l=0.06U
+ w=0.57U
M3454 XCLC8_DC XCLC8_SMPRST VDD VDD pch
+ l=0.06U
+ w=0.57U
M3455 VDD XCLC8_DC XCLC8_DCB VDD pch
+ l=0.06U
+ w=0.7U
M3456 VDD XCLC8_DC XCLC8_DCB VDD
+ pch l=0.06U
+ w=0.7U
M3457 VDD B_GWDC XCLC8_WC VDD pch
+ l=0.06U
+ w=0.41U
M3458 VDD WRTL XCLC8_WRTLB VDD pch
+ l=0.06U
+ w=0.7U
M3459 VDD SMPRSX XCLC8_XNRS_NET3 VDD pch
+ l=0.06U
+ w=0.7U
M3460 VDD SMPRSX XCLC8_SMPRST VDD pch
+ l=0.06U
+ w=0.41U
M3461 VDD SMPRSX XCLC8_SMPRST VDD pch
+ l=0.06U
+ w=0.41U
M3462 XCLC8_XNRS_NET3 SOE XCLC8_SET VDD pch
+ l=0.06U
+ w=0.7U
M3463 XCLC8_XNR0_6_NET3 XCLC8_WRTLB VDD
+ VDD pch l=0.06U
+	 w=0.7U
M3464 BL_5 XCLC8_RBS_5 XCLC8_DT VDD pch
+ l=0.06U
+ w=0.41U
M3465 BL_5 XCLC8_RBS_5 XCLC8_DT VDD pch
+ l=0.06U
+ w=0.41U
M3466 BLB_5 XCLC8_RBS_5 XCLC8_DC VDD pch
+ l=0.06U
+	 w=0.41U
M3467 BLB_5 XCLC8_RBS_5 XCLC8_DC VDD pch
+ l=0.06U
+ w=0.41U
M3468 XCLC8_XND0_5_NET9 XCLC8_RDLB
+ XCLC8_RBS_5 VSS nch_hvt l=0.06U
+ w=0.41U
M3469 VSS XCLC8_YSELT_5 XCLC8_XND0_5_NET9
+ VSS nch_hvt l=0.06U
+	 w=0.41U
M3470 XCLC8_YSELB_5 YSEL_5 VSS VSS nch_hvt
+ l=0.06U
+ w=0.5U
M3471 XCLC8_WBS_6 XCLC8_WRTLB VSS VSS
+ nch l=0.06U
+ w=0.35U
M3472 VDD XCLC8_YSELB_6 XCLC8_YSELT_6 VDD
+ pch_hvt l=0.06U
+	 w=0.465U
M3473 VDD XCLC8_YSELT_6 BLB_6 VDD pch
+ l=0.06U
+ w=0.59U
M3474 VDD XCLC8_YSELT_6 BLB_6 VDD pch
+ l=0.06U
+ w=0.41U
M3475 XCLC8_YSELT_6 XCLC8_YSELB_6 VSS VSS
+ nch_hvt l=0.06U
+ w=0.41U
M3476 XCLC8_WBS_6 XCLC8_YSELB_6
+ XCLC8_XNR0_6_NET3 VDD pch l=0.06U
+ w=0.7U
M3477 VDD XCLC8_YSELB_6 XCLC8_YSELT_6 VDD
+ pch_hvt l=0.06U
+	 w=0.465U
M3478 VDD XCLC8_YSELT_6 BLB_6 VDD pch
+ l=0.06U
+ w=0.59U
M3479 VDD BL_6 BLB_6 VDD pch
+ l=0.06U
+ w=0.41U
M3480 XCLC8_WBS_6 XCLC8_YSELB_6 VSS VSS
+ nch l=0.06U
+ w=0.35U
M3481 VDD XCLC8_YSELB_6 XCLC8_YSELT_6 VDD
+ pch_hvt l=0.06U
+	 w=0.465U
M3482 VDD XCLC8_YSELT_6 BLB_6 VDD pch
+ l=0.06U
+ w=1.44U
M3483 BL_6 XCLC8_YSELT_6 BLB_6 VDD pch
+ l=0.06U
+ w=1.8U
M3484 BL_6 XCLC8_WBS_6 XCLC8_WT VSS nch
+ l=0.06U
+ w=0.54U
M3485 BLB_6 XCLC8_WBS_6 XCLC8_WC VSS nch
+ l=0.06U
+	 w=0.54U
M3486 VDD YSEL_6 XCLC8_YSELB_6 VDD pch_hvt
+ l=0.06U
+ w=0.5U
M3487 BL_6 XCLC8_YSELT_6 VDD VDD pch
+ l=0.06U
+ w=1.44U
M3488 BL_6 XCLC8_WBS_6 XCLC8_WT VSS nch
+ l=0.06U
+ w=0.54U
M3489 BLB_6 XCLC8_WBS_6 XCLC8_WC VSS nch
+ l=0.06U
+	 w=0.54U
M3490 VDD XCLC8_YSELT_6 XCLC8_RBS_6 VDD
+ pch_hvt l=0.06U
+	 w=0.41U
M3491 BL_6 XCLC8_YSELT_6 VDD VDD pch
+ l=0.06U
+ w=0.59U
M3492 BL_6 BLB_6 VDD VDD pch
+ l=0.06U
+ w=0.41U
M3493 BL_6 XCLC8_WBS_6 XCLC8_WT VSS nch
+ l=0.06U
+ w=0.54U
M3494 BLB_6 XCLC8_WBS_6 XCLC8_WC VSS nch
+ l=0.06U
+	 w=0.54U
M3495 VDD XCLC8_RDLB XCLC8_RBS_6 VDD
+ pch_hvt l=0.06U
+	 w=0.41U
M3496 BL_6 XCLC8_YSELT_6 VDD VDD pch
+ l=0.06U
+ w=0.59U
M3497 BL_6 XCLC8_YSELT_6 VDD VDD pch
+ l=0.06U
+ w=0.41U
M3498 BL_6 XCLC8_RBS_6 XCLC8_DT VDD pch
+ l=0.06U
+ w=0.41U
M3499 BL_6 XCLC8_RBS_6 XCLC8_DT VDD pch
+ l=0.06U
+ w=0.41U
M3500 BLB_6 XCLC8_RBS_6 XCLC8_DC VDD pch
+ l=0.06U
+	 w=0.41U
M3501 BLB_6 XCLC8_RBS_6 XCLC8_DC VDD pch
+ l=0.06U
+ w=0.41U
M3502 XCLC8_XND0_6_NET9 XCLC8_RDLB
+ XCLC8_RBS_6 VSS nch_hvt l=0.06U
+ w=0.41U
M3503 VSS XCLC8_YSELT_6 XCLC8_XND0_6_NET9
+ VSS nch_hvt l=0.06U
+	 w=0.41U
M3504 XCLC8_YSELB_6 YSEL_6 VSS VSS nch_hvt
+ l=0.06U
+ w=0.5U
M3505 BL_7 XCLC8_WBS_7 XCLC8_WT VSS nch
+ l=0.06U
+ w=0.54U
M3506 BLB_7 XCLC8_WBS_7 XCLC8_WC VSS nch
+ l=0.06U
+	 w=0.54U
M3507 VDD XCLC8_RDLB XCLC8_RBS_7 VDD
+ pch_hvt l=0.06U
+	 w=0.41U
M3508 BL_7 XCLC8_YSELT_7 VDD VDD pch
+ l=0.06U
+ w=0.59U
M3509 BL_7 XCLC8_YSELT_7 VDD VDD pch
+ l=0.06U
+ w=0.41U
M3510 BL_7 XCLC8_WBS_7 XCLC8_WT VSS nch
+ l=0.06U
+ w=0.54U
M3511 BLB_7 XCLC8_WBS_7 XCLC8_WC VSS nch
+ l=0.06U
+	 w=0.54U
M3512 VDD XCLC8_YSELT_7 XCLC8_RBS_7 VDD
+ pch_hvt l=0.06U
+	 w=0.41U
M3513 BL_7 XCLC8_YSELT_7 VDD VDD pch
+ l=0.06U
+ w=0.59U
M3514 BL_7 BLB_7 VDD VDD pch
+ l=0.06U
+ w=0.41U
M3515 BL_7 XCLC8_WBS_7 XCLC8_WT VSS nch
+ l=0.06U
+ w=0.54U
M3516 BLB_7 XCLC8_WBS_7 XCLC8_WC VSS nch
+ l=0.06U
+	 w=0.54U
M3517 VDD YSEL_7 XCLC8_YSELB_7 VDD pch_hvt
+ l=0.06U
+ w=0.5U
M3518 BL_7 XCLC8_YSELT_7 VDD VDD pch
+ l=0.06U
+ w=1.44U
M3519 BL_7 XCLC8_YSELT_7 BLB_7 VDD pch
+ l=0.06U
+ w=1.8U
M3520 VDD XCLC8_YSELB_7 XCLC8_YSELT_7 VDD
+ pch_hvt l=0.06U
+	 w=0.465U
M3521 VDD XCLC8_YSELT_7 BLB_7 VDD pch
+ l=0.06U
+ w=1.44U
M3522 XCLC8_WBS_7 XCLC8_YSELB_7
+ XCLC8_XNR0_7_NET3 VDD pch l=0.06U
+ w=0.7U
M3523 XCLC8_WBS_7 XCLC8_YSELB_7 VSS VSS
+ nch l=0.06U
+ w=0.35U
M3524 VDD XCLC8_YSELB_7 XCLC8_YSELT_7 VDD
+ pch_hvt l=0.06U
+ w=0.465U
M3525 VDD XCLC8_YSELT_7 BLB_7 VDD pch
+ l=0.06U
+ w=0.59U
M3526 VDD BL_7 BLB_7 VDD pch
+ l=0.06U
+ w=0.41U
M3527 XCLC8_XNR0_7_NET3 XCLC8_WRTLB VDD
+ VDD pch l=0.06U
+ w=0.7U
M3528 XCLC8_WBS_7 XCLC8_WRTLB VSS VSS
+ nch l=0.06U
+ w=0.35U
M3529 XCLC8_YSELT_7 XCLC8_YSELB_7 VSS VSS
+ nch_hvt l=0.06U
+ w=0.41U
M3530 VDD XCLC8_YSELB_7 XCLC8_YSELT_7 VDD
+ pch_hvt l=0.06U
+ w=0.465U
M3531 VDD XCLC8_YSELT_7 BLB_7 VDD pch
+ l=0.06U
+ w=0.59U
M3532 VDD XCLC8_YSELT_7 BLB_7 VDD pch
+ l=0.06U
+ w=0.41U
M3533 XCLC8_WT B_GWDT VSS VSS nch
+ l=0.07U
+ w=1U
M3534 XCLC8_WT B_GWDT VSS VSS nch
+ l=0.07U
+ w=1U
M3535 XCLC8_RDLB RDL VSS VSS nch
+ l=0.06U
+ w=0.45U
M3536 VSS XCLC8_DCB B_GRDC VSS nch
+ l=0.06U
+ w=0.8U
M3537 VSS XCLC8_DCB B_GRDC VSS nch
+ l=0.06U
+ w=0.8U
M3538 XCLC8_DCB XCLC8_DC VSS VSS nch
+ l=0.06U
+ w=0.41U
M3539 XCLC8_DTB XCLC8_DT VSS VSS nch
+ l=0.06U
+ w=0.41U
M3540 B_GRDT XCLC8_DTB VSS VSS nch
+ l=0.06U
+ w=0.8U
M3541 B_GRDT XCLC8_DTB VSS VSS nch
+ l=0.06U
+ w=0.8U
M3542 B_GRDT XCLC8_DTB VSS VSS nch
+ l=0.06U
+ w=0.8U
M3543 B_GRDT XCLC8_DTB VSS VSS nch
+ l=0.06U
+ w=0.8U
M3544 XCLC8_NET18 XCLC8_DC XCLC8_DT VSS
+ nch l=0.12U
+ w=0.7U
M3545 XCLC8_NET18 XCLC8_DC XCLC8_DT VSS
+ nch l=0.12U
+ w=0.7U
M3546 XCLC8_NET18 XCLC8_SET VSS VSS nch
+ l=0.08U
+ w=0.7U
M3547 VSS XCLC8_DCB B_GRDC VSS nch
+ l=0.06U
+ w=0.8U
M3548 XCLC8_DC XCLC8_DT XCLC8_NET18 VSS
+ nch l=0.12U
+ w=0.7U
M3549 XCLC8_DC XCLC8_DT XCLC8_NET18 VSS
+ nch l=0.12U
+ w=0.7U
M3550 XCLC8_NET18 XCLC8_SET VSS VSS nch
+ l=0.08U
+ w=0.7U
M3551 VSS XCLC8_DCB B_GRDC VSS nch
+ l=0.06U
+ w=0.8U
M3552 XCLC8_WRTLB WRTL VSS VSS nch
+ l=0.06U
+ w=0.45U
M3553 XCLC8_SMPRST SMPRSX VSS VSS nch
+ l=0.06U
+ w=0.41U
M3554 XCLC8_SET SMPRSX VSS VSS nch
+ l=0.06U
+ w=0.41U
M3555 XCLC8_SET SOE VSS VSS nch
+ l=0.06U
+ w=0.41U
M3556 XCLC8_WC B_GWDC VSS VSS nch
+ l=0.07U
+ w=1U
M3557 XCLC8_WC B_GWDC VSS VSS nch
+ l=0.07U
+ w=1U
M3558 BL_7 XCLC8_RBS_7 XCLC8_DT VDD pch
+ l=0.06U
+ w=0.41U
M3559 BL_7 XCLC8_RBS_7 XCLC8_DT VDD pch
+ l=0.06U
+ w=0.41U
M3560 BLB_7 XCLC8_RBS_7 XCLC8_DC VDD pch
+ l=0.06U
+	 w=0.41U
M3561 BLB_7 XCLC8_RBS_7 XCLC8_DC VDD pch
+ l=0.06U
+ w=0.41U
M3562 XCLC8_XND0_7_NET9 XCLC8_RDLB
+ XCLC8_RBS_7 VSS nch_hvt l=0.06U
+ w=0.41U
M3563 VSS XCLC8_YSELT_7 XCLC8_XND0_7_NET9
+ VSS nch_hvt l=0.06U
+	 w=0.41U
M3564 XCLC8_YSELB_7 YSEL_7 VSS VSS nch_hvt
+ l=0.06U
+ w=0.5U
.ENDS
* CTRL2P
.SUBCKT SDL400W20S_NCTRL2P AA_15 AA_14 AA_13 AA_12 AA_11 AA_10 AA_9 AA_8
+	 AA_7 AA_6 AA_5 AA_4 AA_3 AA_2 AA_1 AA_0 AB_15 AB_14 AB_13
+	 AB_12 AB_11 AB_10 AB_9 AB_8 AB_7 AB_6 AB_5 AB_4 AB_3 AB_2
+	 AB_1 AB_0 AMA_15 AMA_14 AMA_13 AMA_12 AMA_11 AMA_10 AMA_9
+	 AMA_8 AMA_7 AMA_6 AMA_5 AMA_4 AMA_3 AMA_2 AMA_1 AMA_0 AMB_15
+	 AMB_14 AMB_13 AMB_12 AMB_11 AMB_10 AMB_9 AMB_8 AMB_7 AMB_6
+	 AMB_5 AMB_4 AMB_3 AMB_2 AMB_1 AMB_0 AWT A_DWLF BIST B_DWLF
+	 CEBA CEBB CEBMA CEBMB CLKA CLKB CLKM TM VB_2 VB_1 VB_0 VD_1
+	 VD_0 VR_1 VR_0 VS_1 VS_0 VW_1 VW_0 WEBA WEBB WEBMA WEBMB
+	 A_CKD A_DLRS A_DWL A_GCDEC_3 A_GCDEC_2 A_GCDEC_1 A_GCDEC_0
+	 A_RD A_WENB_3 A_WENB_2 A_WENB_1 A_WENB_0 A_WRT A_XA_7 A_XA_6
+	 A_XA_5 A_XA_4 A_XA_3 A_XA_2 A_XA_1 A_XA_0 A_XB_3 A_XB_2
+	 A_XB_1 A_XB_0 A_XC_7 A_XC_6 A_XC_5 A_XC_4 A_XC_3 A_XC_2
+	 A_XC_1 A_XC_0 A_Y_7 A_Y_6 A_Y_5 A_Y_4 A_Y_3 A_Y_2 A_Y_1 A_Y_0
+	 A_Z_7 A_Z_6 A_Z_5 A_Z_4 A_Z_3 A_Z_2 A_Z_1 A_Z_0 B_CKD B_DLRS
+	 B_DWL B_GCDEC_3 B_GCDEC_2 B_GCDEC_1 B_GCDEC_0 B_RD B_WENB_3
+	 B_WENB_2 B_WENB_1 B_WENB_0 B_WRT B_XA_7 B_XA_6 B_XA_5 B_XA_4
+	 B_XA_3 B_XA_2 B_XA_1 B_XA_0 B_XB_3 B_XB_2 B_XB_1 B_XB_0
+	 B_XC_7 B_XC_6 B_XC_5 B_XC_4 B_XC_3 B_XC_2 B_XC_1 B_XC_0 B_Y_7
+	 B_Y_6 B_Y_5 B_Y_4 B_Y_3 B_Y_2 B_Y_1 B_Y_0 B_Z_7 B_Z_6 B_Z_5
+	 B_Z_4 B_Z_3 B_Z_2 B_Z_1 B_Z_0 AWTI A_DBL BISTC BISTT B_DBL
+	 VHI VLO
M3565 BISTC BIST VSS VSS nch
+ l=0.06U
+ w=1.5U
M3566 XCTRLA_XDEC3DZ_6_Z4 XCTRLA_AT_15 VSS
+ VSS nch l=0.06U
+ w=2U
M3567 XCTRLA_XDEC3DZ_7_Z4 XCTRLA_AT_15 VSS
+ VSS nch l=0.06U
+ w=2U
M3568 VDD XCTRLA_AT_15 XCTRLA_XDEC3DZ_6_Z1
+ VDD pch l=0.06U
+ w=0.21U
M3569 VDD XCTRLA_AT_15 XCTRLA_XDEC3DZ_7_Z1
+ VDD pch l=0.06U
+ w=0.21U
M3570 VDD XCTRLA_RSP XCTRLA_XDEC3DZ_6_Z1
+ VDD pch l=0.06U
+ w=0.75U
M3571 VDD XCTRLA_XDEC3DZ_6_Z1 A_Z_6
+ VDD pch_hvt l=0.06U
+ w=5U
M3572 XCTRLA_XDEC3DZ_6_Z3 XCTRLA_AT_14
+ XCTRLA_XDEC3DZ_6_Z4 VSS nch l=0.06U
+ w=2U
M3573 XCTRLA_XDEC3DZ_7_Z3 XCTRLA_AT_14
+ XCTRLA_XDEC3DZ_7_Z4 VSS nch l=0.06U
+ w=2U
M3574 BISTC BIST VSS VSS nch
+ l=0.06U
+ w=1.5U
M3575 VDD XCTRLA_AT_14 XCTRLA_XDEC3DZ_6_Z1
+ VDD pch l=0.06U
+ w=0.21U
M3576 VDD XCTRLA_AT_14 XCTRLA_XDEC3DZ_7_Z1
+ VDD pch l=0.06U
+ w=0.21U
M3577 VDD XCTRLA_RSP XCTRLA_XDEC3DZ_6_Z1
+ VDD pch l=0.06U
+ w=0.75U
M3578 VDD XCTRLA_XDEC3DZ_6_Z1 A_Z_6
+ VDD pch_hvt l=0.06U
+ w=5U
M3579 XCTRLA_XDEC3DZ_6_Z3 XCTRLA_AC_13
+ XCTRLA_XDEC3DZ_6_Z2 VSS nch l=0.06U
+ w=2U
M3580 XCTRLA_XDEC3DZ_7_Z3 XCTRLA_AT_13
+ XCTRLA_XDEC3DZ_7_Z2 VSS nch l=0.06U
+ w=2U
M3581 BISTT BISTC VSS VSS nch
+ l=0.06U
+ w=0.38U
M3582 BISTT BISTC VSS VSS nch
+ l=0.06U
+ w=0.55U
M3583 VDD XCTRLA_AC_13 XCTRLA_XDEC3DZ_6_Z1
+ VDD pch l=0.06U
+ w=0.21U
M3584 VDD XCTRLA_AT_13 XCTRLA_XDEC3DZ_7_Z1
+ VDD pch l=0.06U
+ w=0.21U
M3585 VDD XCTRLA_RSP XCTRLA_XDEC3DZ_7_Z1
+ VDD pch l=0.06U
+ w=0.75U
M3586 VDD XCTRLA_XDEC3DZ_7_Z1 A_Z_7
+ VDD pch_hvt l=0.06U
+ w=5U
M3587 XCTRLA_XDEC3DZ_6_Z1 XCTRLA_CKP
+ XCTRLA_XDEC3DZ_6_Z2 VSS nch l=0.06U
+ w=2U
M3588 XCTRLA_XDEC3DZ_7_Z1 XCTRLA_CKP
+ XCTRLA_XDEC3DZ_7_Z2 VSS nch l=0.06U
+ w=2U
M3589 BISTT BISTC VSS VSS nch
+ l=0.06U
+ w=0.55U
M3590 VDD XCTRLA_CKP XCTRLA_XDEC3DZ_6_Z1
+ VDD pch l=0.06U
+ w=0.21U
M3591 VDD XCTRLA_CKP XCTRLA_XDEC3DZ_7_Z1
+ VDD pch l=0.06U
+ w=0.21U
M3592 VDD XCTRLA_RSP XCTRLA_XDEC3DZ_7_Z1
+ VDD pch l=0.06U
+ w=0.75U
M3593 VDD XCTRLA_XDEC3DZ_7_Z1 A_Z_7
+ VDD pch_hvt l=0.06U
+ w=5U
M3594 BISTT BISTC VSS VSS nch
+ l=0.06U
+ w=0.38U
M3595 VDD BISTC BISTT VDD pch
+ l=0.06U
+ w=1.92U
M3596 VDD BISTC BISTT VDD pch
+ l=0.06U
+ w=1.92U
M3597 VDD BIST BISTC VDD pch
+ l=0.06U
+ w=1.92U
M3598 VDD BIST BISTC VDD pch
+ l=0.06U
+ w=1.92U
M3599 VDD BISTC BISTT VDD pch
+ l=0.06U
+ w=1.1U
M3600 VDD BISTC BISTT VDD pch
+ l=0.06U
+ w=1.1U
M3601 VDD BIST BISTC VDD pch
+ l=0.06U
+ w=1.1U
M3602 VDD BIST BISTC VDD pch
+ l=0.06U
+ w=1.1U
M3603 XCTRLA_XALTCH_15_Z28 XCTRLA_AC_15 VDD
+ VDD pch l=0.06U
+ w=0.21U
M3604 XCTRLA_XALTCH_15_Z22 AMA_15 VDD VDD
+ pch l=0.08U
+ w=0.42U
M3605 XCTRLA_XALTCH_15_Z27 XCTRLA_CKC VSS
+ VSS nch l=0.06U
+ w=0.21U
M3606 XCTRLA_AC_15 XCTRLA_XALTCH_15_Z1
+ VSS VSS nch l=0.06U
+ w=0.55U
M3607 VDD XCTRLA_XALTCH_15_Z1
+ XCTRLA_AC_15 VDD pch l=0.06U
+ w=1.1U
M3608 VDD XCTRLA_CKP XCTRLA_XDEC3DZ_4_Z1
+ VDD pch l=0.06U
+ w=0.21U
M3609 VDD XCTRLA_CKP XCTRLA_XDEC3DZ_5_Z1
+ VDD pch l=0.06U
+ w=0.21U
M3610 VDD XCTRLA_RSP XCTRLA_XDEC3DZ_5_Z1
+ VDD pch l=0.06U
+ w=0.75U
M3611 VDD XCTRLA_XDEC3DZ_5_Z1 A_Z_5
+ VDD pch_hvt l=0.06U
+ w=5U
M3612 XCTRLA_XDEC3DZ_4_Z2 XCTRLA_CKP
+ XCTRLA_XDEC3DZ_4_Z1 VSS nch l=0.06U
+ w=2U
M3613 XCTRLA_XDEC3DZ_5_Z2 XCTRLA_CKP
+ XCTRLA_XDEC3DZ_5_Z1 VSS nch l=0.06U
+ w=2U
M3614 XCTRLA_XALTCH_15_Z22 BISTC
+ XCTRLA_XALTCH_15_AX VDD pch l=0.08U
+ w=0.42U
M3615 XCTRLA_AC_15 XCTRLA_XALTCH_15_Z1
+ VSS VSS nch l=0.06U
+ w=0.55U
M3616 VDD XCTRLA_XALTCH_15_Z1
+ XCTRLA_AC_15 VDD pch l=0.06U
+ w=1.1U
M3617 VDD XCTRLA_AC_13 XCTRLA_XDEC3DZ_4_Z1
+ VDD pch l=0.06U
+ w=0.21U
M3618 VDD XCTRLA_AT_13 XCTRLA_XDEC3DZ_5_Z1
+ VDD pch l=0.06U
+ w=0.21U
M3619 VDD XCTRLA_RSP XCTRLA_XDEC3DZ_5_Z1
+ VDD pch l=0.06U
+ w=0.75U
M3620 VDD XCTRLA_XDEC3DZ_5_Z1 A_Z_5
+ VDD pch_hvt l=0.06U
+ w=5U
M3621 XCTRLA_XALTCH_15_Z28 XCTRLA_CKC
+ XCTRLA_XALTCH_15_Z1 VDD pch l=0.06U
+ w=0.21U
M3622 XCTRLA_XALTCH_15_Z1 XCTRLA_XALTCH_15_AX
+ XCTRLA_XALTCH_15_Z27 VSS nch l=0.08U
+ w=0.21U
M3623 XCTRLA_XDEC3DZ_4_Z3 XCTRLA_AC_13
+ XCTRLA_XDEC3DZ_4_Z2 VSS nch l=0.06U
+ w=2U
M3624 XCTRLA_XDEC3DZ_5_Z3 XCTRLA_AT_13
+ XCTRLA_XDEC3DZ_5_Z2 VSS nch l=0.06U
+ w=2U
M3625 XCTRLA_XALTCH_15_Z26 XCTRLA_CKP
+ XCTRLA_XALTCH_15_Z1 VSS nch l=0.06U
+ w=0.21U
M3626 XCTRLA_XALTCH_15_Z21 BISTT
+ XCTRLA_XALTCH_15_AX VDD pch l=0.08U
+ w=0.42U
M3627 XCTRLA_XALTCH_15_Z25 XCTRLA_XALTCH_15_AX
+ XCTRLA_XALTCH_15_Z1 VDD pch l=0.08U
+ w=0.42U
M3628 XCTRLA_XDEC3DZ_4_Z4 XCTRLA_AC_14
+ XCTRLA_XDEC3DZ_4_Z3 VSS nch l=0.06U
+ w=2U
M3629 XCTRLA_XDEC3DZ_5_Z4 XCTRLA_AC_14
+ XCTRLA_XDEC3DZ_5_Z3 VSS nch l=0.06U
+ w=2U
M3630 XCTRLA_AT_15 XCTRLA_AC_15 VSS
+ VSS nch l=0.06U
+ w=0.55U
M3631 VDD XCTRLA_AC_15 XCTRLA_AT_15
+ VDD pch l=0.06U
+ w=1.1U
M3632 VDD XCTRLA_AC_14 XCTRLA_XDEC3DZ_4_Z1
+ VDD pch l=0.06U
+ w=0.21U
M3633 VDD XCTRLA_AC_14 XCTRLA_XDEC3DZ_5_Z1
+ VDD pch l=0.06U
+ w=0.21U
M3634 VDD XCTRLA_RSP XCTRLA_XDEC3DZ_4_Z1
+ VDD pch l=0.06U
+ w=0.75U
M3635 VDD XCTRLA_XDEC3DZ_4_Z1 A_Z_4
+ VDD pch_hvt l=0.06U
+ w=5U
M3636 VDD AA_15 XCTRLA_XALTCH_15_Z21 VDD
+ pch l=0.08U
+ w=0.42U
M3637 XCTRLA_AT_15 XCTRLA_AC_15 VSS
+ VSS nch l=0.06U
+	 w=0.55U
M3638 VDD XCTRLA_AC_15 XCTRLA_AT_15
+ VDD pch l=0.06U
+ w=1.1U
M3639 VDD XCTRLA_AT_15 XCTRLA_XDEC3DZ_4_Z1
+ VDD pch l=0.06U
+ w=0.21U
M3640 VDD XCTRLA_AT_15 XCTRLA_XDEC3DZ_5_Z1
+ VDD pch l=0.06U
+ w=0.21U
M3641 VDD XCTRLA_RSP XCTRLA_XDEC3DZ_4_Z1
+ VDD pch l=0.06U
+ w=0.75U
M3642 VDD XCTRLA_XDEC3DZ_4_Z1 A_Z_4
+ VDD pch_hvt l=0.06U
+ w=5U
M3643 VDD XCTRLA_CKP XCTRLA_XALTCH_15_Z25
+ VDD pch l=0.06U
+ w=0.42U
M3644 XCTRLA_XDEC3DZ_4_Z4 XCTRLA_AT_15 VSS
+ VSS nch l=0.06U
+ w=2U
M3645 XCTRLA_XDEC3DZ_5_Z4 XCTRLA_AT_15 VSS
+ VSS nch l=0.06U
+ w=2U
M3646 VSS XCTRLA_AC_15 XCTRLA_XALTCH_15_Z26
+ VSS nch l=0.06U
+ w=0.21U
M3647 VDD A_DWLF A_DBL VDD pch
+ l=0.06U
+ w=1.5U
M3648 VDD A_DWLF A_DBL VDD pch
+ l=0.06U
+ w=1.5U
M3649 VDD A_DWLF A_DBL VDD pch
+ l=0.06U
+ w=1.5U
M3650 VDD A_DWLF A_DBL VDD pch
+ l=0.06U
+ w=1.5U
M3651 XCTRLA_XDBLDG_NC_P1_7 VHI
+ XCTRLA_XDBLDG_XDBLD5_3_Z1 VDD pchpu_hvtdpsr
+ l=0.07U w=0.09U
M3652 XCTRLA_XDBLDG_XDBLD5_3_NC_P0
+	XCTRLA_XDBLDG_XDBLD5_3_Z1 VDD VDD pchpu_hvtdpsr
+ l=0.07U
+	 w=0.09U
M3653 XCTRLA_XDBLDG_NC_P1_6 VHI
+ XCTRLA_XDBLDG_XDBLD5_1_Z1 VDD pchpu_hvtdpsr
+ l=0.07U w=0.09U
M3654 XCTRLA_XDBLDG_XDBLD5_1_NC_P0
+	XCTRLA_XDBLDG_XDBLD5_1_Z1 VDD VDD pchpu_hvtdpsr
+ l=0.07U
+	 w=0.09U
M3655 XCTRLA_XDBLDG_NC_P1_6 VHI
+ XCTRLA_XDBLDG_XDBLD5_2_Z1 VDD pchpu_hvtdpsr
+ l=0.07U w=0.09U
M3656 XCTRLA_XDBLDG_XDBLD5_2_NC_P0
+	XCTRLA_XDBLDG_XDBLD5_2_Z1 VDD VDD pchpu_hvtdpsr
+ l=0.07U
+	 w=0.09U
M3657 XCTRLA_XDBLDG_XDBLD5_0_NC_P0
+	XCTRLA_XDBLDG_XDBLD5_0_Z1 VDD VDD pchpu_hvtdpsr
+ l=0.07U
+	 w=0.09U
M3658 XCTRLA_XDBLDG_NC_P1_5 VB_2
+ XCTRLA_XDBLDG_XDBLD4_3_Z1 VDD pchpu_hvtdpsr
+ l=0.07U w=0.09U
M3659 XCTRLA_XDBLDG_XDBLD4_3_NC_P0
+	XCTRLA_XDBLDG_XDBLD4_3_Z1 VDD VDD pchpu_hvtdpsr
+ l=0.07U
+	 w=0.09U
M3660 XCTRLA_XDBLDG_NC_P1_5 VHI
+ XCTRLA_XDBLDG_XDBLD5_0_Z1 VDD pchpu_hvtdpsr
+ l=0.07U w=0.09U
M3661 XCTRLA_XDBLDG_XDBLD4_1_NC_P0
+	XCTRLA_XDBLDG_XDBLD4_1_Z1 VDD VDD pchpu_hvtdpsr
+ l=0.07U
+	 w=0.09U
M3662 XCTRLA_XDBLDG_NC_P1_4 VB_2
+ XCTRLA_XDBLDG_XDBLD4_1_Z1 VDD pchpu_hvtdpsr
+ l=0.07U w=0.09U
M3663 XCTRLA_XDBLDG_NC_P1_4 VB_2
+ XCTRLA_XDBLDG_XDBLD4_2_Z1 VDD pchpu_hvtdpsr
+ l=0.07U w=0.09U
M3664 XCTRLA_XDBLDG_XDBLD4_2_NC_P0
+	XCTRLA_XDBLDG_XDBLD4_2_Z1 VDD VDD pchpu_hvtdpsr
+ l=0.07U
+	 w=0.09U
M3665 XCTRLA_XDBLDG_NC_P1_3 VB_2
+ XCTRLA_XDBLDG_XDBLD4_0_Z1 VDD pchpu_hvtdpsr
+ l=0.07U w=0.09U
M3666 XCTRLA_XDBLDG_XDBLD4_0_NC_P0
+	XCTRLA_XDBLDG_XDBLD4_0_Z1 VDD VDD pchpu_hvtdpsr
+ l=0.07U
+	 w=0.09U
M3667 XCTRLA_XDBLDG_XDBLD3_0_NC_P0
+	XCTRLA_XDBLDG_XDBLD3_0_Z1 VDD VDD pchpu_hvtdpsr
+ l=0.07U
+	 w=0.09U
M3668 XCTRLA_XDBLDG_NC_P1_3 VB_1
+ XCTRLA_XDBLDG_XDBLD3_1_Z1 VDD pchpu_hvtdpsr
+ l=0.07U w=0.09U
M3669 XCTRLA_XDBLDG_XDBLD3_1_NC_P0
+	XCTRLA_XDBLDG_XDBLD3_1_Z1 VDD VDD pchpu_hvtdpsr
+ l=0.07U
+	 w=0.09U
M3670 XCTRLA_XDBLDG_NC_P1_2 VB_1
+ XCTRLA_XDBLDG_XDBLD3_0_Z1 VDD pchpu_hvtdpsr
+ l=0.07U w=0.09U
M3671 XCTRLA_XDBLDG_XDBLD1_1_NC_P0
+	XCTRLA_XDBLDG_XDBLD1_1_Z1 VDD VDD pchpu_hvtdpsr
+ l=0.07U
+	 w=0.09U
M3672 XCTRLA_XDBLDG_NC_P1_2 VB_0
+ XCTRLA_XDBLDG_XDBLD2_Z1 VDD pchpu_hvtdpsr
+ l=0.07U w=0.09U
M3673 XCTRLA_XDBLDG_XDBLD2_NC_P0
+ XCTRLA_XDBLDG_XDBLD2_Z1 VDD VDD pchpu_hvtdpsr
+ l=0.07U w=0.09U
M3674 XCTRLA_XDBLDG_NC_P1_1 VD_1
+ XCTRLA_XDBLDG_XDBLD1_1_Z1 VDD pchpu_hvtdpsr
+ l=0.07U w=0.09U
M3675 XCTRLA_XDBLDG_XDBLD0_NC_P0
+ XCTRLA_XDBLDG_XDBLD0_Z1 VDD VDD pchpu_hvtdpsr
+ l=0.07U w=0.09U
M3676 XCTRLA_XDBLDG_NC_P1_1 VD_1
+ XCTRLA_XDBLDG_XDBLD1_0_Z1 VDD pchpu_hvtdpsr
+ l=0.07U w=0.09U
M3677 XCTRLA_XDBLDG_XDBLD1_0_NC_P0
+	XCTRLA_XDBLDG_XDBLD1_0_Z1 VDD VDD pchpu_hvtdpsr
+ l=0.07U
+	 w=0.09U
M3678 XCTRLA_XDBLDG_NC_P1_0 VD_0
+ XCTRLA_XDBLDG_XDBLD0_Z1 VDD pchpu_hvtdpsr
+ l=0.07U w=0.09U
M3679 XCTRLA_XDEC3DZ_2_Z4 XCTRLA_AC_15 VSS
+ VSS nch l=0.06U
+ w=2U
M3680 XCTRLA_XDEC3DZ_3_Z4 XCTRLA_AC_15 VSS
+ VSS nch l=0.06U
+ w=2U
M3681 XCTRLA_XALTCH_14_Z26 XCTRLA_AC_14 VSS
+ VSS nch l=0.06U
+ w=0.21U
M3682 VDD XCTRLA_CKP XCTRLA_XALTCH_14_Z25
+ VDD pch l=0.06U
+ w=0.42U
M3683 XCTRLA_XALTCH_14_Z21 AA_14 VDD VDD
+ pch l=0.08U
+ w=0.42U
M3684 XCTRLA_AT_14 XCTRLA_AC_14 VSS
+ VSS nch l=0.06U
+ w=0.55U
M3685 VDD XCTRLA_AC_14 XCTRLA_AT_14
+ VDD pch l=0.06U
+ w=1.1U
M3686 VDD XCTRLA_AC_15 XCTRLA_XDEC3DZ_2_Z1
+ VDD pch l=0.06U
+ w=0.21U
M3687 VDD XCTRLA_AC_15 XCTRLA_XDEC3DZ_3_Z1
+ VDD pch l=0.06U
+ w=0.21U
M3688 VDD XCTRLA_RSP XCTRLA_XDEC3DZ_2_Z1
+ VDD pch l=0.06U
+ w=0.75U
M3689 VDD XCTRLA_XDEC3DZ_2_Z1 A_Z_2
+ VDD pch_hvt l=0.06U
+ w=5U
M3690 XCTRLA_XDEC3DZ_2_Z3 XCTRLA_AT_14
+ XCTRLA_XDEC3DZ_2_Z4 VSS nch l=0.06U
+ w=2U
M3691 XCTRLA_XDEC3DZ_3_Z3 XCTRLA_AT_14
+ XCTRLA_XDEC3DZ_3_Z4 VSS nch l=0.06U
+ w=2U
M3692 XCTRLA_XALTCH_14_Z26 XCTRLA_CKP
+ XCTRLA_XALTCH_14_Z1 VSS nch l=0.06U
+ w=0.21U
M3693 XCTRLA_XALTCH_14_Z21 BISTT
+ XCTRLA_XALTCH_14_AX VDD pch l=0.08U
+ w=0.42U
M3694 XCTRLA_AT_14 XCTRLA_AC_14 VSS
+ VSS nch l=0.06U
+ w=0.55U
M3695 VDD XCTRLA_AC_14 XCTRLA_AT_14
+ VDD pch l=0.06U
+ w=1.1U
M3696 VDD XCTRLA_AT_14 XCTRLA_XDEC3DZ_2_Z1
+ VDD pch l=0.06U
+ w=0.21U
M3697 VDD XCTRLA_AT_14 XCTRLA_XDEC3DZ_3_Z1
+ VDD pch l=0.06U
+ w=0.21U
M3698 VDD XCTRLA_RSP XCTRLA_XDEC3DZ_2_Z1
+ VDD pch l=0.06U
+ w=0.75U
M3699 VDD XCTRLA_XDEC3DZ_2_Z1 A_Z_2
+ VDD pch_hvt l=0.06U
+ w=5U
M3700 XCTRLA_XALTCH_14_Z1 XCTRLA_XALTCH_14_AX
+ XCTRLA_XALTCH_14_Z25 VDD pch l=0.08U
+ w=0.42U
M3701 XCTRLA_XDEC3DZ_2_Z3 XCTRLA_AC_13
+ XCTRLA_XDEC3DZ_2_Z2 VSS nch l=0.06U
+ w=2U
M3702 XCTRLA_XDEC3DZ_3_Z3 XCTRLA_AT_13
+ XCTRLA_XDEC3DZ_3_Z2 VSS nch l=0.06U
+ w=2U
M3703 XCTRLA_XALTCH_14_Z1 XCTRLA_CKC
+ XCTRLA_XALTCH_14_Z28 VDD pch l=0.06U
+ w=0.21U
M3704 XCTRLA_XALTCH_14_Z1 XCTRLA_XALTCH_14_AX
+ XCTRLA_XALTCH_14_Z27 VSS nch l=0.08U
+ w=0.21U
M3705 XCTRLA_XALTCH_14_AX BISTC
+ XCTRLA_XALTCH_14_Z22 VDD pch l=0.08U
+ w=0.42U
M3706 XCTRLA_AC_14 XCTRLA_XALTCH_14_Z1
+ VSS VSS nch l=0.06U
+ w=0.55U
M3707 VDD XCTRLA_XALTCH_14_Z1
+ XCTRLA_AC_14 VDD pch l=0.06U
+ w=1.1U
M3708 VDD XCTRLA_AC_13 XCTRLA_XDEC3DZ_2_Z1
+ VDD pch l=0.06U
+ w=0.21U
M3709 VDD XCTRLA_AT_13 XCTRLA_XDEC3DZ_3_Z1
+ VDD pch l=0.06U
+ w=0.21U
M3710 VDD XCTRLA_RSP XCTRLA_XDEC3DZ_3_Z1
+ VDD pch l=0.06U
+ w=0.75U
M3711 VDD XCTRLA_XDEC3DZ_3_Z1 A_Z_3
+ VDD pch_hvt l=0.06U
+ w=5U
M3712 XCTRLA_XDEC3DZ_2_Z1 XCTRLA_CKP
+ XCTRLA_XDEC3DZ_2_Z2 VSS nch l=0.06U
+ w=2U
M3713 XCTRLA_XDEC3DZ_3_Z1 XCTRLA_CKP
+ XCTRLA_XDEC3DZ_3_Z2 VSS nch l=0.06U
+ w=2U
M3714 VDD AMA_14 XCTRLA_XALTCH_14_Z22 VDD
+ pch l=0.08U
+ w=0.42U
M3715 XCTRLA_AC_14 XCTRLA_XALTCH_14_Z1
+ VSS VSS nch l=0.06U
+ w=0.55U
M3716 VDD XCTRLA_XALTCH_14_Z1
+ XCTRLA_AC_14 VDD pch l=0.06U
+ w=1.1U
M3717 VDD XCTRLA_CKP XCTRLA_XDEC3DZ_2_Z1
+ VDD pch l=0.06U
+ w=0.21U
M3718 VDD XCTRLA_CKP XCTRLA_XDEC3DZ_3_Z1
+ VDD pch l=0.06U
+ w=0.21U
M3719 VDD XCTRLA_RSP XCTRLA_XDEC3DZ_3_Z1
+ VDD pch l=0.06U
+ w=0.75U
M3720 VDD XCTRLA_XDEC3DZ_3_Z1 A_Z_3
+ VDD pch_hvt l=0.06U
+ w=5U
M3721 VDD XCTRLA_AC_14 XCTRLA_XALTCH_14_Z28
+ VDD pch l=0.06U
+ w=0.21U
M3722 XCTRLA_XALTCH_14_Z27 XCTRLA_CKC VSS
+ VSS nch l=0.06U
+	 w=0.21U
M3723 XCTRLA_XALTCH_13_Z28 XCTRLA_AC_13 VDD
+ VDD pch l=0.06U
+ w=0.21U
M3724 XCTRLA_XALTCH_13_Z22 AMA_13 VDD VDD
+ pch l=0.08U
+ w=0.42U
M3725 XCTRLA_XALTCH_13_Z27 XCTRLA_CKC VSS
+ VSS nch l=0.06U
+ w=0.21U
M3726 XCTRLA_AC_13 XCTRLA_XALTCH_13_Z1
+ VSS VSS nch l=0.06U
+ w=0.55U
M3727 VDD XCTRLA_XALTCH_13_Z1
+ XCTRLA_AC_13 VDD pch l=0.06U
+ w=1.1U
M3728 VDD XCTRLA_CKP XCTRLA_XDEC3DZ_0_Z1
+ VDD pch l=0.06U
+ w=0.21U
M3729 VDD XCTRLA_CKP XCTRLA_XDEC3DZ_1_Z1
+ VDD pch l=0.06U
+ w=0.21U
M3730 VDD XCTRLA_RSP XCTRLA_XDEC3DZ_1_Z1
+ VDD pch l=0.06U
+ w=0.75U
M3731 VDD XCTRLA_XDEC3DZ_1_Z1 A_Z_1
+ VDD pch_hvt l=0.06U
+ w=5U
M3732 XCTRLA_XDEC3DZ_0_Z2 XCTRLA_CKP
+ XCTRLA_XDEC3DZ_0_Z1 VSS nch l=0.06U
+ w=2U
M3733 XCTRLA_XDEC3DZ_1_Z2 XCTRLA_CKP
+ XCTRLA_XDEC3DZ_1_Z1 VSS nch l=0.06U
+ w=2U
M3734 XCTRLA_XALTCH_13_Z22 BISTC
+ XCTRLA_XALTCH_13_AX VDD pch l=0.08U
+ w=0.42U
M3735 XCTRLA_AC_13 XCTRLA_XALTCH_13_Z1
+ VSS VSS nch l=0.06U
+ w=0.55U
M3736 VDD XCTRLA_XALTCH_13_Z1
+ XCTRLA_AC_13 VDD pch l=0.06U
+ w=1.1U
M3737 VDD XCTRLA_AC_13 XCTRLA_XDEC3DZ_0_Z1
+ VDD pch l=0.06U
+ w=0.21U
M3738 VDD XCTRLA_AT_13 XCTRLA_XDEC3DZ_1_Z1
+ VDD pch l=0.06U
+ w=0.21U
M3739 VDD XCTRLA_RSP XCTRLA_XDEC3DZ_1_Z1
+ VDD pch l=0.06U
+ w=0.75U
M3740 VDD XCTRLA_XDEC3DZ_1_Z1 A_Z_1
+ VDD pch_hvt l=0.06U
+ w=5U
M3741 XCTRLA_XALTCH_13_Z28 XCTRLA_CKC
+ XCTRLA_XALTCH_13_Z1 VDD pch l=0.06U
+ w=0.21U
M3742 XCTRLA_XALTCH_13_Z27 XCTRLA_XALTCH_13_AX
+ XCTRLA_XALTCH_13_Z1 VSS nch l=0.08U
+ w=0.21U
M3743 XCTRLA_XDEC3DZ_0_Z3 XCTRLA_AC_13
+ XCTRLA_XDEC3DZ_0_Z2 VSS nch l=0.06U
+ w=2U
M3744 XCTRLA_XDEC3DZ_1_Z3 XCTRLA_AT_13
+ XCTRLA_XDEC3DZ_1_Z2 VSS nch l=0.06U
+ w=2U
M3745 XCTRLA_XALTCH_13_Z26 XCTRLA_CKP
+ XCTRLA_XALTCH_13_Z1 VSS nch l=0.06U
+ w=0.21U
M3746 XCTRLA_XALTCH_13_Z21 BISTT
+ XCTRLA_XALTCH_13_AX VDD pch l=0.08U
+ w=0.42U
M3747 XCTRLA_XALTCH_13_Z1 XCTRLA_XALTCH_13_AX
+ XCTRLA_XALTCH_13_Z25 VDD pch l=0.08U
+ w=0.42U
M3748 XCTRLA_XDEC3DZ_0_Z4 XCTRLA_AC_14
+ XCTRLA_XDEC3DZ_0_Z3 VSS nch l=0.06U
+ w=2U
M3749 XCTRLA_XDEC3DZ_1_Z4 XCTRLA_AC_14
+ XCTRLA_XDEC3DZ_1_Z3 VSS nch l=0.06U
+ w=2U
M3750 XCTRLA_AT_13 XCTRLA_AC_13 VSS
+ VSS nch l=0.06U
+ w=0.55U
M3751 VDD XCTRLA_AC_13 XCTRLA_AT_13
+ VDD pch l=0.06U
+ w=1.1U
M3752 VDD XCTRLA_AC_14 XCTRLA_XDEC3DZ_0_Z1
+ VDD pch l=0.06U
+	 w=0.21U
M3753 VDD XCTRLA_AC_14 XCTRLA_XDEC3DZ_1_Z1
+ VDD pch l=0.06U
+	 w=0.21U
M3754 VDD XCTRLA_RSP XCTRLA_XDEC3DZ_0_Z1
+ VDD pch l=0.06U
+ w=0.75U
M3755 VDD XCTRLA_XDEC3DZ_0_Z1 A_Z_0
+ VDD pch_hvt l=0.06U
+ w=5U
M3756 VDD AA_13 XCTRLA_XALTCH_13_Z21 VDD
+ pch l=0.08U
+ w=0.42U
M3757 XCTRLA_AT_13 XCTRLA_AC_13 VSS
+ VSS nch l=0.06U
+	 w=0.55U
M3758 VDD XCTRLA_AC_13 XCTRLA_AT_13
+ VDD pch l=0.06U
+ w=1.1U
M3759 VDD XCTRLA_AC_15 XCTRLA_XDEC3DZ_0_Z1
+ VDD pch l=0.06U
+ w=0.21U
M3760 VDD XCTRLA_AC_15 XCTRLA_XDEC3DZ_1_Z1
+ VDD pch l=0.06U
+ w=0.21U
M3761 VDD XCTRLA_RSP XCTRLA_XDEC3DZ_0_Z1
+ VDD pch l=0.06U
+ w=0.75U
M3762 VDD XCTRLA_XDEC3DZ_0_Z1 A_Z_0
+ VDD pch_hvt l=0.06U
+ w=5U
M3763 VDD XCTRLA_CKP XCTRLA_XALTCH_13_Z25
+ VDD pch l=0.06U
+ w=0.42U
M3764 XCTRLA_XDEC3DZ_0_Z4 XCTRLA_AC_15 VSS
+ VSS nch l=0.06U
+ w=2U
M3765 XCTRLA_XDEC3DZ_1_Z4 XCTRLA_AC_15 VSS
+ VSS nch l=0.06U
+ w=2U
M3766 VSS XCTRLA_AC_13 XCTRLA_XALTCH_13_Z26
+ VSS nch l=0.06U
+ w=0.21U
M3767 XCTRLA_XDEC3DXA_6_Z4 XCTRLA_AT_7 VSS
+ VSS nch l=0.06U
+ w=2U
M3768 XCTRLA_XDEC3DXA_7_Z4 XCTRLA_AT_7 VSS
+ VSS nch l=0.06U
+ w=2U
M3769 XCTRLA_XALTCH_5_Z26 XCTRLA_AC_5 VSS
+ VSS nch l=0.06U
+ w=0.21U
M3770 VDD XCTRLA_CKP XCTRLA_XALTCH_5_Z25
+ VDD pch l=0.06U
+	 w=0.42U
M3771 XCTRLA_XALTCH_5_Z21 AA_5 VDD VDD
+ pch l=0.08U
+ w=0.42U
M3772 XCTRLA_AT_5 XCTRLA_AC_5 VSS VSS
+ nch l=0.06U
+ w=0.55U
M3773 VDD XCTRLA_AC_5 XCTRLA_AT_5
+ VDD pch l=0.06U
+ w=1.1U
M3774 VDD XCTRLA_AT_7 XCTRLA_XDEC3DXA_6_Z1
+ VDD pch l=0.06U
+ w=0.21U
M3775 VDD XCTRLA_AT_7 XCTRLA_XDEC3DXA_7_Z1
+ VDD pch l=0.06U
+ w=0.21U
M3776 VDD XCTRLA_RSP XCTRLA_XDEC3DXA_6_Z1
+ VDD pch l=0.06U
+ w=0.75U
M3777 VDD XCTRLA_XDEC3DXA_6_Z1 A_XA_6
+ VDD pch_hvt l=0.06U
+ w=5U
M3778 XCTRLA_XDEC3DXA_6_Z3 XCTRLA_AT_6
+ XCTRLA_XDEC3DXA_6_Z4 VSS nch l=0.06U
+ w=2U
M3779 XCTRLA_XDEC3DXA_7_Z3 XCTRLA_AT_6
+ XCTRLA_XDEC3DXA_7_Z4 VSS nch l=0.06U
+ w=2U
M3780 XCTRLA_XALTCH_5_Z26 XCTRLA_CKP
+ XCTRLA_XALTCH_5_Z1 VSS nch l=0.06U
+ w=0.21U
M3781 XCTRLA_XALTCH_5_Z21 BISTT
+ XCTRLA_XALTCH_5_AX VDD pch l=0.08U
+ w=0.42U
M3782 XCTRLA_AT_5 XCTRLA_AC_5 VSS
+ VSS nch l=0.06U
+ w=0.55U
M3783 VDD XCTRLA_AC_5 XCTRLA_AT_5 VDD
+ pch l=0.06U
+ w=1.1U
M3784 VDD XCTRLA_AT_6 XCTRLA_XDEC3DXA_6_Z1
+ VDD pch l=0.06U
+ w=0.21U
M3785 VDD XCTRLA_AT_6 XCTRLA_XDEC3DXA_7_Z1
+ VDD pch l=0.06U
+ w=0.21U
M3786 VDD XCTRLA_RSP
+ XCTRLA_XDEC3DXA_6_Z1 VDD pch l=0.06U
+ w=0.75U
M3787 VDD XCTRLA_XDEC3DXA_6_Z1 A_XA_6
+ VDD pch_hvt l=0.06U
+ w=5U
M3788 XCTRLA_XALTCH_5_Z25 XCTRLA_XALTCH_5_AX
+ XCTRLA_XALTCH_5_Z1 VDD pch l=0.08U
+ w=0.42U
M3789 XCTRLA_XDEC3DXA_6_Z2 XCTRLA_AC_5
+ XCTRLA_XDEC3DXA_6_Z3 VSS nch l=0.06U
+ w=2U
M3790 XCTRLA_XDEC3DXA_7_Z2 XCTRLA_AT_5
+ XCTRLA_XDEC3DXA_7_Z3 VSS nch l=0.06U
+ w=2U
M3791 VDD XCTRLA_XDLRSD_Z6
+ XCTRLA_XDLRSD_Z7 VDD pch l=0.06U
+ w=1.4U
M3792 VDD XCTRLA_XDLRSD_Z6
+ XCTRLA_XDLRSD_Z7 VDD pch l=0.06U
+ w=1.4U
M3793 VDD XCTRLA_XDLRSD_Z6
+ XCTRLA_XDLRSD_Z7 VDD pch l=0.06U
+ w=1.4U
M3794 VDD XCTRLA_XDLRSD_Z6
+ XCTRLA_XDLRSD_Z7 VDD pch l=0.06U
+ w=1.4U
M3795 VDD XCTRLA_XDLRSD_Z5
+ XCTRLA_XDLRSD_Z6 VDD pch l=0.08U
+ w=0.6U
M3796 VDD XCTRLA_XDLRSD_Z5
+ XCTRLA_XDLRSD_Z6 VDD pch l=0.08U
+ w=0.6U
M3797 VDD XCTRLA_XDLRSD_Z5
+ XCTRLA_XDLRSD_Z6 VDD pch l=0.08U
+ w=0.6U
M3798 VDD XCTRLA_XDLRSD_Z4
+ XCTRLA_XDLRSD_Z5 VDD pch l=0.06U
+ w=0.41U
M3799 VDD XCTRLA_XDLRSD_Z4
+ XCTRLA_XDLRSD_Z5 VDD pch l=0.06U
+ w=0.41U
M3800 VDD XCTRLA_XDLRSD_Z7 A_DLRS VDD
+ pch l=0.06U
+	 w=1.5U
M3801 VDD XCTRLA_XDLRSD_Z7 A_DLRS
+ VDD pch l=0.06U
+ w=1.5U
M3802 VDD XCTRLA_XDLRSD_Z7 A_DLRS
+ VDD pch l=0.06U
+	 w=1.5U
M3803 VDD XCTRLA_XDLRSD_Z7 A_DLRS
+ VDD pch l=0.06U
+ w=1.5U
M3804 VDD XCTRLA_XDLRSD_Z7 A_DLRS
+ VDD pch l=0.06U
+ w=1.5U
M3805 VDD XCTRLA_XDLRSD_Z7 A_DLRS
+ VDD pch l=0.06U
+ w=1.5U
M3806 VDD XCTRLA_XDLRSD_Z7 A_DLRS
+ VDD pch l=0.06U
+	 w=1.5U
M3807 VDD XCTRLA_XDLRSD_Z7 A_DLRS
+ VDD pch l=0.06U
+ w=1.5U
M3808 VDD XCTRLA_XDLRSD_Z7 A_DLRS
+ VDD pch l=0.06U
+ w=1.5U
M3809 VDD XCTRLA_XDLRSD_Z7 A_DLRS
+ VDD pch l=0.06U
+	 w=1.5U
M3810 VDD XCTRLA_XDLRSD_Z37
+ XCTRLA_XDLRSD_Z38 VDD pch l=0.06U
+ w=0.41U
M3811 VDD XCTRLA_XDLRSD_Z36
+ XCTRLA_XDLRSD_Z37 VDD pch l=0.14U
+ w=0.41U
M3812 VDD XCTRLA_XDLRSD_Z3
+ XCTRLA_XDLRSD_Z4 VDD pch l=0.08U
+ w=0.41U
M3813 VDD XCTRLA_XDLRSD_Z2
+ XCTRLA_XDLRSD_Z3 VDD pch l=0.06U
+ w=0.41U
M3814 VDD XCTRLA_XDLRSD_Z38
+ XCTRLA_XDLRSD_Z2 VDD pch l=0.1U
+ w=0.41U
M3815 VDD A_RD XCTRLA_XDLRSD_Z1 VDD
+ pch l=0.06U
+ w=0.41U
M3816 VDD A_RD XCTRLA_XDLRSD_Z1
+ VDD pch l=0.06U
+	 w=0.41U
M3817 VDD XCTRLA_XDLRSD_Z32
+ XCTRLA_XDLRSD_Z33 VDD pch l=0.14U
+ w=0.41U
M3818 VDD XCTRLA_XDLRSD_Z33
+ XCTRLA_XDLRSD_Z34 VDD pch l=0.06U
+ w=0.41U
M3819 VDD XCTRLA_XDLRSD_Z1
+ XCTRLA_XDLRSD_Z2 VDD pch l=0.06U
+ w=0.41U
M3820 VDD XCTRLA_XDLRSD_Z29
+ XCTRLA_XDLRSD_Z38 VDD pch l=0.06U
+ w=0.41U
M3821 VDD XCTRLA_XDLRSD_Z31
+ XCTRLA_XDLRSD_Z32 VDD pch l=0.06U
+ w=0.41U
M3822 VDD XCTRLA_XDLRSD_Z34
+ XCTRLA_XDLRSD_Z35 VDD pch l=0.14U
+ w=0.41U
M3823 VDD XCTRLA_XDLRSD_Z35
+ XCTRLA_XDLRSD_Z36 VDD pch l=0.06U
+ w=0.41U
M3824 VDD XCTRLA_XDLRSD_Z22
+ XCTRLA_XDLRSD_Z23 VDD pch l=0.14U
+ w=0.41U
M3825 VDD XCTRLA_XDLRSD_Z25
+ XCTRLA_XDLRSD_Z26 VDD pch l=0.06U
+ w=0.41U
M3826 VDD XCTRLA_XDLRSD_Z24
+ XCTRLA_XDLRSD_Z25 VDD pch l=0.14U
+ w=0.41U
M3827 VDD XCTRLA_XDLRSD_Z27
+ XCTRLA_XDLRSD_Z28 VDD pch l=0.06U
+ w=0.41U
M3828 VDD XCTRLA_XDLRSD_Z26
+ XCTRLA_XDLRSD_Z27 VDD pch l=0.14U
+ w=0.41U
M3829 VDD XCTRLA_XDLRSD_Z23
+ XCTRLA_XDLRSD_Z24 VDD pch l=0.06U
+ w=0.41U
M3830 VDD XCTRLA_XDLRSD_Z21
+ XCTRLA_XDLRSD_Z22 VDD pch l=0.06U
+ w=0.41U
M3831 VDD XCTRLA_XDLRSD_Z20
+ XCTRLA_XDLRSD_Z21 VDD pch l=0.14U
+ w=0.41U
M3832 VDD XCTRLA_XDLRSD_Z15
+ XCTRLA_XDLRSD_Z20 VDD pch l=0.06U
+ w=0.41U
M3833 VDD XCTRLA_XDLRSD_Z11
+ XCTRLA_XDLRSD_Z20 VDD pch l=0.06U
+ w=0.41U
M3834 VDD XCTRLA_XDLRSD_Z1
+ XCTRLA_XDLRSD_Z20 VDD pch l=0.06U
+ w=0.41U
M3835 VDD XCTRLA_XDLRSD_Z28
+ XCTRLA_XDLRSD_Z29 VDD pch l=0.14U
+ w=0.41U
M3836 VDD XCTRLA_XDLRSD_Z30
+ XCTRLA_XDLRSD_Z31 VDD pch l=0.14U
+ w=0.41U
M3837 VDD XCTRLA_XDLRSD_Z29
+ XCTRLA_XDLRSD_Z30 VDD pch l=0.06U
+ w=0.41U
M3838 VDD XCTRLA_XDLRSD_Z12
+ XCTRLA_XDLRSD_Z13 VDD pch l=0.08U
+ w=0.41U
M3839 VDD VS_0 XCTRLA_XDLRSD_Z11 VDD
+ pch l=0.06U
+ w=0.41U
M3840 VDD XCTRLA_XDLRSD_Z14
+ XCTRLA_XDLRSD_Z15 VDD pch l=0.08U
+ w=0.41U
M3841 VDD XCTRLA_XDLRSD_Z10
+ XCTRLA_XDLRSD_Z11 VDD pch l=0.08U
+ w=0.41U
M3842 VDD XCTRLA_XDLRSD_Z15
+ XCTRLA_XDLRSD_Z10 VDD pch l=0.06U
+ w=0.41U
M3843 VDD XCTRLA_XDLRSD_Z13
+ XCTRLA_XDLRSD_Z14 VDD pch l=0.06U
+ w=0.41U
M3844 VDD XCTRLA_XDLRSD_Z1
+ XCTRLA_XDLRSD_Z10 VDD pch l=0.06U
+ w=0.41U
M3845 VDD VS_1 XCTRLA_XDLRSD_Z13 VDD
+ pch l=0.06U
+	 w=0.41U
M3846 VDD XCTRLA_XDLRSD_Z1
+ XCTRLA_XDLRSD_Z12 VDD pch l=0.06U
+ w=0.41U
M3847 XCTRLA_XALTCH_5_Z28 XCTRLA_CKC
+ XCTRLA_XALTCH_5_Z1 VDD pch l=0.06U
+ w=0.21U
M3848 XCTRLA_XALTCH_5_Z27 XCTRLA_XALTCH_5_AX
+ XCTRLA_XALTCH_5_Z1 VSS nch l=0.08U
+ w=0.21U
M3849 XCTRLA_XALTCH_5_Z22 BISTC
+ XCTRLA_XALTCH_5_AX VDD pch l=0.08U
+ w=0.42U
M3850 XCTRLA_AC_5 XCTRLA_XALTCH_5_Z1
+ VSS VSS nch l=0.06U
+ w=0.55U
M3851 VDD XCTRLA_XALTCH_5_Z1
+ XCTRLA_AC_5 VDD pch l=0.06U
+ w=1.1U
M3852 VDD XCTRLA_AC_5 XCTRLA_XDEC3DXA_6_Z1
+ VDD pch l=0.06U
+ w=0.21U
M3853 VDD XCTRLA_AT_5 XCTRLA_XDEC3DXA_7_Z1
+ VDD pch l=0.06U
+ w=0.21U
M3854 VDD XCTRLA_RSP
+ XCTRLA_XDEC3DXA_7_Z1 VDD pch l=0.06U
+ w=0.75U
M3855 VDD XCTRLA_XDEC3DXA_7_Z1 A_XA_7
+ VDD pch_hvt l=0.06U
+ w=5U
M3856 XCTRLA_XDEC3DXA_6_Z2 XCTRLA_CKP
+ XCTRLA_XDEC3DXA_6_Z1 VSS nch l=0.06U
+ w=2U
M3857 XCTRLA_XDEC3DXA_7_Z2 XCTRLA_CKP
+ XCTRLA_XDEC3DXA_7_Z1 VSS nch l=0.06U
+ w=2U
M3858 VDD AMA_5 XCTRLA_XALTCH_5_Z22 VDD
+ pch l=0.08U
+ w=0.42U
M3859 XCTRLA_AC_5 XCTRLA_XALTCH_5_Z1
+ VSS VSS nch l=0.06U
+ w=0.55U
M3860 VDD XCTRLA_XALTCH_5_Z1
+ XCTRLA_AC_5 VDD pch l=0.06U
+ w=1.1U
M3861 VDD XCTRLA_CKP XCTRLA_XDEC3DXA_6_Z1
+ VDD pch l=0.06U
+ w=0.21U
M3862 VDD XCTRLA_CKP XCTRLA_XDEC3DXA_7_Z1
+ VDD pch l=0.06U
+ w=0.21U
M3863 VDD XCTRLA_RSP XCTRLA_XDEC3DXA_7_Z1
+ VDD pch l=0.06U
+ w=0.75U
M3864 VDD XCTRLA_XDEC3DXA_7_Z1 A_XA_7
+ VDD pch_hvt l=0.06U
+ w=5U
M3865 VDD XCTRLA_AC_5 XCTRLA_XALTCH_5_Z28
+ VDD pch l=0.06U
+ w=0.21U
M3866 VSS XCTRLA_CKC XCTRLA_XALTCH_5_Z27
+ VSS nch l=0.06U
+ w=0.21U
M3867 VDD XCTRLA_AC_6 XCTRLA_XALTCH_6_Z28
+ VDD pch l=0.06U
+ w=0.21U
M3868 XCTRLA_XALTCH_6_Z22 AMA_6 VDD VDD
+ pch l=0.08U
+ w=0.42U
M3869 XCTRLA_XALTCH_6_Z27 XCTRLA_CKC VSS
+ VSS nch l=0.06U
+ w=0.21U
M3870 XCTRLA_AC_6 XCTRLA_XALTCH_6_Z1
+ VSS VSS nch l=0.06U
+ w=0.55U
M3871 VDD XCTRLA_XALTCH_6_Z1
+ XCTRLA_AC_6 VDD pch l=0.06U
+ w=1.1U
M3872 VDD XCTRLA_CKP XCTRLA_XDEC3DXA_4_Z1
+ VDD pch l=0.06U
+ w=0.21U
M3873 VDD XCTRLA_CKP XCTRLA_XDEC3DXA_5_Z1
+ VDD pch l=0.06U
+ w=0.21U
M3874 VDD XCTRLA_RSP
+ XCTRLA_XDEC3DXA_5_Z1 VDD pch l=0.06U
+ w=0.75U
M3875 VDD XCTRLA_XDEC3DXA_5_Z1 A_XA_5
+ VDD pch_hvt l=0.06U
+ w=5U
M3876 XCTRLA_XDEC3DXA_4_Z2 XCTRLA_CKP
+ XCTRLA_XDEC3DXA_4_Z1 VSS nch l=0.06U
+ w=2U
M3877 XCTRLA_XDEC3DXA_5_Z2 XCTRLA_CKP
+ XCTRLA_XDEC3DXA_5_Z1 VSS nch l=0.06U
+ w=2U
M3878 XCTRLA_XDBLDG_ENB_S A_DBL VSS
+ VSS nch_hvt l=0.06U
+ w=0.62U
M3879 XCTRLA_XDBLDG_ENB_S A_DBL VSS
+ VSS nch_hvt l=0.06U
+	 w=0.62U
M3880 A_DBL XCTRLA_XDBLDG_XDBLDD_Z0 VSS
+ VSS nch_hvt l=0.08U
+ w=0.62U
M3881 XCTRLA_XDBLDG_XDBLDD_Z0 VHI VSS
+ VSS nch_hvt l=0.08U
+ w=0.62U
M3882 A_DBL A_DWLF XCTRLA_XDBLDG_ENB_S
+ VSS nch_hvt l=0.08U
+ w=0.62U
M3883 A_DWL XCTRLA_XDWLDV_DWLC VSS VSS
+ nch_hvt l=0.06U
+	 w=1U
M3884 A_DWL XCTRLA_XDWLDV_DWLC VSS
+ VSS nch_hvt l=0.06U
+	 w=1U
M3885 XCTRLA_XDBLDG_XDBLD5_3_Z1 A_DWLF
+ A_DBL VSS nchpg_hvtdpsr l=0.08U
+ w=0.105U
M3886 VSS A_DWLF
+ XCTRLA_XDBLDG_XDBLD5_3_Z0 VSS nchpg_hvtdpsr
+ l=0.08U w=0.105U
M3887 VSS A_DWLF
+ XCTRLA_XDBLDG_XDBLD1_0_NC_N3 VSS nchpg_hvtdpsr
+ l=0.08U w=0.105U
M3888 XCTRLA_XDBLDG_XDBLD5_3_Z1 A_DWLF
+ A_DBL VSS nchpg_hvtdpsr l=0.08U
+ w=0.105U
M3889 VSS A_DWLF
+ XCTRLA_XDBLDG_XDBLD5_3_NC_N3 VSS nchpg_hvtdpsr
+ l=0.08U w=0.105U
M3890 XCTRLA_XDBLDG_XDBLD5_1_Z1 A_DWLF
+ A_DBL VSS nchpg_hvtdpsr l=0.08U
+ w=0.105U
M3891 XCTRLA_XDBLDG_XDBLD5_1_Z1 A_DWLF
+ A_DBL VSS nchpg_hvtdpsr l=0.08U
+ w=0.105U
M3892 VSS A_DWLF
+ XCTRLA_XDBLDG_XDBLD5_1_Z0 VSS nchpg_hvtdpsr
+ l=0.08U w=0.105U
M3893 XCTRLA_XDBLDG_XDBLD5_2_Z1 A_DWLF
+ A_DBL VSS nchpg_hvtdpsr l=0.08U
+ w=0.105U
M3894 VSS A_DWLF
+ XCTRLA_XDBLDG_XDBLD5_2_Z0 VSS nchpg_hvtdpsr
+ l=0.08U w=0.105U
M3895 VSS A_DWLF
+ XCTRLA_XDBLDG_XDBLD4_2_NC_N3 VSS nchpg_hvtdpsr
+ l=0.08U w=0.105U
M3896 XCTRLA_XDBLDG_XDBLD5_2_Z1 A_DWLF
+ A_DBL VSS nchpg_hvtdpsr l=0.08U
+ w=0.105U
M3897 VSS A_DWLF
+ XCTRLA_XDBLDG_XDBLD0_NC_N3 VSS nchpg_hvtdpsr
+ l=0.08U w=0.105U
M3898 XCTRLA_XDBLDG_XDBLD5_0_Z1 A_DWLF
+ A_DBL VSS nchpg_hvtdpsr l=0.08U
+ w=0.105U
M3899 XCTRLA_XDBLDG_XDBLD5_0_Z1 A_DWLF
+ A_DBL VSS nchpg_hvtdpsr l=0.08U
+ w=0.105U
M3900 VSS A_DWLF
+ XCTRLA_XDBLDG_XDBLD5_0_Z0 VSS nchpg_hvtdpsr
+ l=0.08U w=0.105U
M3901 VSS A_DWLF
+ XCTRLA_XDBLDG_XDBLD4_1_NC_N3 VSS nchpg_hvtdpsr
+ l=0.08U w=0.105U
M3902 XCTRLA_XDBLDG_XDBLD4_3_Z1 A_DWLF
+ A_DBL VSS nchpg_hvtdpsr l=0.08U
+ w=0.105U
M3903 XCTRLA_XDBLDG_XDBLD4_3_Z1 A_DWLF
+ A_DBL VSS nchpg_hvtdpsr l=0.08U
+ w=0.105U
M3904 VSS A_DWLF
+ XCTRLA_XDBLDG_XDBLD4_3_Z0 VSS nchpg_hvtdpsr
+ l=0.08U w=0.105U
M3905 VSS A_DWLF
+ XCTRLA_XDBLDG_XDBLD4_0_NC_N3 VSS nchpg_hvtdpsr
+ l=0.08U w=0.105U
M3906 XCTRLA_XDBLDG_XDBLD4_1_Z1 A_DWLF
+ A_DBL VSS nchpg_hvtdpsr l=0.08U
+ w=0.105U
M3907 XCTRLA_XDBLDG_XDBLD4_1_Z1 A_DWLF
+ A_DBL VSS nchpg_hvtdpsr l=0.08U
+ w=0.105U
M3908 VSS A_DWLF
+ XCTRLA_XDBLDG_XDBLD4_1_Z0 VSS nchpg_hvtdpsr
+ l=0.08U w=0.105U
M3909 XCTRLA_XDBLDG_XDBLD4_2_Z1 A_DWLF
+ A_DBL VSS nchpg_hvtdpsr l=0.08U
+ w=0.105U
M3910 VSS A_DWLF
+ XCTRLA_XDBLDG_XDBLD4_2_Z0 VSS nchpg_hvtdpsr
+ l=0.08U w=0.105U
M3911 VSS A_DWLF
+ XCTRLA_XDBLDG_XDBLD5_1_NC_N3 VSS nchpg_hvtdpsr
+ l=0.08U w=0.105U
M3912 XCTRLA_XDBLDG_XDBLD4_2_Z1 A_DWLF
+ A_DBL VSS nchpg_hvtdpsr l=0.08U
+ w=0.105U
M3913 VSS A_DWLF
+ XCTRLA_XDBLDG_XDBLD5_0_NC_N3 VSS nchpg_hvtdpsr
+ l=0.08U w=0.105U
M3914 XCTRLA_XDBLDG_XDBLD4_0_Z1 A_DWLF
+ A_DBL VSS nchpg_hvtdpsr l=0.08U
+ w=0.105U
M3915 VSS A_DWLF
+ XCTRLA_XDBLDG_XDBLD3_0_NC_N3 VSS nchpg_hvtdpsr
+ l=0.08U w=0.105U
M3916 XCTRLA_XDBLDG_XDBLD3_1_Z1 A_DWLF
+ A_DBL VSS nchpg_hvtdpsr l=0.08U
+ w=0.105U
M3917 XCTRLA_XDBLDG_XDBLD3_1_Z1 A_DWLF
+ A_DBL VSS nchpg_hvtdpsr l=0.08U
+ w=0.105U
M3918 VSS A_DWLF
+ XCTRLA_XDBLDG_XDBLD3_1_Z0 VSS nchpg_hvtdpsr
+ l=0.08U w=0.105U
M3919 XCTRLA_XDBLDG_XDBLD4_0_Z1 A_DWLF
+ A_DBL VSS nchpg_hvtdpsr l=0.08U
+ w=0.105U
M3920 VSS A_DWLF
+ XCTRLA_XDBLDG_XDBLD4_0_Z0 VSS nchpg_hvtdpsr
+ l=0.08U w=0.105U
M3921 VSS A_DWLF
+ XCTRLA_XDBLDG_XDBLD3_1_NC_N3 VSS nchpg_hvtdpsr
+ l=0.08U w=0.105U
M3922 XCTRLA_XDBLDG_XDBLD3_0_Z1 A_DWLF
+ A_DBL VSS nchpg_hvtdpsr l=0.08U
+ w=0.105U
M3923 XCTRLA_XDBLDG_XDBLD3_0_Z1 A_DWLF
+ A_DBL VSS nchpg_hvtdpsr l=0.08U
+ w=0.105U
M3924 VSS A_DWLF
+ XCTRLA_XDBLDG_XDBLD3_0_Z0 VSS nchpg_hvtdpsr
+ l=0.08U w=0.105U
M3925 VSS A_DWLF
+ XCTRLA_XDBLDG_XDBLD4_3_NC_N3 VSS nchpg_hvtdpsr
+ l=0.08U w=0.105U
M3926 XCTRLA_XDBLDG_XDBLD1_1_Z1 A_DWLF
+ A_DBL VSS nchpg_hvtdpsr l=0.08U
+ w=0.105U
M3927 VSS A_DWLF
+ XCTRLA_XDBLDG_XDBLD5_2_NC_N3 VSS nchpg_hvtdpsr
+ l=0.08U w=0.105U
M3928 XCTRLA_XDBLDG_XDBLD2_Z1 A_DWLF A_DBL
+ VSS nchpg_hvtdpsr l=0.08U
+ w=0.105U
M3929 XCTRLA_XDBLDG_XDBLD2_Z1 A_DWLF A_DBL
+ VSS nchpg_hvtdpsr l=0.08U
+ w=0.105U
M3930 VSS A_DWLF
+ XCTRLA_XDBLDG_XDBLD2_Z0 VSS nchpg_hvtdpsr
+ l=0.08U w=0.105U
M3931 XCTRLA_XDBLDG_XDBLD1_1_Z1 A_DWLF
+ A_DBL VSS nchpg_hvtdpsr l=0.08U
+ w=0.105U
M3932 VSS A_DWLF
+ XCTRLA_XDBLDG_XDBLD1_1_Z0 VSS nchpg_hvtdpsr
+ l=0.08U w=0.105U
M3933 XCTRLA_XDBLDG_XDBLD1_0_Z1 A_DWLF
+ A_DBL VSS nchpg_hvtdpsr l=0.08U
+ w=0.105U
M3934 VSS A_DWLF
+ XCTRLA_XDBLDG_XDBLD1_0_Z0 VSS nchpg_hvtdpsr
+ l=0.08U w=0.105U
M3935 XCTRLA_XDBLDG_XDBLD0_Z1 A_DWLF A_DBL
+ VSS nchpg_hvtdpsr l=0.08U
+ w=0.105U
M3936 VSS A_DWLF
+ XCTRLA_XDBLDG_XDBLD0_Z0 VSS nchpg_hvtdpsr
+ l=0.08U w=0.105U
M3937 VSS A_DWLF
+ XCTRLA_XDBLDG_XDBLD1_1_NC_N3 VSS nchpg_hvtdpsr
+ l=0.08U w=0.105U
M3938 XCTRLA_XDBLDG_XDBLD0_Z1 A_DWLF A_DBL
+ VSS nchpg_hvtdpsr l=0.08U
+ w=0.105U
M3939 VSS A_DWLF
+ XCTRLA_XDBLDG_XDBLD2_NC_N3 VSS nchpg_hvtdpsr
+ l=0.08U w=0.105U
M3940 XCTRLA_XDBLDG_XDBLD1_0_Z1 A_DWLF
+ A_DBL VSS nchpg_hvtdpsr l=0.08U
+ w=0.105U
M3941 VSS XCTRLA_XDBLDG_XDBLD5_3_Z1
+ XCTRLA_XDBLDG_XDBLD5_3_Z0 VSS nchpd_hvtdpsr
+ l=0.065U w=0.315U
M3942 VSS XCTRLA_XDBLDG_XDBLD5_1_Z1
+ XCTRLA_XDBLDG_XDBLD5_1_Z0 VSS nchpd_hvtdpsr
+ l=0.065U w=0.315U
M3943 XCTRLA_XDBLDG_XDBLD5_3_Z1 VHI
+ VSS VSS nchpd_hvtdpsr l=0.065U
+ w=0.315U
M3944 XCTRLA_XDBLDG_XDBLD5_1_Z1 VHI
+ VSS VSS nchpd_hvtdpsr l=0.065U
+ w=0.315U
M3945 XCTRLA_XDBLDG_XDBLD5_2_Z1 VHI
+ VSS VSS nchpd_hvtdpsr l=0.065U
+ w=0.315U
M3946 VSS XCTRLA_XDBLDG_XDBLD5_2_Z1
+ XCTRLA_XDBLDG_XDBLD5_2_Z0 VSS nchpd_hvtdpsr
+ l=0.065U w=0.315U
M3947 VSS XCTRLA_XDBLDG_XDBLD5_0_Z1
+ XCTRLA_XDBLDG_XDBLD5_0_Z0 VSS nchpd_hvtdpsr
+ l=0.065U w=0.315U
M3948 VSS XCTRLA_XDBLDG_XDBLD4_3_Z1
+ XCTRLA_XDBLDG_XDBLD4_3_Z0 VSS nchpd_hvtdpsr
+ l=0.065U w=0.315U
M3949 XCTRLA_XDBLDG_XDBLD4_3_Z1 VB_2
+ VSS VSS nchpd_hvtdpsr l=0.065U
+ w=0.315U
M3950 XCTRLA_XDBLDG_XDBLD5_0_Z1 VHI
+ VSS VSS nchpd_hvtdpsr l=0.065U
+ w=0.315U
M3951 VSS XCTRLA_XDBLDG_XDBLD4_1_Z1
+ XCTRLA_XDBLDG_XDBLD4_1_Z0 VSS nchpd_hvtdpsr
+ l=0.065U w=0.315U
M3952 VSS XCTRLA_XDBLDG_XDBLD4_2_Z1
+ XCTRLA_XDBLDG_XDBLD4_2_Z0 VSS nchpd_hvtdpsr
+ l=0.065U w=0.315U
M3953 XCTRLA_XDBLDG_XDBLD4_1_Z1 VB_2
+ VSS VSS nchpd_hvtdpsr l=0.065U
+ w=0.315U
M3954 XCTRLA_XDBLDG_XDBLD4_2_Z1 VB_2
+ VSS VSS nchpd_hvtdpsr l=0.065U
+ w=0.315U
M3955 VSS XCTRLA_XDBLDG_XDBLD4_0_Z1
+ XCTRLA_XDBLDG_XDBLD4_0_Z0 VSS nchpd_hvtdpsr
+ l=0.065U w=0.315U
M3956 VSS XCTRLA_XDBLDG_XDBLD3_0_Z1
+ XCTRLA_XDBLDG_XDBLD3_0_Z0 VSS nchpd_hvtdpsr
+ l=0.065U w=0.315U
M3957 VSS XCTRLA_XDBLDG_XDBLD3_1_Z1
+ XCTRLA_XDBLDG_XDBLD3_1_Z0 VSS nchpd_hvtdpsr
+ l=0.065U w=0.315U
M3958 XCTRLA_XDBLDG_XDBLD4_0_Z1 VB_2
+ VSS VSS nchpd_hvtdpsr l=0.065U
+ w=0.315U
M3959 XCTRLA_XDBLDG_XDBLD3_1_Z1 VB_1
+ VSS VSS nchpd_hvtdpsr l=0.065U
+ w=0.315U
M3960 VSS XCTRLA_XDBLDG_XDBLD1_1_Z1
+ XCTRLA_XDBLDG_XDBLD1_1_Z0 VSS nchpd_hvtdpsr
+ l=0.065U w=0.315U
M3961 VSS XCTRLA_XDBLDG_XDBLD2_Z1
+ XCTRLA_XDBLDG_XDBLD2_Z0 VSS nchpd_hvtdpsr
+ l=0.065U w=0.315U
M3962 XCTRLA_XDBLDG_XDBLD3_0_Z1 VB_1
+ VSS VSS nchpd_hvtdpsr l=0.065U
+ w=0.315U
M3963 XCTRLA_XDBLDG_XDBLD2_Z1 VB_0 VSS
+ VSS nchpd_hvtdpsr l=0.065U
+ w=0.315U
M3964 XCTRLA_XDBLDG_XDBLD1_1_Z1 VD_1
+ XCTRLA_XDBLDG_ENB_S VSS nchpd_hvtdpsr
+ l=0.065U w=0.315U
M3965 VSS XCTRLA_XDBLDG_XDBLD0_Z1
+ XCTRLA_XDBLDG_XDBLD0_Z0 VSS nchpd_hvtdpsr
+ l=0.065U w=0.315U
M3966 VSS XCTRLA_XDBLDG_XDBLD1_0_Z1
+ XCTRLA_XDBLDG_XDBLD1_0_Z0 VSS nchpd_hvtdpsr
+ l=0.065U w=0.315U
M3967 XCTRLA_XDBLDG_XDBLD1_0_Z1 VD_1
+ XCTRLA_XDBLDG_ENB_S VSS nchpd_hvtdpsr
+ l=0.065U w=0.315U
M3968 XCTRLA_XDBLDG_XDBLD0_Z1 VD_0
+ XCTRLA_XDBLDG_ENB_S VSS nchpd_hvtdpsr
+ l=0.065U w=0.315U
M3969 XCTRLA_XALTCH_6_Z22 BISTC
+ XCTRLA_XALTCH_6_AX VDD pch l=0.08U
+ w=0.42U
M3970 XCTRLA_AC_6 XCTRLA_XALTCH_6_Z1
+ VSS VSS nch l=0.06U
+ w=0.55U
M3971 VDD XCTRLA_XALTCH_6_Z1
+ XCTRLA_AC_6 VDD pch l=0.06U
+ w=1.1U
M3972 VDD XCTRLA_AC_5 XCTRLA_XDEC3DXA_4_Z1
+ VDD pch l=0.06U
+ w=0.21U
M3973 VDD XCTRLA_AT_5 XCTRLA_XDEC3DXA_5_Z1
+ VDD pch l=0.06U
+ w=0.21U
M3974 VDD XCTRLA_RSP XCTRLA_XDEC3DXA_5_Z1
+ VDD pch l=0.06U
+ w=0.75U
M3975 VDD XCTRLA_XDEC3DXA_5_Z1 A_XA_5
+ VDD pch_hvt l=0.06U
+ w=5U
M3976 XCTRLA_XALTCH_6_Z28 XCTRLA_CKC
+ XCTRLA_XALTCH_6_Z1 VDD pch l=0.06U
+ w=0.21U
M3977 XCTRLA_XALTCH_6_Z1 XCTRLA_XALTCH_6_AX
+ XCTRLA_XALTCH_6_Z27 VSS nch l=0.08U
+ w=0.21U
M3978 XCTRLA_XDEC3DXA_4_Z3 XCTRLA_AC_5
+ XCTRLA_XDEC3DXA_4_Z2 VSS nch l=0.06U
+ w=2U
M3979 XCTRLA_XDEC3DXA_5_Z3 XCTRLA_AT_5
+ XCTRLA_XDEC3DXA_5_Z2 VSS nch l=0.06U
+ w=2U
M3980 XCTRLA_XALTCH_6_Z1 XCTRLA_CKP
+ XCTRLA_XALTCH_6_Z26 VSS nch l=0.06U
+ w=0.21U
M3981 XCTRLA_XALTCH_6_Z21 BISTT
+ XCTRLA_XALTCH_6_AX VDD pch l=0.08U
+ w=0.42U
M3982 XCTRLA_XALTCH_6_Z1 XCTRLA_XALTCH_6_AX
+ XCTRLA_XALTCH_6_Z25 VDD pch l=0.08U
+ w=0.42U
M3983 XCTRLA_XDEC3DXA_4_Z4 XCTRLA_AC_6
+ XCTRLA_XDEC3DXA_4_Z3 VSS nch l=0.06U
+ w=2U
M3984 XCTRLA_XDEC3DXA_5_Z4 XCTRLA_AC_6
+ XCTRLA_XDEC3DXA_5_Z3 VSS nch l=0.06U
+ w=2U
M3985 XCTRLA_AT_6 XCTRLA_AC_6 VSS VSS
+ nch l=0.06U
+ w=0.55U
M3986 VDD XCTRLA_AC_6 XCTRLA_AT_6 VDD
+ pch l=0.06U
+ w=1.1U
M3987 VDD XCTRLA_AC_6 XCTRLA_XDEC3DXA_4_Z1
+ VDD pch l=0.06U
+ w=0.21U
M3988 VDD XCTRLA_AC_6 XCTRLA_XDEC3DXA_5_Z1
+ VDD pch l=0.06U
+ w=0.21U
M3989 VDD XCTRLA_RSP
+ XCTRLA_XDEC3DXA_4_Z1 VDD pch l=0.06U
+ w=0.75U
M3990 VDD XCTRLA_XDEC3DXA_4_Z1 A_XA_4
+ VDD pch_hvt l=0.06U
+ w=5U
M3991 XCTRLA_XALTCH_6_Z21 AA_6 VDD VDD
+ pch l=0.08U
+ w=0.42U
M3992 XCTRLA_AT_6 XCTRLA_AC_6 VSS
+ VSS nch l=0.06U
+ w=0.55U
M3993 VDD XCTRLA_AC_6 XCTRLA_AT_6
+ VDD pch l=0.06U
+ w=1.1U
M3994 VDD XCTRLA_AT_7 XCTRLA_XDEC3DXA_4_Z1
+ VDD pch l=0.06U
+ w=0.21U
M3995 VDD XCTRLA_AT_7 XCTRLA_XDEC3DXA_5_Z1
+ VDD pch l=0.06U
+ w=0.21U
M3996 VDD XCTRLA_RSP XCTRLA_XDEC3DXA_4_Z1
+ VDD pch l=0.06U
+ w=0.75U
M3997 VDD XCTRLA_XDEC3DXA_4_Z1 A_XA_4
+ VDD pch_hvt l=0.06U
+ w=5U
M3998 XCTRLA_XALTCH_6_Z25 XCTRLA_CKP VDD
+ VDD pch l=0.06U
+ w=0.42U
M3999 VSS XCTRLA_AT_7 XCTRLA_XDEC3DXA_4_Z4
+ VSS nch l=0.06U
+ w=2U
M4000 VSS XCTRLA_AT_7 XCTRLA_XDEC3DXA_5_Z4
+ VSS nch l=0.06U
+ w=2U
M4001 XCTRLA_XALTCH_6_Z26 XCTRLA_AC_6 VSS
+ VSS nch l=0.06U
+ w=0.21U
M4002 XCTRLA_XDEC3DXA_2_Z4 XCTRLA_AC_7 VSS
+ VSS nch l=0.06U
+ w=2U
M4003 XCTRLA_XDEC3DXA_3_Z4 XCTRLA_AC_7 VSS
+ VSS nch l=0.06U
+ w=2U
M4004 XCTRLA_XALTCH_7_Z26 XCTRLA_AC_7 VSS
+ VSS nch l=0.06U
+ w=0.21U
M4005 XCTRLA_XALTCH_7_Z25 XCTRLA_CKP VDD
+ VDD pch l=0.06U
+ w=0.42U
M4006 XCTRLA_XALTCH_7_Z21 AA_7 VDD VDD
+ pch l=0.08U
+ w=0.42U
M4007 XCTRLA_AT_7 XCTRLA_AC_7 VSS VSS
+ nch l=0.06U
+ w=0.55U
M4008 VDD XCTRLA_AC_7 XCTRLA_AT_7 VDD
+ pch l=0.06U
+ w=1.1U
M4009 VDD XCTRLA_AC_7 XCTRLA_XDEC3DXA_2_Z1
+ VDD pch l=0.06U
+ w=0.21U
M4010 VDD XCTRLA_AC_7 XCTRLA_XDEC3DXA_3_Z1
+ VDD pch l=0.06U
+ w=0.21U
M4011 VDD XCTRLA_RSP
+ XCTRLA_XDEC3DXA_2_Z1 VDD pch l=0.06U
+ w=0.75U
M4012 VDD XCTRLA_XDEC3DXA_2_Z1 A_XA_2
+ VDD pch_hvt l=0.06U
+ w=5U
M4013 XCTRLA_XDEC3DXA_2_Z3 XCTRLA_AT_6
+ XCTRLA_XDEC3DXA_2_Z4 VSS nch l=0.06U
+ w=2U
M4014 XCTRLA_XDEC3DXA_3_Z3 XCTRLA_AT_6
+ XCTRLA_XDEC3DXA_3_Z4 VSS nch l=0.06U
+ w=2U
M4015 XCTRLA_XALTCH_7_Z26 XCTRLA_CKP
+ XCTRLA_XALTCH_7_Z1 VSS nch l=0.06U
+ w=0.21U
M4016 XCTRLA_XALTCH_7_AX BISTT
+ XCTRLA_XALTCH_7_Z21 VDD pch l=0.08U
+ w=0.42U
M4017 XCTRLA_AT_7 XCTRLA_AC_7 VSS
+ VSS nch l=0.06U
+ w=0.55U
M4018 VDD XCTRLA_AC_7 XCTRLA_AT_7
+ VDD pch l=0.06U
+ w=1.1U
M4019 VDD XCTRLA_AT_6 XCTRLA_XDEC3DXA_2_Z1
+ VDD pch l=0.06U
+ w=0.21U
M4020 VDD XCTRLA_AT_6 XCTRLA_XDEC3DXA_3_Z1
+ VDD pch l=0.06U
+	 w=0.21U
M4021 VDD XCTRLA_RSP XCTRLA_XDEC3DXA_2_Z1
+ VDD pch l=0.06U
+ w=0.75U
M4022 VDD XCTRLA_XDEC3DXA_2_Z1 A_XA_2
+ VDD pch_hvt l=0.06U
+ w=5U
M4023 XCTRLA_XALTCH_7_Z1 XCTRLA_XALTCH_7_AX
+ XCTRLA_XALTCH_7_Z25 VDD pch l=0.08U
+ w=0.42U
M4024 XCTRLA_XDEC3DXA_2_Z2 XCTRLA_AC_5
+ XCTRLA_XDEC3DXA_2_Z3 VSS nch l=0.06U
+ w=2U
M4025 XCTRLA_XDEC3DXA_3_Z2 XCTRLA_AT_5
+ XCTRLA_XDEC3DXA_3_Z3 VSS nch l=0.06U
+ w=2U
M4026 XCTRLA_XALTCH_7_Z28 XCTRLA_CKC
+ XCTRLA_XALTCH_7_Z1 VDD pch l=0.06U
+ w=0.21U
M4027 XCTRLA_XALTCH_7_Z1 XCTRLA_XALTCH_7_AX
+ XCTRLA_XALTCH_7_Z27 VSS nch l=0.08U
+ w=0.21U
M4028 XCTRLA_XALTCH_7_Z22 BISTC
+ XCTRLA_XALTCH_7_AX VDD pch l=0.08U
+ w=0.42U
M4029 XCTRLA_AC_7 XCTRLA_XALTCH_7_Z1
+ VSS VSS nch l=0.06U
+ w=0.55U
M4030 VDD XCTRLA_XALTCH_7_Z1
+ XCTRLA_AC_7 VDD pch l=0.06U
+ w=1.1U
M4031 VDD XCTRLA_AC_5 XCTRLA_XDEC3DXA_2_Z1
+ VDD pch l=0.06U
+	 w=0.21U
M4032 VDD XCTRLA_AT_5 XCTRLA_XDEC3DXA_3_Z1
+ VDD pch l=0.06U
+ w=0.21U
M4033 VDD XCTRLA_RSP
+ XCTRLA_XDEC3DXA_3_Z1 VDD pch l=0.06U
+ w=0.75U
M4034 VDD XCTRLA_XDEC3DXA_3_Z1 A_XA_3
+ VDD pch_hvt l=0.06U
+ w=5U
M4035 XCTRLA_XDEC3DXA_2_Z2 XCTRLA_CKP
+ XCTRLA_XDEC3DXA_2_Z1 VSS nch l=0.06U
+ w=2U
M4036 XCTRLA_XDEC3DXA_3_Z2 XCTRLA_CKP
+ XCTRLA_XDEC3DXA_3_Z1 VSS nch l=0.06U
+ w=2U
M4037 VSS XVHILO_Z2 VLO VSS nch
+ l=0.06U
+ w=2.5U
M4038 VSS XVHILO_Z2 XVHILO_Z1 VSS nch
+ l=0.07U
+ w=0.41U
M4039 VDD AMA_7 XCTRLA_XALTCH_7_Z22 VDD
+ pch l=0.08U
+ w=0.42U
M4040 XCTRLA_AC_7 XCTRLA_XALTCH_7_Z1
+ VSS VSS nch l=0.06U
+ w=0.55U
M4041 VDD XCTRLA_XALTCH_7_Z1
+ XCTRLA_AC_7 VDD pch l=0.06U
+ w=1.1U
M4042 VDD XCTRLA_CKP XCTRLA_XDEC3DXA_2_Z1
+ VDD pch l=0.06U
+ w=0.21U
M4043 VDD XCTRLA_CKP XCTRLA_XDEC3DXA_3_Z1
+ VDD pch l=0.06U
+ w=0.21U
M4044 VDD XCTRLA_RSP XCTRLA_XDEC3DXA_3_Z1
+ VDD pch l=0.06U
+ w=0.75U
M4045 VDD XCTRLA_XDEC3DXA_3_Z1 A_XA_3
+ VDD pch_hvt l=0.06U
+ w=5U
M4046 VDD XCTRLA_AC_7 XCTRLA_XALTCH_7_Z28
+ VDD pch l=0.06U
+ w=0.21U
M4047 VSS XCTRLA_CKC XCTRLA_XALTCH_7_Z27
+ VSS nch l=0.06U
+	 w=0.21U
M4048 VSS XVHILO_Z1 XVHILO_Z1 VSS nch
+ l=0.07U
+ w=0.41U
M4049 VSS XVHILO_Z2 VLO VSS nch
+ l=0.06U
+ w=2.5U
M4050 VDD XCTRLA_AC_12 XCTRLA_XALTCH_12_Z28
+ VDD pch l=0.06U
+ w=0.21U
M4051 XCTRLA_XALTCH_12_Z22 AMA_12 VDD VDD
+ pch l=0.08U
+ w=0.42U
M4052 XCTRLA_XALTCH_12_Z27 XCTRLA_CKC VSS
+ VSS nch l=0.06U
+ w=0.21U
M4053 XCTRLA_AC_12 XCTRLA_XALTCH_12_Z1
+ VSS VSS nch l=0.06U
+ w=0.55U
M4054 VDD XCTRLA_XALTCH_12_Z1
+ XCTRLA_AC_12 VDD pch l=0.06U
+ w=1.1U
M4055 VDD XCTRLA_CKP XCTRLA_XDEC3DXA_0_Z1
+ VDD pch l=0.06U
+ w=0.21U
M4056 VDD XCTRLA_CKP XCTRLA_XDEC3DXA_1_Z1
+ VDD pch l=0.06U
+ w=0.21U
M4057 VDD XCTRLA_RSP
+ XCTRLA_XDEC3DXA_1_Z1 VDD pch l=0.06U
+ w=0.75U
M4058 VDD XCTRLA_XDEC3DXA_1_Z1 A_XA_1
+ VDD pch_hvt l=0.06U
+ w=5U
M4059 XCTRLA_XDEC3DXA_0_Z2 XCTRLA_CKP
+ XCTRLA_XDEC3DXA_0_Z1 VSS nch l=0.06U
+ w=2U
M4060 XCTRLA_XDEC3DXA_1_Z2 XCTRLA_CKP
+ XCTRLA_XDEC3DXA_1_Z1 VSS nch l=0.06U
+ w=2U
M4061 VSS XVHILO_Z2 VLO VSS nch
+ l=0.06U
+ w=2.5U
M4062 XCTRLA_XALTCH_12_Z22 BISTC
+ XCTRLA_XALTCH_12_AX VDD pch l=0.08U
+ w=0.42U
M4063 XCTRLA_AC_12 XCTRLA_XALTCH_12_Z1
+ VSS VSS nch l=0.06U
+ w=0.55U
M4064 VDD XCTRLA_XALTCH_12_Z1
+ XCTRLA_AC_12 VDD pch l=0.06U
+ w=1.1U
M4065 VDD XCTRLA_AC_5 XCTRLA_XDEC3DXA_0_Z1
+ VDD pch l=0.06U
+ w=0.21U
M4066 VDD XCTRLA_AT_5 XCTRLA_XDEC3DXA_1_Z1
+ VDD pch l=0.06U
+ w=0.21U
M4067 VDD XCTRLA_RSP XCTRLA_XDEC3DXA_1_Z1
+ VDD pch l=0.06U
+ w=0.75U
M4068 VDD XCTRLA_XDEC3DXA_1_Z1 A_XA_1
+ VDD pch_hvt l=0.06U
+ w=5U
M4069 XCTRLA_XALTCH_12_Z28 XCTRLA_CKC
+ XCTRLA_XALTCH_12_Z1 VDD pch l=0.06U
+ w=0.21U
M4070 XCTRLA_XALTCH_12_Z1 XCTRLA_XALTCH_12_AX
+ XCTRLA_XALTCH_12_Z27 VSS nch l=0.08U
+ w=0.21U
M4071 XCTRLA_XDEC3DXA_0_Z3 XCTRLA_AC_5
+ XCTRLA_XDEC3DXA_0_Z2 VSS nch l=0.06U
+ w=2U
M4072 XCTRLA_XDEC3DXA_1_Z3 XCTRLA_AT_5
+ XCTRLA_XDEC3DXA_1_Z2 VSS nch l=0.06U
+ w=2U
M4073 VSS XVHILO_Z2 VLO VSS nch
+ l=0.06U
+ w=2.5U
M4074 XCTRLA_XALTCH_12_Z1 XCTRLA_CKP
+ XCTRLA_XALTCH_12_Z26 VSS nch l=0.06U
+ w=0.21U
M4075 XCTRLA_XALTCH_12_Z21 BISTT
+ XCTRLA_XALTCH_12_AX VDD pch l=0.08U
+ w=0.42U
M4076 XCTRLA_XALTCH_12_Z1 XCTRLA_XALTCH_12_AX
+ XCTRLA_XALTCH_12_Z25 VDD pch l=0.08U
+ w=0.42U
M4077 XCTRLA_XDEC3DXA_0_Z3 XCTRLA_AC_6
+ XCTRLA_XDEC3DXA_0_Z4 VSS nch l=0.06U
+ w=2U
M4078 XCTRLA_XDEC3DXA_1_Z3 XCTRLA_AC_6
+ XCTRLA_XDEC3DXA_1_Z4 VSS nch l=0.06U
+ w=2U
M4079 XCTRLA_AT_12 XCTRLA_AC_12 VSS
+ VSS nch l=0.06U
+ w=0.55U
M4080 VDD XCTRLA_AC_12 XCTRLA_AT_12
+ VDD pch l=0.06U
+ w=1.1U
M4081 VDD XCTRLA_AC_6 XCTRLA_XDEC3DXA_0_Z1
+ VDD pch l=0.06U
+ w=0.21U
M4082 VDD XCTRLA_AC_6 XCTRLA_XDEC3DXA_1_Z1
+ VDD pch l=0.06U
+ w=0.21U
M4083 VDD XCTRLA_RSP
+ XCTRLA_XDEC3DXA_0_Z1 VDD pch l=0.06U
+ w=0.75U
M4084 VDD XCTRLA_XDEC3DXA_0_Z1 A_XA_0
+ VDD pch_hvt l=0.06U
+ w=5U
M4085 VDD XVHILO_Z1 XVHILO_Z2 VDD pch
+ l=0.07U
+	 w=0.41U
M4086 VDD XVHILO_Z2 XVHILO_Z2 VDD pch
+ l=0.06U
+	 w=0.41U
M4087 VDD AA_12 XCTRLA_XALTCH_12_Z21 VDD
+ pch l=0.08U
+ w=0.42U
M4088 XCTRLA_AT_12 XCTRLA_AC_12 VSS
+ VSS nch l=0.06U
+ w=0.55U
M4089 VDD XCTRLA_AC_12 XCTRLA_AT_12
+ VDD pch l=0.06U
+ w=1.1U
M4090 VDD XCTRLA_AC_7 XCTRLA_XDEC3DXA_0_Z1
+ VDD pch l=0.06U
+ w=0.21U
M4091 VDD XCTRLA_AC_7 XCTRLA_XDEC3DXA_1_Z1
+ VDD pch l=0.06U
+ w=0.21U
M4092 VDD XCTRLA_RSP XCTRLA_XDEC3DXA_0_Z1
+ VDD pch l=0.06U
+ w=0.75U
M4093 VDD XCTRLA_XDEC3DXA_0_Z1 A_XA_0
+ VDD pch_hvt l=0.06U
+ w=5U
M4094 VDD XCTRLA_CKP XCTRLA_XALTCH_12_Z25
+ VDD pch l=0.06U
+	 w=0.42U
M4095 XCTRLA_XDEC3DXA_0_Z4 XCTRLA_AC_7 VSS
+ VSS nch l=0.06U
+ w=2U
M4096 XCTRLA_XDEC3DXA_1_Z4 XCTRLA_AC_7 VSS
+ VSS nch l=0.06U
+ w=2U
M4097 VSS XCTRLA_AC_12 XCTRLA_XALTCH_12_Z26
+ VSS nch l=0.06U
+	 w=0.21U
M4098 XCTRLA_XDEC3DXC_6_Z4 XCTRLA_AT_12 VSS
+ VSS nch l=0.06U
+ w=2U
M4099 XCTRLA_XDEC3DXC_7_Z4 XCTRLA_AT_12 VSS
+ VSS nch l=0.06U
+ w=2U
M4100 XCTRLA_XALTCH_11_Z26 XCTRLA_AC_11 VSS
+ VSS nch l=0.06U
+ w=0.21U
M4101 XCTRLA_XALTCH_11_Z25 XCTRLA_CKP VDD
+ VDD pch l=0.06U
+ w=0.42U
M4102 XCTRLA_XALTCH_11_Z21 AA_11 VDD VDD
+ pch l=0.08U
+ w=0.42U
M4103 XCTRLA_AT_11 XCTRLA_AC_11 VSS
+ VSS nch l=0.06U
+ w=0.55U
M4104 VDD XCTRLA_AC_11 XCTRLA_AT_11
+ VDD pch l=0.06U
+ w=1.1U
M4105 VDD XCTRLA_AT_12 XCTRLA_XDEC3DXC_6_Z1
+ VDD pch l=0.06U
+ w=0.21U
M4106 VDD XCTRLA_AT_12 XCTRLA_XDEC3DXC_7_Z1
+ VDD pch l=0.06U
+ w=0.21U
M4107 VDD XCTRLA_RSP
+ XCTRLA_XDEC3DXC_6_Z1 VDD pch l=0.06U
+ w=0.75U
M4108 VDD XCTRLA_XDEC3DXC_6_Z1 A_XC_6
+ VDD pch_hvt l=0.06U
+ w=5U
M4109 XCTRLA_XDLRSD_Z7 XCTRLA_XDLRSD_Z6
+ VSS VSS nch l=0.06U
+ w=0.41U
M4110 XCTRLA_XDLRSD_Z7
+ XCTRLA_XDLRSD_Z6 VSS VSS nch
+ l=0.06U
+ w=0.41U
M4111 XCTRLA_XDLRSD_Z7
+ XCTRLA_XDLRSD_Z6 VSS VSS nch
+ l=0.06U
+ w=0.41U
M4112 XCTRLA_XDLRSD_Z7
+ XCTRLA_XDLRSD_Z6 VSS VSS nch
+ l=0.06U
+ w=0.41U
M4113 XCTRLA_XDLRSD_Z6 XCTRLA_XDLRSD_Z5
+ VSS VSS nch l=0.06U
+ w=0.41U
M4114 XCTRLA_XDLRSD_Z6
+ XCTRLA_XDLRSD_Z5 VSS VSS nch
+ l=0.06U
+ w=0.41U
M4115 XCTRLA_XDLRSD_Z6
+ XCTRLA_XDLRSD_Z5 VSS VSS nch
+ l=0.06U
+ w=0.41U
M4116 XCTRLA_XDLRSD_Z5 XCTRLA_XDLRSD_Z4
+ VSS VSS nch l=0.08U
+ w=0.41U
M4117 A_DLRS XCTRLA_XDLRSD_Z7 VSS VSS
+ nch l=0.06U
+ w=0.75U
M4118 A_DLRS XCTRLA_XDLRSD_Z7 VSS
+ VSS nch l=0.06U
+ w=0.75U
M4119 A_DLRS XCTRLA_XDLRSD_Z7 VSS
+ VSS nch l=0.06U
+ w=0.75U
M4120 A_DLRS XCTRLA_XDLRSD_Z7 VSS
+ VSS nch l=0.06U
+ w=0.75U
M4121 A_DLRS XCTRLA_XDLRSD_Z7 VSS
+ VSS nch l=0.06U
+ w=0.75U
M4122 A_DLRS XCTRLA_XDLRSD_Z7 VSS
+ VSS nch l=0.06U
+ w=0.75U
M4123 A_DLRS XCTRLA_XDLRSD_Z7 VSS
+ VSS nch l=0.06U
+ w=0.75U
M4124 A_DLRS XCTRLA_XDLRSD_Z7 VSS
+ VSS nch l=0.06U
+ w=0.75U
M4125 A_DLRS XCTRLA_XDLRSD_Z7 VSS
+ VSS nch l=0.06U
+ w=0.75U
M4126 A_DLRS XCTRLA_XDLRSD_Z7 VSS
+ VSS nch l=0.06U
+ w=0.75U
M4127 VSS XCTRLA_XDLRSD_Z37
+ XCTRLA_XDLRSD_XI74_NET9 VSS nch l=0.14U
+ w=0.41U
M4128 XCTRLA_XDLRSD_Z37 XCTRLA_XDLRSD_Z36
+ VSS VSS nch l=0.06U
+ w=0.41U
M4129 XCTRLA_XDLRSD_Z4 XCTRLA_XDLRSD_Z3
+ VSS VSS nch l=0.06U
+ w=0.41U
M4130 XCTRLA_XDLRSD_Z3 XCTRLA_XDLRSD_Z2
+ VSS VSS nch l=0.08U
+ w=0.21U
M4131 XCTRLA_XDLRSD_XND1_NET9 XCTRLA_XDLRSD_Z38
+ VSS VSS nch l=0.06U
+ w=0.41U
M4132 XCTRLA_XDLRSD_Z1 A_RD VSS VSS
+ nch l=0.06U
+ w=0.41U
M4133 XCTRLA_XDLRSD_Z33 XCTRLA_XDLRSD_Z32
+ VSS VSS nch l=0.06U
+ w=0.41U
M4134 XCTRLA_XDLRSD_Z34 XCTRLA_XDLRSD_Z33
+ VSS VSS nch l=0.14U
+ w=0.41U
M4135 XCTRLA_XDLRSD_Z2 XCTRLA_XDLRSD_Z1
+ XCTRLA_XDLRSD_XND1_NET9 VSS nch l=0.06U
+ w=0.41U
M4136 XCTRLA_XDLRSD_XI74_NET9 XCTRLA_XDLRSD_Z29
+ XCTRLA_XDLRSD_Z38 VSS nch l=0.14U
+ w=0.41U
M4137 XCTRLA_XDLRSD_Z32 XCTRLA_XDLRSD_Z31
+ VSS VSS nch l=0.14U
+ w=0.41U
M4138 XCTRLA_XDLRSD_Z35 XCTRLA_XDLRSD_Z34
+ VSS VSS nch l=0.06U
+ w=0.41U
M4139 XCTRLA_XDLRSD_Z36 XCTRLA_XDLRSD_Z35
+ VSS VSS nch l=0.14U
+ w=0.41U
M4140 XCTRLA_XDLRSD_Z23 XCTRLA_XDLRSD_Z22
+ VSS VSS nch l=0.06U
+ w=0.41U
M4141 XCTRLA_XDLRSD_Z26 XCTRLA_XDLRSD_Z25
+ VSS VSS nch l=0.14U
+ w=0.41U
M4142 XCTRLA_XDLRSD_Z25 XCTRLA_XDLRSD_Z24
+ VSS VSS nch l=0.06U
+ w=0.41U
M4143 XCTRLA_XDLRSD_Z28 XCTRLA_XDLRSD_Z27
+ VSS VSS nch l=0.14U
+ w=0.41U
M4144 XCTRLA_XDLRSD_Z27 XCTRLA_XDLRSD_Z26
+ VSS VSS nch l=0.06U
+ w=0.41U
M4145 XCTRLA_XDLRSD_Z24 XCTRLA_XDLRSD_Z23
+ VSS VSS nch l=0.14U
+ w=0.41U
M4146 XCTRLA_XDLRSD_Z22 XCTRLA_XDLRSD_Z21
+ VSS VSS nch l=0.14U
+ w=0.41U
M4147 XCTRLA_XDLRSD_Z21 XCTRLA_XDLRSD_Z20
+ VSS VSS nch l=0.06U
+ w=0.41U
M4148 VSS XCTRLA_XDLRSD_Z15
+ XCTRLA_XDLRSD_XND5_NET14 VSS nch
+ l=0.08U
+ w=0.41U
M4149 XCTRLA_XDLRSD_XND5_NET14
+	XCTRLA_XDLRSD_Z11 XCTRLA_XDLRSD_XND5_NET17 VSS
+ nch l=0.08U
+ w=0.41U
M4150 XCTRLA_XDLRSD_Z20 XCTRLA_XDLRSD_Z1
+ XCTRLA_XDLRSD_XND5_NET17 VSS nch
+ l=0.08U
+ w=0.41U
M4151 XCTRLA_XDLRSD_Z29 XCTRLA_XDLRSD_Z28
+ VSS VSS nch l=0.06U
+ w=0.41U
M4152 XCTRLA_XDLRSD_Z31 XCTRLA_XDLRSD_Z30
+ VSS VSS nch l=0.06U
+ w=0.41U
M4153 XCTRLA_XDLRSD_Z30 XCTRLA_XDLRSD_Z29
+ VSS VSS nch l=0.14U
+ w=0.41U
M4154 VSS XCTRLA_XDLRSD_Z12
+ XCTRLA_XDLRSD_XND4_NET9 VSS nch l=0.06U
+ w=0.41U
M4155 XCTRLA_XDLRSD_XND3_NET9 VS_0
+ XCTRLA_XDLRSD_Z11 VSS nch l=0.06U
+ w=0.41U
M4156 XCTRLA_XDLRSD_Z15
+ XCTRLA_XDLRSD_Z14 VSS VSS nch
+ l=0.06U
+ w=0.21U
M4157 VSS XCTRLA_XDLRSD_Z10
+ XCTRLA_XDLRSD_XND3_NET9 VSS nch l=0.06U
+ w=0.41U
M4158 XCTRLA_XDLRSD_XND2_NET9 XCTRLA_XDLRSD_Z15
+ VSS VSS nch l=0.08U
+ w=0.41U
M4159 XCTRLA_XDLRSD_Z14
+ XCTRLA_XDLRSD_Z13 VSS VSS nch
+ l=0.08U
+ w=0.21U
M4160 XCTRLA_XDLRSD_Z10 XCTRLA_XDLRSD_Z1
+ XCTRLA_XDLRSD_XND2_NET9 VSS nch l=0.08U
+ w=0.41U
M4161 XCTRLA_XDLRSD_XND4_NET9 VS_1
+ XCTRLA_XDLRSD_Z13 VSS nch l=0.06U
+ w=0.41U
M4162 XCTRLA_XDLRSD_Z12
+ XCTRLA_XDLRSD_Z1 VSS VSS nch
+ l=0.08U
+ w=0.21U
M4163 XCTRLA_XDEC3DXC_6_Z3 XCTRLA_AT_11
+ XCTRLA_XDEC3DXC_6_Z4 VSS nch l=0.06U
+ w=2U
M4164 XCTRLA_XDEC3DXC_7_Z3 XCTRLA_AT_11
+ XCTRLA_XDEC3DXC_7_Z4 VSS nch l=0.06U
+ w=2U
M4165 XCTRLA_XALTCH_11_Z26 XCTRLA_CKP
+ XCTRLA_XALTCH_11_Z1 VSS nch l=0.06U
+ w=0.21U
M4166 XCTRLA_XALTCH_11_Z21 BISTT
+ XCTRLA_XALTCH_11_AX VDD pch l=0.08U
+ w=0.42U
M4167 XCTRLA_AT_11 XCTRLA_AC_11 VSS
+ VSS nch l=0.06U
+ w=0.55U
M4168 VDD XCTRLA_AC_11 XCTRLA_AT_11
+ VDD pch l=0.06U
+ w=1.1U
M4169 VDD XCTRLA_AT_11 XCTRLA_XDEC3DXC_6_Z1
+ VDD pch l=0.06U
+ w=0.21U
M4170 VDD XCTRLA_AT_11 XCTRLA_XDEC3DXC_7_Z1
+ VDD pch l=0.06U
+ w=0.21U
M4171 VDD XCTRLA_RSP XCTRLA_XDEC3DXC_6_Z1
+ VDD pch l=0.06U
+ w=0.75U
M4172 VDD XCTRLA_XDEC3DXC_6_Z1 A_XC_6
+ VDD pch_hvt l=0.06U
+ w=5U
M4173 XCTRLA_XALTCH_11_Z1 XCTRLA_XALTCH_11_AX
+ XCTRLA_XALTCH_11_Z25 VDD pch l=0.08U
+ w=0.42U
M4174 XCTRLA_XDEC3DXC_6_Z3 XCTRLA_AC_10
+ XCTRLA_XDEC3DXC_6_Z2 VSS nch l=0.06U
+ w=2U
M4175 XCTRLA_XDEC3DXC_7_Z3 XCTRLA_AT_10
+ XCTRLA_XDEC3DXC_7_Z2 VSS nch l=0.06U
+ w=2U
M4176 VDD XVHILO_Z1 VHI VDD pch
+ l=0.06U
+ w=3.335U
M4177 VDD XVHILO_Z1 VHI VDD pch
+ l=0.06U
+ w=3.335U
M4178 VDD XVHILO_Z1 VHI VDD pch
+ l=0.06U
+ w=3.335U
M4179 VDD XVHILO_Z1 VHI VDD pch
+ l=0.06U
+ w=3.335U
M4180 VDD XVHILO_Z1 VHI VDD pch
+ l=0.06U
+ w=3.335U
M4181 VDD XVHILO_Z1 VHI VDD pch
+ l=0.06U
+ w=3.325U
M4182 XCTRLA_XALTCH_11_Z28 XCTRLA_CKC
+ XCTRLA_XALTCH_11_Z1 VDD pch l=0.06U
+ w=0.21U
M4183 XCTRLA_XALTCH_11_Z1 XCTRLA_XALTCH_11_AX
+ XCTRLA_XALTCH_11_Z27 VSS nch l=0.08U
+ w=0.21U
M4184 XCTRLA_XALTCH_11_Z22 BISTC
+ XCTRLA_XALTCH_11_AX VDD pch l=0.08U
+ w=0.42U
M4185 XCTRLA_AC_11 XCTRLA_XALTCH_11_Z1
+ VSS VSS nch l=0.06U
+ w=0.55U
M4186 VDD XCTRLA_XALTCH_11_Z1
+ XCTRLA_AC_11 VDD pch l=0.06U
+ w=1.1U
M4187 VDD XCTRLA_AC_10 XCTRLA_XDEC3DXC_6_Z1
+ VDD pch l=0.06U
+ w=0.21U
M4188 VDD XCTRLA_AT_10 XCTRLA_XDEC3DXC_7_Z1
+ VDD pch l=0.06U
+ w=0.21U
M4189 VDD XCTRLA_RSP
+ XCTRLA_XDEC3DXC_7_Z1 VDD pch l=0.06U
+ w=0.75U
M4190 VDD XCTRLA_XDEC3DXC_7_Z1 A_XC_7
+ VDD pch_hvt l=0.06U
+ w=5U
M4191 XCTRLA_XDEC3DXC_6_Z1 XCTRLA_CKP
+ XCTRLA_XDEC3DXC_6_Z2 VSS nch l=0.06U
+ w=2U
M4192 XCTRLA_XDEC3DXC_7_Z1 XCTRLA_CKP
+ XCTRLA_XDEC3DXC_7_Z2 VSS nch l=0.06U
+ w=2U
M4193 VDD XCTRLA_CKP XCTRLA_XDWLDV_DWLC
+ VDD pch l=0.06U
+	 w=0.61U
M4194 VDD XCTRLA_XDWLDV_DWLC A_DWL VDD
+ pch_hvt l=0.06U
+	 w=2.5U
M4195 VDD XCTRLA_XDWLDV_DWLC A_DWL
+ VDD pch_hvt l=0.06U
+	 w=2.5U
M4196 VDD XCTRLA_XDWLDV_DWLC A_DWL
+ VDD pch_hvt l=0.06U
+	 w=2.5U
M4197 XCTRLA_XALTCH_11_Z22 AMA_11 VDD VDD
+ pch l=0.08U
+ w=0.42U
M4198 XCTRLA_AC_11 XCTRLA_XALTCH_11_Z1
+ VSS VSS nch l=0.06U
+ w=0.55U
M4199 VDD XCTRLA_XALTCH_11_Z1
+ XCTRLA_AC_11 VDD pch l=0.06U
+ w=1.1U
M4200 VDD XCTRLA_CKP XCTRLA_XDEC3DXC_6_Z1
+ VDD pch l=0.06U
+ w=0.21U
M4201 VDD XCTRLA_CKP XCTRLA_XDEC3DXC_7_Z1
+ VDD pch l=0.06U
+ w=0.21U
M4202 VDD XCTRLA_RSP XCTRLA_XDEC3DXC_7_Z1
+ VDD pch l=0.06U
+ w=0.75U
M4203 VDD XCTRLA_XDEC3DXC_7_Z1 A_XC_7
+ VDD pch_hvt l=0.06U
+ w=5U
M4204 XCTRLA_XALTCH_11_Z28 XCTRLA_AC_11 VDD
+ VDD pch l=0.06U
+ w=0.21U
M4205 XCTRLA_XALTCH_11_Z27 XCTRLA_CKC VSS
+ VSS nch l=0.06U
+	 w=0.21U
M4206 XCTRLA_XALTCH_10_Z28 XCTRLA_AC_10 VDD
+ VDD pch l=0.06U
+ w=0.21U
M4207 XCTRLA_XALTCH_10_Z22 AMA_10 VDD VDD
+ pch l=0.08U
+ w=0.42U
M4208 XCTRLA_XALTCH_10_Z27 XCTRLA_CKC VSS
+ VSS nch l=0.06U
+	 w=0.21U
M4209 XCTRLA_AC_10 XCTRLA_XALTCH_10_Z1
+ VSS VSS nch l=0.06U
+ w=0.55U
M4210 VDD XCTRLA_XALTCH_10_Z1
+ XCTRLA_AC_10 VDD pch l=0.06U
+ w=1.1U
M4211 VDD XCTRLA_CKP XCTRLA_XDEC3DXC_4_Z1
+ VDD pch l=0.06U
+ w=0.21U
M4212 VDD XCTRLA_CKP XCTRLA_XDEC3DXC_5_Z1
+ VDD pch l=0.06U
+ w=0.21U
M4213 VDD XCTRLA_RSP
+ XCTRLA_XDEC3DXC_5_Z1 VDD pch l=0.06U
+ w=0.75U
M4214 VDD XCTRLA_XDEC3DXC_5_Z1 A_XC_5
+ VDD pch_hvt l=0.06U
+ w=5U
M4215 XCTRLA_XDEC3DXC_4_Z2 XCTRLA_CKP
+ XCTRLA_XDEC3DXC_4_Z1 VSS nch l=0.06U
+ w=2U
M4216 XCTRLA_XDEC3DXC_5_Z2 XCTRLA_CKP
+ XCTRLA_XDEC3DXC_5_Z1 VSS nch l=0.06U
+ w=2U
M4217 XCTRLA_XALTCH_10_Z22 BISTC
+ XCTRLA_XALTCH_10_AX VDD pch l=0.08U
+ w=0.42U
M4218 XCTRLA_AC_10 XCTRLA_XALTCH_10_Z1
+ VSS VSS nch l=0.06U
+ w=0.55U
M4219 VDD XCTRLA_XALTCH_10_Z1
+ XCTRLA_AC_10 VDD pch l=0.06U
+ w=1.1U
M4220 VDD XCTRLA_AC_10 XCTRLA_XDEC3DXC_4_Z1
+ VDD pch l=0.06U
+ w=0.21U
M4221 VDD XCTRLA_AT_10 XCTRLA_XDEC3DXC_5_Z1
+ VDD pch l=0.06U
+	 w=0.21U
M4222 VDD XCTRLA_RSP XCTRLA_XDEC3DXC_5_Z1
+ VDD pch l=0.06U
+ w=0.75U
M4223 VDD XCTRLA_XDEC3DXC_5_Z1 A_XC_5
+ VDD pch_hvt l=0.06U
+ w=5U
M4224 XCTRLA_XALTCH_10_Z28 XCTRLA_CKC
+ XCTRLA_XALTCH_10_Z1 VDD pch l=0.06U
+ w=0.21U
M4225 XCTRLA_XALTCH_10_Z1 XCTRLA_XALTCH_10_AX
+ XCTRLA_XALTCH_10_Z27 VSS nch l=0.08U
+ w=0.21U
M4226 XCTRLA_XDEC3DXC_4_Z3 XCTRLA_AC_10
+ XCTRLA_XDEC3DXC_4_Z2 VSS nch l=0.06U
+ w=2U
M4227 XCTRLA_XDEC3DXC_5_Z3 XCTRLA_AT_10
+ XCTRLA_XDEC3DXC_5_Z2 VSS nch l=0.06U
+ w=2U
M4228 XCTRLA_XALTCH_10_Z1 XCTRLA_CKP
+ XCTRLA_XALTCH_10_Z26 VSS nch l=0.06U
+ w=0.21U
M4229 XCTRLA_XALTCH_10_Z21 BISTT
+ XCTRLA_XALTCH_10_AX VDD pch l=0.08U
+ w=0.42U
M4230 XCTRLA_XALTCH_10_Z25 XCTRLA_XALTCH_10_AX
+ XCTRLA_XALTCH_10_Z1 VDD pch l=0.08U
+ w=0.42U
M4231 XCTRLA_XDEC3DXC_4_Z3 XCTRLA_AC_11
+ XCTRLA_XDEC3DXC_4_Z4 VSS nch l=0.06U
+ w=2U
M4232 XCTRLA_XDEC3DXC_5_Z3 XCTRLA_AC_11
+ XCTRLA_XDEC3DXC_5_Z4 VSS nch l=0.06U
+ w=2U
M4233 XCTRLA_AT_10 XCTRLA_AC_10 VSS
+ VSS nch l=0.06U
+ w=0.55U
M4234 VDD XCTRLA_AC_10 XCTRLA_AT_10
+ VDD pch l=0.06U
+ w=1.1U
M4235 VDD XCTRLA_AC_11 XCTRLA_XDEC3DXC_4_Z1
+ VDD pch l=0.06U
+ w=0.21U
M4236 VDD XCTRLA_AC_11 XCTRLA_XDEC3DXC_5_Z1
+ VDD pch l=0.06U
+ w=0.21U
M4237 VDD XCTRLA_RSP
+ XCTRLA_XDEC3DXC_4_Z1 VDD pch l=0.06U
+ w=0.75U
M4238 VDD XCTRLA_XDEC3DXC_4_Z1 A_XC_4
+ VDD pch_hvt l=0.06U
+ w=5U
M4239 VDD AA_10 XCTRLA_XALTCH_10_Z21 VDD
+ pch l=0.08U
+ w=0.42U
M4240 XCTRLA_AT_10 XCTRLA_AC_10 VSS
+ VSS nch l=0.06U
+ w=0.55U
M4241 VDD XCTRLA_AC_10 XCTRLA_AT_10
+ VDD pch l=0.06U
+ w=1.1U
M4242 VDD XCTRLA_AT_12 XCTRLA_XDEC3DXC_4_Z1
+ VDD pch l=0.06U
+ w=0.21U
M4243 VDD XCTRLA_AT_12 XCTRLA_XDEC3DXC_5_Z1
+ VDD pch l=0.06U
+ w=0.21U
M4244 VDD XCTRLA_RSP XCTRLA_XDEC3DXC_4_Z1
+ VDD pch l=0.06U
+ w=0.75U
M4245 VDD XCTRLA_XDEC3DXC_4_Z1 A_XC_4
+ VDD pch_hvt l=0.06U
+ w=5U
M4246 VDD XCTRLA_CKP XCTRLA_XALTCH_10_Z25
+ VDD pch l=0.06U
+ w=0.42U
M4247 VSS XCTRLA_AT_12 XCTRLA_XDEC3DXC_4_Z4
+ VSS nch l=0.06U
+ w=2U
M4248 VSS XCTRLA_AT_12 XCTRLA_XDEC3DXC_5_Z4
+ VSS nch l=0.06U
+ w=2U
M4249 VSS XCTRLA_AC_10 XCTRLA_XALTCH_10_Z26
+ VSS nch l=0.06U
+ w=0.21U
M4250 XCTRLA_XDEC3DXC_2_Z4 XCTRLA_AC_12 VSS
+ VSS nch l=0.06U
+ w=2U
M4251 XCTRLA_XDEC3DXC_3_Z4 XCTRLA_AC_12 VSS
+ VSS nch l=0.06U
+ w=2U
M4252 XCTRLA_XALTCH_8_Z26 XCTRLA_AC_8 VSS
+ VSS nch l=0.06U
+ w=0.21U
M4253 VDD XCTRLA_CKP XCTRLA_XALTCH_8_Z25
+ VDD pch l=0.06U
+ w=0.42U
M4254 XCTRLA_XALTCH_8_Z21 AA_8 VDD VDD
+ pch l=0.08U
+ w=0.42U
M4255 XCTRLA_AT_8 XCTRLA_AC_8 VSS
+ VSS nch l=0.06U
+ w=0.55U
M4256 VDD XCTRLA_AC_8 XCTRLA_AT_8 VDD
+ pch l=0.06U
+ w=1.1U
M4257 VDD XCTRLA_AC_12 XCTRLA_XDEC3DXC_2_Z1
+ VDD pch l=0.06U
+ w=0.21U
M4258 VDD XCTRLA_AC_12 XCTRLA_XDEC3DXC_3_Z1
+ VDD pch l=0.06U
+ w=0.21U
M4259 VDD XCTRLA_RSP
+ XCTRLA_XDEC3DXC_2_Z1 VDD pch l=0.06U
+ w=0.75U
M4260 VDD XCTRLA_XDEC3DXC_2_Z1 A_XC_2
+ VDD pch_hvt l=0.06U
+ w=5U
M4261 XCTRLA_XDEC3DXC_2_Z3 XCTRLA_AT_11
+ XCTRLA_XDEC3DXC_2_Z4 VSS nch l=0.06U
+ w=2U
M4262 XCTRLA_XDEC3DXC_3_Z3 XCTRLA_AT_11
+ XCTRLA_XDEC3DXC_3_Z4 VSS nch l=0.06U
+ w=2U
M4263 XCTRLA_XALTCH_8_Z1 XCTRLA_CKP
+ XCTRLA_XALTCH_8_Z26 VSS nch l=0.06U
+ w=0.21U
M4264 XCTRLA_XALTCH_8_Z21 BISTT
+ XCTRLA_XALTCH_8_AX VDD pch l=0.08U
+ w=0.42U
M4265 XCTRLA_AT_8 XCTRLA_AC_8 VSS VSS
+ nch l=0.06U
+ w=0.55U
M4266 VDD XCTRLA_AC_8 XCTRLA_AT_8
+ VDD pch l=0.06U
+ w=1.1U
M4267 VDD XCTRLA_AT_11 XCTRLA_XDEC3DXC_2_Z1
+ VDD pch l=0.06U
+ w=0.21U
M4268 VDD XCTRLA_AT_11 XCTRLA_XDEC3DXC_3_Z1
+ VDD pch l=0.06U
+ w=0.21U
M4269 VDD XCTRLA_RSP XCTRLA_XDEC3DXC_2_Z1
+ VDD pch l=0.06U
+ w=0.75U
M4270 VDD XCTRLA_XDEC3DXC_2_Z1 A_XC_2
+ VDD pch_hvt l=0.06U
+ w=5U
M4271 XCTRLA_XALTCH_8_Z25 XCTRLA_XALTCH_8_AX
+ XCTRLA_XALTCH_8_Z1 VDD pch l=0.08U
+ w=0.42U
M4272 XCTRLA_XDEC3DXC_2_Z2 XCTRLA_AC_10
+ XCTRLA_XDEC3DXC_2_Z3 VSS nch l=0.06U
+ w=2U
M4273 XCTRLA_XDEC3DXC_3_Z2 XCTRLA_AT_10
+ XCTRLA_XDEC3DXC_3_Z3 VSS nch l=0.06U
+ w=2U
M4274 XCTRLA_XALTCH_8_Z28 XCTRLA_CKC
+ XCTRLA_XALTCH_8_Z1 VDD pch l=0.06U
+ w=0.21U
M4275 XCTRLA_XALTCH_8_Z1 XCTRLA_XALTCH_8_AX
+ XCTRLA_XALTCH_8_Z27 VSS nch l=0.08U
+ w=0.21U
M4276 XCTRLA_XALTCH_8_Z22 BISTC
+ XCTRLA_XALTCH_8_AX VDD pch l=0.08U
+ w=0.42U
M4277 XCTRLA_AC_8 XCTRLA_XALTCH_8_Z1
+ VSS VSS nch l=0.06U
+ w=0.55U
M4278 VDD XCTRLA_XALTCH_8_Z1
+ XCTRLA_AC_8 VDD pch l=0.06U
+ w=1.1U
M4279 VDD XCTRLA_AC_10 XCTRLA_XDEC3DXC_2_Z1
+ VDD pch l=0.06U
+ w=0.21U
M4280 VDD XCTRLA_AT_10 XCTRLA_XDEC3DXC_3_Z1
+ VDD pch l=0.06U
+ w=0.21U
M4281 VDD XCTRLA_RSP
+ XCTRLA_XDEC3DXC_3_Z1 VDD pch l=0.06U
+ w=0.75U
M4282 VDD XCTRLA_XDEC3DXC_3_Z1 A_XC_3
+ VDD pch_hvt l=0.06U
+ w=5U
M4283 XCTRLA_XDEC3DXC_2_Z2 XCTRLA_CKP
+ XCTRLA_XDEC3DXC_2_Z1 VSS nch l=0.06U
+ w=2U
M4284 XCTRLA_XDEC3DXC_3_Z2 XCTRLA_CKP
+ XCTRLA_XDEC3DXC_3_Z1 VSS nch l=0.06U
+ w=2U
M4285 VDD AMA_8 XCTRLA_XALTCH_8_Z22 VDD
+ pch l=0.08U
+ w=0.42U
M4286 XCTRLA_AC_8 XCTRLA_XALTCH_8_Z1
+ VSS VSS nch l=0.06U
+ w=0.55U
M4287 VDD XCTRLA_XALTCH_8_Z1
+ XCTRLA_AC_8 VDD pch l=0.06U
+ w=1.1U
M4288 VDD XCTRLA_CKP XCTRLA_XDEC3DXC_2_Z1
+ VDD pch l=0.06U
+ w=0.21U
M4289 VDD XCTRLA_CKP XCTRLA_XDEC3DXC_3_Z1
+ VDD pch l=0.06U
+ w=0.21U
M4290 VDD XCTRLA_RSP XCTRLA_XDEC3DXC_3_Z1
+ VDD pch l=0.06U
+ w=0.75U
M4291 VDD XCTRLA_XDEC3DXC_3_Z1 A_XC_3
+ VDD pch_hvt l=0.06U
+ w=5U
M4292 VDD XCTRLA_AC_8 XCTRLA_XALTCH_8_Z28
+ VDD pch l=0.06U
+ w=0.21U
M4293 VSS XCTRLA_CKC XCTRLA_XALTCH_8_Z27
+ VSS nch l=0.06U
+	 w=0.21U
M4294 VDD XCTRLA_AC_9 XCTRLA_XALTCH_9_Z28
+ VDD pch l=0.06U
+ w=0.21U
M4295 XCTRLA_XALTCH_9_Z22 AMA_9 VDD VDD
+ pch l=0.08U
+ w=0.42U
M4296 XCTRLA_XALTCH_9_Z27 XCTRLA_CKC VSS
+ VSS nch l=0.06U
+ w=0.21U
M4297 XCTRLA_AC_9 XCTRLA_XALTCH_9_Z1
+ VSS VSS nch l=0.06U
+ w=0.55U
M4298 VDD XCTRLA_XALTCH_9_Z1
+ XCTRLA_AC_9 VDD pch l=0.06U
+ w=1.1U
M4299 VDD XCTRLA_CKP XCTRLA_XDEC3DXC_0_Z1
+ VDD pch l=0.06U
+ w=0.21U
M4300 VDD XCTRLA_CKP XCTRLA_XDEC3DXC_1_Z1
+ VDD pch l=0.06U
+ w=0.21U
M4301 VDD XCTRLA_RSP
+ XCTRLA_XDEC3DXC_1_Z1 VDD pch l=0.06U
+ w=0.75U
M4302 VDD XCTRLA_XDEC3DXC_1_Z1 A_XC_1
+ VDD pch_hvt l=0.06U
+ w=5U
M4303 XCTRLA_XDEC3DXC_0_Z2 XCTRLA_CKP
+ XCTRLA_XDEC3DXC_0_Z1 VSS nch l=0.06U
+ w=2U
M4304 XCTRLA_XDEC3DXC_1_Z2 XCTRLA_CKP
+ XCTRLA_XDEC3DXC_1_Z1 VSS nch l=0.06U
+ w=2U
M4305 XCTRLA_XALTCH_9_Z22 BISTC
+ XCTRLA_XALTCH_9_AX VDD pch l=0.08U
+ w=0.42U
M4306 XCTRLA_AC_9 XCTRLA_XALTCH_9_Z1
+ VSS VSS nch l=0.06U
+ w=0.55U
M4307 VDD XCTRLA_XALTCH_9_Z1
+ XCTRLA_AC_9 VDD pch l=0.06U
+ w=1.1U
M4308 VDD XCTRLA_AC_10 XCTRLA_XDEC3DXC_0_Z1
+ VDD pch l=0.06U
+ w=0.21U
M4309 VDD XCTRLA_AT_10 XCTRLA_XDEC3DXC_1_Z1
+ VDD pch l=0.06U
+ w=0.21U
M4310 VDD XCTRLA_RSP XCTRLA_XDEC3DXC_1_Z1
+ VDD pch l=0.06U
+ w=0.75U
M4311 VDD XCTRLA_XDEC3DXC_1_Z1 A_XC_1
+ VDD pch_hvt l=0.06U
+ w=5U
M4312 XCTRLA_XALTCH_9_Z28 XCTRLA_CKC
+ XCTRLA_XALTCH_9_Z1 VDD pch l=0.06U
+ w=0.21U
M4313 XCTRLA_XALTCH_9_Z1 XCTRLA_XALTCH_9_AX
+ XCTRLA_XALTCH_9_Z27 VSS nch l=0.08U
+ w=0.21U
M4314 XCTRLA_XDEC3DXC_0_Z3 XCTRLA_AC_10
+ XCTRLA_XDEC3DXC_0_Z2 VSS nch l=0.06U
+ w=2U
M4315 XCTRLA_XDEC3DXC_1_Z3 XCTRLA_AT_10
+ XCTRLA_XDEC3DXC_1_Z2 VSS nch l=0.06U
+ w=2U
M4316 XCTRLA_XALTCH_9_Z26 XCTRLA_CKP
+ XCTRLA_XALTCH_9_Z1 VSS nch l=0.06U
+ w=0.21U
M4317 XCTRLA_XALTCH_9_Z21 BISTT
+ XCTRLA_XALTCH_9_AX VDD pch l=0.08U
+ w=0.42U
M4318 XCTRLA_XALTCH_9_Z25 XCTRLA_XALTCH_9_AX
+ XCTRLA_XALTCH_9_Z1 VDD pch l=0.08U
+ w=0.42U
M4319 XCTRLA_XDEC3DXC_0_Z4 XCTRLA_AC_11
+ XCTRLA_XDEC3DXC_0_Z3 VSS nch l=0.06U
+ w=2U
M4320 XCTRLA_XDEC3DXC_1_Z4 XCTRLA_AC_11
+ XCTRLA_XDEC3DXC_1_Z3 VSS nch l=0.06U
+ w=2U
M4321 XCTRLA_AT_9 XCTRLA_AC_9 VSS VSS
+ nch l=0.06U
+ w=0.55U
M4322 VDD XCTRLA_AC_9 XCTRLA_AT_9 VDD
+ pch l=0.06U
+ w=1.1U
M4323 VDD XCTRLA_AC_11 XCTRLA_XDEC3DXC_0_Z1
+ VDD pch l=0.06U
+ w=0.21U
M4324 VDD XCTRLA_AC_11 XCTRLA_XDEC3DXC_1_Z1
+ VDD pch l=0.06U
+ w=0.21U
M4325 VDD XCTRLA_RSP
+ XCTRLA_XDEC3DXC_0_Z1 VDD pch l=0.06U
+ w=0.75U
M4326 VDD XCTRLA_XDEC3DXC_0_Z1 A_XC_0
+ VDD pch_hvt l=0.06U
+ w=5U
M4327 XCTRLA_XALTCH_9_Z21 AA_9 VDD VDD
+ pch l=0.08U
+ w=0.42U
M4328 XCTRLA_AT_9 XCTRLA_AC_9 VSS
+ VSS nch l=0.06U
+ w=0.55U
M4329 VDD XCTRLA_AC_9 XCTRLA_AT_9
+ VDD pch l=0.06U
+ w=1.1U
M4330 VDD XCTRLA_AC_12 XCTRLA_XDEC3DXC_0_Z1
+ VDD pch l=0.06U
+ w=0.21U
M4331 VSS XCTRLA_AC_12 XCTRLA_XDEC3DXC_0_Z4
+ VSS nch l=0.06U
+ w=2U
M4332 VSS XCTRLA_AC_12 XCTRLA_XDEC3DXC_1_Z4
+ VSS nch l=0.06U
+ w=2U
M4333 VDD XCTRLA_AC_12 XCTRLA_XDEC3DXC_1_Z1
+ VDD pch l=0.06U
+ w=0.21U
M4334 VDD XCTRLA_RSP XCTRLA_XDEC3DXC_0_Z1
+ VDD pch l=0.06U
+ w=0.75U
M4335 VDD XCTRLA_XDEC3DXC_0_Z1 A_XC_0
+ VDD pch_hvt l=0.06U
+ w=5U
M4336 XCTRLA_XALTCH_9_Z25 XCTRLA_CKP VDD
+ VDD pch l=0.06U
+	 w=0.42U
M4337 VSS XCTRLA_AC_9 XCTRLA_XALTCH_9_Z26
+ VSS nch l=0.06U
+ w=0.21U
M4338 XCTRLA_XALTCH_0_Z26 XCTRLA_AC_0 VSS
+ VSS nch l=0.06U
+ w=0.21U
M4339 VDD XCTRLA_CKP XCTRLA_XALTCH_0_Z25
+ VDD pch l=0.06U
+	 w=0.42U
M4340 XCTRLA_XALTCH_0_Z21 AA_0 VDD VDD
+ pch l=0.08U
+ w=0.42U
M4341 XCTRLA_AT_0 XCTRLA_AC_0 VSS
+ VSS nch l=0.06U
+ w=0.55U
M4342 VDD XCTRLA_AC_0 XCTRLA_AT_0
+ VDD pch l=0.06U
+ w=1.1U
M4343 VDD XCTRLA_AT_9
+ XCTRLA_XDEC3DXB_2_Z1 VDD pch l=0.06U
+ w=0.21U
M4344 XCTRLA_XDEC3DXB_2_XND0_NET14
+ XCTRLA_AT_9 VSS VSS nch l=0.06U
+ w=2U
M4345 XCTRLA_XDEC3DXB_3_XND0_NET14
+ XCTRLA_AT_9 VSS VSS nch l=0.06U
+ w=2U
M4346 VDD XCTRLA_AT_9
+ XCTRLA_XDEC3DXB_3_Z1 VDD pch l=0.06U
+ w=0.21U
M4347 VDD XCTRLA_RSP XCTRLA_XDEC3DXB_2_Z1
+ VDD pch l=0.06U
+ w=0.75U
M4348 VDD XCTRLA_XDEC3DXB_2_Z1 A_XB_2
+ VDD pch_hvt l=0.06U
+ w=5U
M4349 XCTRLA_XALTCH_0_Z26 XCTRLA_CKP
+ XCTRLA_XALTCH_0_Z1 VSS nch l=0.06U
+ w=0.21U
M4350 XCTRLA_XALTCH_0_AX BISTT
+ XCTRLA_XALTCH_0_Z21 VDD pch l=0.08U
+ w=0.42U
M4351 XCTRLA_AT_0 XCTRLA_AC_0 VSS VSS
+ nch l=0.06U
+ w=0.55U
M4352 VDD XCTRLA_AC_0 XCTRLA_AT_0 VDD
+ pch l=0.06U
+ w=1.1U
M4353 VDD XCTRLA_AC_8
+ XCTRLA_XDEC3DXB_2_Z1 VDD pch l=0.06U
+ w=0.21U
M4354 VDD XCTRLA_AT_8
+ XCTRLA_XDEC3DXB_3_Z1 VDD pch l=0.06U
+ w=0.21U
M4355 VDD XCTRLA_RSP
+ XCTRLA_XDEC3DXB_2_Z1 VDD pch l=0.06U
+ w=0.75U
M4356 VDD XCTRLA_XDEC3DXB_2_Z1 A_XB_2
+ VDD pch_hvt l=0.06U
+ w=5U
M4357 XCTRLA_XALTCH_0_Z1 XCTRLA_XALTCH_0_AX
+ XCTRLA_XALTCH_0_Z25 VDD pch l=0.08U
+ w=0.42U
M4358 XCTRLA_XDEC3DXB_2_XND0_NET17
+	XCTRLA_AC_8 XCTRLA_XDEC3DXB_2_XND0_NET14 VSS nch
+ l=0.06U
+ w=2U
M4359 XCTRLA_XDEC3DXB_3_XND0_NET17
+	XCTRLA_AT_8 XCTRLA_XDEC3DXB_3_XND0_NET14 VSS nch
+ l=0.06U
+ w=2U
M4360 XCTRLA_XALTCH_0_Z28 XCTRLA_CKC
+ XCTRLA_XALTCH_0_Z1 VDD pch l=0.06U
+ w=0.21U
M4361 XCTRLA_XALTCH_0_Z27 XCTRLA_XALTCH_0_AX
+ XCTRLA_XALTCH_0_Z1 VSS nch l=0.08U
+ w=0.21U
M4362 XCTRLA_XALTCH_0_Z22 BISTC
+ XCTRLA_XALTCH_0_AX VDD pch l=0.08U
+ w=0.42U
M4363 XCTRLA_AC_0 XCTRLA_XALTCH_0_Z1
+ VSS VSS nch l=0.06U
+ w=0.55U
M4364 VDD XCTRLA_XALTCH_0_Z1
+ XCTRLA_AC_0 VDD pch l=0.06U
+ w=1.1U
M4365 VDD XCTRLA_RSP
+ XCTRLA_XDEC3DXB_3_Z1 VDD pch l=0.06U
+ w=0.75U
M4366 VDD XCTRLA_XDEC3DXB_3_Z1 A_XB_3
+ VDD pch_hvt l=0.06U
+ w=5U
M4367 VDD XCTRLA_CKP
+ XCTRLA_XDEC3DXB_2_Z1 VDD pch l=0.06U
+ w=0.21U
M4368 VDD XCTRLA_CKP
+ XCTRLA_XDEC3DXB_3_Z1 VDD pch l=0.06U
+ w=0.21U
M4369 XCTRLA_XDEC3DXB_2_Z1 XCTRLA_CKP
+ XCTRLA_XDEC3DXB_2_XND0_NET17 VSS nch
+ l=0.06U
+ w=2U
M4370 XCTRLA_XDEC3DXB_3_Z1 XCTRLA_CKP
+ XCTRLA_XDEC3DXB_3_XND0_NET17 VSS nch
+ l=0.06U
+ w=2U
M4371 VDD AMA_0 XCTRLA_XALTCH_0_Z22 VDD
+ pch l=0.08U
+ w=0.42U
M4372 XCTRLA_AC_0 XCTRLA_XALTCH_0_Z1
+ VSS VSS nch l=0.06U
+ w=0.55U
M4373 VDD XCTRLA_XALTCH_0_Z1
+ XCTRLA_AC_0 VDD pch l=0.06U
+ w=1.1U
M4374 VDD XCTRLA_RSP XCTRLA_XDEC3DXB_3_Z1
+ VDD pch l=0.06U
+ w=0.75U
M4375 VDD XCTRLA_XDEC3DXB_3_Z1 A_XB_3
+ VDD pch_hvt l=0.06U
+ w=5U
M4376 VDD XCTRLA_AC_0 XCTRLA_XALTCH_0_Z28
+ VDD pch l=0.06U
+ w=0.21U
M4377 VSS XCTRLA_CKC XCTRLA_XALTCH_0_Z27
+ VSS nch l=0.06U
+	 w=0.21U
M4378 VDD XCTRLA_AC_1 XCTRLA_XALTCH_1_Z28
+ VDD pch l=0.06U
+ w=0.21U
M4379 XCTRLA_XALTCH_1_Z22 AMA_1 VDD VDD
+ pch l=0.08U
+ w=0.42U
M4380 XCTRLA_XALTCH_1_Z27 XCTRLA_CKC VSS
+ VSS nch l=0.06U
+ w=0.21U
M4381 XCTRLA_AC_1 XCTRLA_XALTCH_1_Z1
+ VSS VSS nch l=0.06U
+ w=0.55U
M4382 VDD XCTRLA_XALTCH_1_Z1
+ XCTRLA_AC_1 VDD pch l=0.06U
+ w=1.1U
M4383 VDD XCTRLA_RSP XCTRLA_XDEC3DXB_1_Z1
+ VDD pch l=0.06U
+ w=0.75U
M4384 VDD XCTRLA_XDEC3DXB_1_Z1 A_XB_1
+ VDD pch_hvt l=0.06U
+ w=5U
M4385 XCTRLA_XALTCH_1_Z22 BISTC
+ XCTRLA_XALTCH_1_AX VDD pch l=0.08U
+ w=0.42U
M4386 XCTRLA_AC_1 XCTRLA_XALTCH_1_Z1
+ VSS VSS nch l=0.06U
+ w=0.55U
M4387 VDD XCTRLA_XALTCH_1_Z1
+ XCTRLA_AC_1 VDD pch l=0.06U
+ w=1.1U
M4388 VDD XCTRLA_CKP
+ XCTRLA_XDEC3DXB_0_Z1 VDD pch l=0.06U
+ w=0.21U
M4389 XCTRLA_XDEC3DXB_0_XND0_NET17
+ XCTRLA_CKP XCTRLA_XDEC3DXB_0_Z1 VSS nch
+ l=0.06U
+ w=2U
M4390 XCTRLA_XDEC3DXB_1_XND0_NET17
+ XCTRLA_CKP XCTRLA_XDEC3DXB_1_Z1 VSS nch
+ l=0.06U
+ w=2U
M4391 VDD XCTRLA_CKP
+ XCTRLA_XDEC3DXB_1_Z1 VDD pch l=0.06U
+ w=0.21U
M4392 VDD XCTRLA_RSP
+ XCTRLA_XDEC3DXB_1_Z1 VDD pch l=0.06U
+ w=0.75U
M4393 VDD XCTRLA_XDEC3DXB_1_Z1 A_XB_1
+ VDD pch_hvt l=0.06U
+ w=5U
M4394 XCTRLA_XALTCH_1_Z28 XCTRLA_CKC
+ XCTRLA_XALTCH_1_Z1 VDD pch l=0.06U
+ w=0.21U
M4395 XCTRLA_XALTCH_1_Z1 XCTRLA_XALTCH_1_AX
+ XCTRLA_XALTCH_1_Z27 VSS nch l=0.08U
+ w=0.21U
M4396 XCTRLA_XALTCH_1_Z26 XCTRLA_CKP
+ XCTRLA_XALTCH_1_Z1 VSS nch l=0.06U
+ w=0.21U
M4397 XCTRLA_XALTCH_1_Z21 BISTT
+ XCTRLA_XALTCH_1_AX VDD pch l=0.08U
+ w=0.42U
M4398 XCTRLA_XALTCH_1_Z1 XCTRLA_XALTCH_1_AX
+ XCTRLA_XALTCH_1_Z25 VDD pch l=0.08U
+ w=0.42U
M4399 XCTRLA_AT_1 XCTRLA_AC_1 VSS VSS
+ nch l=0.06U
+ w=0.55U
M4400 VDD XCTRLA_AC_1 XCTRLA_AT_1 VDD
+ pch l=0.06U
+ w=1.1U
M4401 VDD XCTRLA_AC_8
+ XCTRLA_XDEC3DXB_0_Z1 VDD pch l=0.06U
+ w=0.21U
M4402 XCTRLA_XDEC3DXB_0_XND0_NET14
+	XCTRLA_AC_8 XCTRLA_XDEC3DXB_0_XND0_NET17 VSS nch
+ l=0.06U
+ w=2U
M4403 XCTRLA_XDEC3DXB_1_XND0_NET14
+	XCTRLA_AT_8 XCTRLA_XDEC3DXB_1_XND0_NET17 VSS nch
+ l=0.06U
+ w=2U
M4404 VDD XCTRLA_AT_8
+ XCTRLA_XDEC3DXB_1_Z1 VDD pch l=0.06U
+ w=0.21U
M4405 VDD XCTRLA_RSP
+ XCTRLA_XDEC3DXB_0_Z1 VDD pch l=0.06U
+ w=0.75U
M4406 VDD XCTRLA_XDEC3DXB_0_Z1 A_XB_0
+ VDD pch_hvt l=0.06U
+ w=5U
M4407 VDD AA_1 XCTRLA_XALTCH_1_Z21 VDD
+ pch l=0.08U
+ w=0.42U
M4408 XCTRLA_AT_1 XCTRLA_AC_1 VSS
+ VSS nch l=0.06U
+ w=0.55U
M4409 VDD XCTRLA_AC_1 XCTRLA_AT_1
+ VDD pch l=0.06U
+ w=1.1U
M4410 VDD XCTRLA_AC_9
+ XCTRLA_XDEC3DXB_0_Z1 VDD pch l=0.06U
+ w=0.21U
M4411 VDD XCTRLA_AC_9
+ XCTRLA_XDEC3DXB_1_Z1 VDD pch l=0.06U
+ w=0.21U
M4412 VDD XCTRLA_RSP XCTRLA_XDEC3DXB_0_Z1
+ VDD pch l=0.06U
+ w=0.75U
M4413 VDD XCTRLA_XDEC3DXB_0_Z1 A_XB_0
+ VDD pch_hvt l=0.06U
+ w=5U
M4414 VDD XCTRLA_CKP XCTRLA_XALTCH_1_Z25
+ VDD pch l=0.06U
+ w=0.42U
M4415 VSS XCTRLA_AC_9
+ XCTRLA_XDEC3DXB_0_XND0_NET14 VSS nch
+ l=0.06U
+ w=2U
M4416 VSS XCTRLA_AC_9
+ XCTRLA_XDEC3DXB_1_XND0_NET14 VSS nch
+ l=0.06U
+ w=2U
M4417 VSS XCTRLA_AC_1 XCTRLA_XALTCH_1_Z26
+ VSS nch l=0.06U
+ w=0.21U
M4418 XCTRLA_XDEC3DY_6_Z4 XCTRLA_AT_2 VSS
+ VSS nch l=0.06U
+ w=2U
M4419 XCTRLA_XDEC3DY_7_Z4 XCTRLA_AT_2 VSS
+ VSS nch l=0.06U
+ w=2U
M4420 XCTRLA_XALTCH_2_Z26 XCTRLA_AC_2 VSS
+ VSS nch l=0.06U
+ w=0.21U
M4421 VDD XCTRLA_CKP XCTRLA_XALTCH_2_Z25
+ VDD pch l=0.06U
+ w=0.42U
M4422 XCTRLA_XALTCH_2_Z21 AA_2 VDD VDD
+ pch l=0.08U
+ w=0.42U
M4423 XCTRLA_AT_2 XCTRLA_AC_2 VSS VSS
+ nch l=0.06U
+ w=0.55U
M4424 VDD XCTRLA_AC_2 XCTRLA_AT_2
+ VDD pch l=0.06U
+ w=1.1U
M4425 VDD XCTRLA_AT_2 XCTRLA_XDEC3DY_6_Z1
+ VDD pch l=0.06U
+ w=0.21U
M4426 VDD XCTRLA_AT_2 XCTRLA_XDEC3DY_7_Z1
+ VDD pch l=0.06U
+ w=0.21U
M4427 VDD XCTRLA_RSP XCTRLA_XDEC3DY_6_Z1
+ VDD pch l=0.06U
+ w=0.75U
M4428 VDD XCTRLA_XDEC3DY_6_Z1 A_Y_6
+ VDD pch_hvt l=0.06U
+ w=5U
M4429 XCTRLA_XDEC3DY_6_Z3 XCTRLA_AT_1
+ XCTRLA_XDEC3DY_6_Z4 VSS nch l=0.06U
+ w=2U
M4430 XCTRLA_XDEC3DY_7_Z3 XCTRLA_AT_1
+ XCTRLA_XDEC3DY_7_Z4 VSS nch l=0.06U
+ w=2U
M4431 XCTRLA_XALTCH_2_Z26 XCTRLA_CKP
+ XCTRLA_XALTCH_2_Z1 VSS nch l=0.06U
+ w=0.21U
M4432 XCTRLA_XALTCH_2_Z21 BISTT
+ XCTRLA_XALTCH_2_AX VDD pch l=0.08U
+ w=0.42U
M4433 XCTRLA_AT_2 XCTRLA_AC_2 VSS
+ VSS nch l=0.06U
+ w=0.55U
M4434 VDD XCTRLA_AC_2 XCTRLA_AT_2 VDD
+ pch l=0.06U
+ w=1.1U
M4435 VDD XCTRLA_AT_1 XCTRLA_XDEC3DY_6_Z1
+ VDD pch l=0.06U
+ w=0.21U
M4436 VDD XCTRLA_AT_1 XCTRLA_XDEC3DY_7_Z1
+ VDD pch l=0.06U
+ w=0.21U
M4437 VDD XCTRLA_RSP XCTRLA_XDEC3DY_6_Z1
+ VDD pch l=0.06U
+ w=0.75U
M4438 VDD XCTRLA_XDEC3DY_6_Z1 A_Y_6
+ VDD pch_hvt l=0.06U
+ w=5U
M4439 XCTRLA_XALTCH_2_Z1 XCTRLA_XALTCH_2_AX
+ XCTRLA_XALTCH_2_Z25 VDD pch l=0.08U
+ w=0.42U
M4440 XCTRLA_XDEC3DY_6_Z3 XCTRLA_AC_0
+ XCTRLA_XDEC3DY_6_Z2 VSS nch l=0.06U
+ w=2U
M4441 XCTRLA_XDEC3DY_7_Z3 XCTRLA_AT_0
+ XCTRLA_XDEC3DY_7_Z2 VSS nch l=0.06U
+ w=2U
M4442 XCTRLA_XALTCH_2_Z28 XCTRLA_CKC
+ XCTRLA_XALTCH_2_Z1 VDD pch l=0.06U
+ w=0.21U
M4443 XCTRLA_XALTCH_2_Z27 XCTRLA_XALTCH_2_AX
+ XCTRLA_XALTCH_2_Z1 VSS nch l=0.08U
+ w=0.21U
M4444 XCTRLA_XALTCH_2_Z22 BISTC
+ XCTRLA_XALTCH_2_AX VDD pch l=0.08U
+ w=0.42U
M4445 XCTRLA_AC_2 XCTRLA_XALTCH_2_Z1
+ VSS VSS nch l=0.06U
+ w=0.55U
M4446 VDD XCTRLA_XALTCH_2_Z1
+ XCTRLA_AC_2 VDD pch l=0.06U
+ w=1.1U
M4447 VDD XCTRLA_AC_0 XCTRLA_XDEC3DY_6_Z1
+ VDD pch l=0.06U
+ w=0.21U
M4448 VDD XCTRLA_AT_0 XCTRLA_XDEC3DY_7_Z1
+ VDD pch l=0.06U
+ w=0.21U
M4449 VDD XCTRLA_RSP XCTRLA_XDEC3DY_7_Z1
+ VDD pch l=0.06U
+ w=0.75U
M4450 VDD XCTRLA_XDEC3DY_7_Z1 A_Y_7
+ VDD pch_hvt l=0.06U
+ w=5U
M4451 XCTRLA_XDEC3DY_6_Z1 XCTRLA_CKP
+ XCTRLA_XDEC3DY_6_Z2 VSS nch l=0.06U
+ w=2U
M4452 XCTRLA_XDEC3DY_7_Z1 XCTRLA_CKP
+ XCTRLA_XDEC3DY_7_Z2 VSS nch l=0.06U
+ w=2U
M4453 VDD AMA_2 XCTRLA_XALTCH_2_Z22 VDD
+ pch l=0.08U
+ w=0.42U
M4454 XCTRLA_AC_2 XCTRLA_XALTCH_2_Z1
+ VSS VSS nch l=0.06U
+ w=0.55U
M4455 VDD XCTRLA_XALTCH_2_Z1
+ XCTRLA_AC_2 VDD pch l=0.06U
+ w=1.1U
M4456 VDD XCTRLA_CKP XCTRLA_XDEC3DY_6_Z1
+ VDD pch l=0.06U
+ w=0.21U
M4457 VDD XCTRLA_CKP XCTRLA_XDEC3DY_7_Z1
+ VDD pch l=0.06U
+ w=0.21U
M4458 VDD XCTRLA_RSP XCTRLA_XDEC3DY_7_Z1
+ VDD pch l=0.06U
+ w=0.75U
M4459 VDD XCTRLA_XDEC3DY_7_Z1 A_Y_7
+ VDD pch_hvt l=0.06U
+ w=5U
M4460 VDD XCTRLA_AC_2 XCTRLA_XALTCH_2_Z28
+ VDD pch l=0.06U
+ w=0.21U
M4461 VSS XCTRLA_CKC XCTRLA_XALTCH_2_Z27
+ VSS nch l=0.06U
+ w=0.21U
M4462 VDD XCTRLA_AC_3 XCTRLA_XALTCH_3_Z28
+ VDD pch l=0.06U
+ w=0.21U
M4463 VDD AMA_3 XCTRLA_XALTCH_3_Z22 VDD
+ pch l=0.08U
+ w=0.42U
M4464 VSS XCTRLA_CKC XCTRLA_XALTCH_3_Z27
+ VSS nch l=0.06U
+ w=0.21U
M4465 XCTRLA_AC_3 XCTRLA_XALTCH_3_Z1
+ VSS VSS nch l=0.06U
+ w=0.55U
M4466 VDD XCTRLA_XALTCH_3_Z1
+ XCTRLA_AC_3 VDD pch l=0.06U
+ w=1.1U
M4467 VDD XCTRLA_CKP XCTRLA_XDEC3DY_4_Z1
+ VDD pch l=0.06U
+ w=0.21U
M4468 VDD XCTRLA_CKP XCTRLA_XDEC3DY_5_Z1
+ VDD pch l=0.06U
+ w=0.21U
M4469 VDD XCTRLA_RSP XCTRLA_XDEC3DY_5_Z1
+ VDD pch l=0.06U
+ w=0.75U
M4470 VDD XCTRLA_XDEC3DY_5_Z1 A_Y_5
+ VDD pch_hvt l=0.06U
+ w=5U
M4471 XCTRLA_XDEC3DY_4_Z2 XCTRLA_CKP
+ XCTRLA_XDEC3DY_4_Z1 VSS nch l=0.06U
+ w=2U
M4472 XCTRLA_XDEC3DY_5_Z2 XCTRLA_CKP
+ XCTRLA_XDEC3DY_5_Z1 VSS nch l=0.06U
+ w=2U
M4473 XCTRLA_XALTCH_3_Z22 BISTC
+ XCTRLA_XALTCH_3_AX VDD pch l=0.08U
+ w=0.42U
M4474 XCTRLA_AC_3 XCTRLA_XALTCH_3_Z1
+ VSS VSS nch l=0.06U
+ w=0.55U
M4475 VDD XCTRLA_XALTCH_3_Z1
+ XCTRLA_AC_3 VDD pch l=0.06U
+ w=1.1U
M4476 VDD XCTRLA_AC_0 XCTRLA_XDEC3DY_4_Z1
+ VDD pch l=0.06U
+ w=0.21U
M4477 VDD XCTRLA_AT_0 XCTRLA_XDEC3DY_5_Z1
+ VDD pch l=0.06U
+ w=0.21U
M4478 VDD XCTRLA_RSP XCTRLA_XDEC3DY_5_Z1
+ VDD pch l=0.06U
+ w=0.75U
M4479 VDD XCTRLA_XDEC3DY_5_Z1 A_Y_5
+ VDD pch_hvt l=0.06U
+ w=5U
M4480 XCTRLA_XALTCH_3_Z28 XCTRLA_CKC
+ XCTRLA_XALTCH_3_Z1 VDD pch l=0.06U
+ w=0.21U
M4481 XCTRLA_XALTCH_3_Z1 XCTRLA_XALTCH_3_AX
+ XCTRLA_XALTCH_3_Z27 VSS nch l=0.08U
+ w=0.21U
M4482 XCTRLA_XDEC3DY_4_Z3 XCTRLA_AC_0
+ XCTRLA_XDEC3DY_4_Z2 VSS nch l=0.06U
+ w=2U
M4483 XCTRLA_XDEC3DY_5_Z3 XCTRLA_AT_0
+ XCTRLA_XDEC3DY_5_Z2 VSS nch l=0.06U
+ w=2U
M4484 XCTRLA_XALTCH_3_Z26 XCTRLA_CKP
+ XCTRLA_XALTCH_3_Z1 VSS nch l=0.06U
+ w=0.21U
M4485 XCTRLA_XALTCH_3_Z21 BISTT
+ XCTRLA_XALTCH_3_AX VDD pch l=0.08U
+ w=0.42U
M4486 XCTRLA_XALTCH_3_Z25 XCTRLA_XALTCH_3_AX
+ XCTRLA_XALTCH_3_Z1 VDD pch l=0.08U
+ w=0.42U
M4487 XCTRLA_XDEC3DY_4_Z3 XCTRLA_AC_1
+ XCTRLA_XDEC3DY_4_Z4 VSS nch l=0.06U
+ w=2U
M4488 XCTRLA_XDEC3DY_5_Z3 XCTRLA_AC_1
+ XCTRLA_XDEC3DY_5_Z4 VSS nch l=0.06U
+ w=2U
M4489 XCTRLA_AT_3 XCTRLA_AC_3 VSS VSS
+ nch l=0.06U
+ w=0.55U
M4490 VDD XCTRLA_AC_3 XCTRLA_AT_3 VDD
+ pch l=0.06U
+ w=1.1U
M4491 VDD XCTRLA_AC_1 XCTRLA_XDEC3DY_4_Z1
+ VDD pch l=0.06U
+ w=0.21U
M4492 VDD XCTRLA_AC_1 XCTRLA_XDEC3DY_5_Z1
+ VDD pch l=0.06U
+ w=0.21U
M4493 VDD XCTRLA_RSP XCTRLA_XDEC3DY_4_Z1
+ VDD pch l=0.06U
+ w=0.75U
M4494 VDD XCTRLA_XDEC3DY_4_Z1 A_Y_4
+ VDD pch_hvt l=0.06U
+ w=5U
M4495 VDD AA_3 XCTRLA_XALTCH_3_Z21 VDD
+ pch l=0.08U
+ w=0.42U
M4496 XCTRLA_AT_3 XCTRLA_AC_3 VSS
+ VSS nch l=0.06U
+ w=0.55U
M4497 VDD XCTRLA_AC_3 XCTRLA_AT_3
+ VDD pch l=0.06U
+ w=1.1U
M4498 VDD XCTRLA_AT_2 XCTRLA_XDEC3DY_4_Z1
+ VDD pch l=0.06U
+ w=0.21U
M4499 VDD XCTRLA_AT_2 XCTRLA_XDEC3DY_5_Z1
+ VDD pch l=0.06U
+ w=0.21U
M4500 VDD XCTRLA_RSP XCTRLA_XDEC3DY_4_Z1
+ VDD pch l=0.06U
+ w=0.75U
M4501 VDD XCTRLA_XDEC3DY_4_Z1 A_Y_4
+ VDD pch_hvt l=0.06U
+ w=5U
M4502 VDD XCTRLA_CKP XCTRLA_XALTCH_3_Z25
+ VDD pch l=0.06U
+	 w=0.42U
M4503 XCTRLA_XDEC3DY_4_Z4 XCTRLA_AT_2 VSS
+ VSS nch l=0.06U
+ w=2U
M4504 XCTRLA_XDEC3DY_5_Z4 XCTRLA_AT_2 VSS
+ VSS nch l=0.06U
+ w=2U
M4505 VSS XCTRLA_AC_3 XCTRLA_XALTCH_3_Z26
+ VSS nch l=0.06U
+ w=0.21U
M4506 XCTRLA_XDEC3DY_2_Z4 XCTRLA_AC_2 VSS
+ VSS nch l=0.06U
+ w=2U
M4507 XCTRLA_XDEC3DY_3_Z4 XCTRLA_AC_2 VSS
+ VSS nch l=0.06U
+ w=2U
M4508 XCTRLA_XALTCH_4_Z26 XCTRLA_AC_4 VSS
+ VSS nch l=0.06U
+ w=0.21U
M4509 VDD XCTRLA_CKP XCTRLA_XALTCH_4_Z25
+ VDD pch l=0.06U
+ w=0.42U
M4510 VDD AA_4 XCTRLA_XALTCH_4_Z21 VDD
+ pch l=0.08U
+ w=0.42U
M4511 XCTRLA_AT_4 XCTRLA_AC_4 VSS VSS
+ nch l=0.06U
+ w=0.55U
M4512 VDD XCTRLA_AC_4 XCTRLA_AT_4 VDD
+ pch l=0.06U
+ w=1.1U
M4513 VDD XCTRLA_AC_2 XCTRLA_XDEC3DY_2_Z1
+ VDD pch l=0.06U
+ w=0.21U
M4514 VDD XCTRLA_AC_2 XCTRLA_XDEC3DY_3_Z1
+ VDD pch l=0.06U
+ w=0.21U
M4515 VDD XCTRLA_RSP XCTRLA_XDEC3DY_2_Z1
+ VDD pch l=0.06U
+ w=0.75U
M4516 VDD XCTRLA_XDEC3DY_2_Z1 A_Y_2
+ VDD pch_hvt l=0.06U
+ w=5U
M4517 XCTRLA_XDEC3DY_2_Z3 XCTRLA_AT_1
+ XCTRLA_XDEC3DY_2_Z4 VSS nch l=0.06U
+ w=2U
M4518 XCTRLA_XDEC3DY_3_Z3 XCTRLA_AT_1
+ XCTRLA_XDEC3DY_3_Z4 VSS nch l=0.06U
+ w=2U
M4519 XCTRLA_XALTCH_4_Z26 XCTRLA_CKP
+ XCTRLA_XALTCH_4_Z1 VSS nch l=0.06U
+ w=0.21U
M4520 XCTRLA_XALTCH_4_Z21 BISTT
+ XCTRLA_XALTCH_4_AX VDD pch l=0.08U
+ w=0.42U
M4521 XCTRLA_AT_4 XCTRLA_AC_4 VSS
+ VSS nch l=0.06U
+ w=0.55U
M4522 VDD XCTRLA_AC_4 XCTRLA_AT_4
+ VDD pch l=0.06U
+ w=1.1U
M4523 VDD XCTRLA_AT_1 XCTRLA_XDEC3DY_2_Z1
+ VDD pch l=0.06U
+	 w=0.21U
M4524 VDD XCTRLA_AT_1 XCTRLA_XDEC3DY_3_Z1
+ VDD pch l=0.06U
+ w=0.21U
M4525 VDD XCTRLA_RSP XCTRLA_XDEC3DY_2_Z1
+ VDD pch l=0.06U
+ w=0.75U
M4526 VDD XCTRLA_XDEC3DY_2_Z1 A_Y_2
+ VDD pch_hvt l=0.06U
+ w=5U
M4527 XCTRLA_XALTCH_4_Z1 XCTRLA_XALTCH_4_AX
+ XCTRLA_XALTCH_4_Z25 VDD pch l=0.08U
+ w=0.42U
M4528 XCTRLA_XDEC3DY_2_Z2 XCTRLA_AC_0
+ XCTRLA_XDEC3DY_2_Z3 VSS nch l=0.06U
+ w=2U
M4529 XCTRLA_XDEC3DY_3_Z2 XCTRLA_AT_0
+ XCTRLA_XDEC3DY_3_Z3 VSS nch l=0.06U
+ w=2U
M4530 XCTRLA_XALTCH_4_Z1 XCTRLA_CKC
+ XCTRLA_XALTCH_4_Z28 VDD pch l=0.06U
+ w=0.21U
M4531 XCTRLA_XALTCH_4_Z1 XCTRLA_XALTCH_4_AX
+ XCTRLA_XALTCH_4_Z27 VSS nch l=0.08U
+ w=0.21U
M4532 XCTRLA_XALTCH_4_AX BISTC
+ XCTRLA_XALTCH_4_Z22 VDD pch l=0.08U
+ w=0.42U
M4533 XCTRLA_AC_4 XCTRLA_XALTCH_4_Z1
+ VSS VSS nch l=0.06U
+ w=0.55U
M4534 VDD XCTRLA_XALTCH_4_Z1
+ XCTRLA_AC_4 VDD pch l=0.06U
+ w=1.1U
M4535 VDD XCTRLA_AC_0 XCTRLA_XDEC3DY_2_Z1
+ VDD pch l=0.06U
+ w=0.21U
M4536 VDD XCTRLA_AT_0 XCTRLA_XDEC3DY_3_Z1
+ VDD pch l=0.06U
+ w=0.21U
M4537 VDD XCTRLA_RSP XCTRLA_XDEC3DY_3_Z1
+ VDD pch l=0.06U
+ w=0.75U
M4538 VDD XCTRLA_XDEC3DY_3_Z1 A_Y_3
+ VDD pch_hvt l=0.06U
+ w=5U
M4539 XCTRLA_XDEC3DY_2_Z2 XCTRLA_CKP
+ XCTRLA_XDEC3DY_2_Z1 VSS nch l=0.06U
+ w=2U
M4540 XCTRLA_XDEC3DY_3_Z2 XCTRLA_CKP
+ XCTRLA_XDEC3DY_3_Z1 VSS nch l=0.06U
+ w=2U
M4541 XCTRLA_XALTCH_4_Z22 AMA_4 VDD VDD
+ pch l=0.08U
+ w=0.42U
M4542 XCTRLA_AC_4 XCTRLA_XALTCH_4_Z1
+ VSS VSS nch l=0.06U
+ w=0.55U
M4543 VDD XCTRLA_XALTCH_4_Z1
+ XCTRLA_AC_4 VDD pch l=0.06U
+ w=1.1U
M4544 VDD XCTRLA_CKP XCTRLA_XDEC3DY_2_Z1
+ VDD pch l=0.06U
+ w=0.21U
M4545 VDD XCTRLA_CKP XCTRLA_XDEC3DY_3_Z1
+ VDD pch l=0.06U
+ w=0.21U
M4546 VDD XCTRLA_RSP XCTRLA_XDEC3DY_3_Z1
+ VDD pch l=0.06U
+ w=0.75U
M4547 VDD XCTRLA_XDEC3DY_3_Z1 A_Y_3
+ VDD pch_hvt l=0.06U
+ w=5U
M4548 VDD XCTRLA_AC_4 XCTRLA_XALTCH_4_Z28
+ VDD pch l=0.06U
+ w=0.21U
M4549 XCTRLA_XALTCH_4_Z27 XCTRLA_CKC VSS
+ VSS nch l=0.06U
+ w=0.21U
M4550 VDD XCTRLA_RWC XCTRLA_XALTCH0_Z28
+ VDD pch l=0.06U
+ w=0.21U
M4551 VDD WEBMA XCTRLA_XALTCH0_Z22 VDD
+ pch l=0.08U
+ w=0.42U
M4552 XCTRLA_XALTCH0_Z27 XCTRLA_CKC VSS
+ VSS nch l=0.06U
+ w=0.21U
M4553 XCTRLA_RWC XCTRLA_XALTCH0_Z1
+ VSS VSS nch l=0.06U
+ w=0.55U
M4554 VDD XCTRLA_XALTCH0_Z1
+ XCTRLA_RWC VDD pch l=0.06U
+ w=1.1U
M4555 VDD XCTRLA_CKP XCTRLA_XDEC3DY_0_Z1
+ VDD pch l=0.06U
+ w=0.21U
M4556 VDD XCTRLA_CKP XCTRLA_XDEC3DY_1_Z1
+ VDD pch l=0.06U
+	 w=0.21U
M4557 VDD XCTRLA_RSP XCTRLA_XDEC3DY_1_Z1
+ VDD pch l=0.06U
+ w=0.75U
M4558 VDD XCTRLA_XDEC3DY_1_Z1 A_Y_1
+ VDD pch_hvt l=0.06U
+ w=5U
M4559 XCTRLA_XDEC3DY_0_Z2 XCTRLA_CKP
+ XCTRLA_XDEC3DY_0_Z1 VSS nch l=0.06U
+ w=2U
M4560 XCTRLA_XDEC3DY_1_Z2 XCTRLA_CKP
+ XCTRLA_XDEC3DY_1_Z1 VSS nch l=0.06U
+ w=2U
M4561 XCTRLA_XALTCH0_Z22 BISTC
+ XCTRLA_XALTCH0_AX VDD pch l=0.08U
+ w=0.42U
M4562 XCTRLA_RWC XCTRLA_XALTCH0_Z1
+ VSS VSS nch l=0.06U
+ w=0.55U
M4563 VDD XCTRLA_XALTCH0_Z1
+ XCTRLA_RWC VDD pch l=0.06U
+ w=1.1U
M4564 VDD XCTRLA_AC_0 XCTRLA_XDEC3DY_0_Z1
+ VDD pch l=0.06U
+ w=0.21U
M4565 VDD XCTRLA_AT_0 XCTRLA_XDEC3DY_1_Z1
+ VDD pch l=0.06U
+	 w=0.21U
M4566 VDD XCTRLA_RSP XCTRLA_XDEC3DY_1_Z1
+ VDD pch l=0.06U
+ w=0.75U
M4567 VDD XCTRLA_XDEC3DY_1_Z1 A_Y_1
+ VDD pch_hvt l=0.06U
+ w=5U
M4568 XCTRLA_XALTCH0_Z28 XCTRLA_CKC
+ XCTRLA_XALTCH0_Z1 VDD pch l=0.06U
+ w=0.21U
M4569 XCTRLA_XALTCH0_Z1 XCTRLA_XALTCH0_AX
+ XCTRLA_XALTCH0_Z27 VSS nch l=0.08U
+ w=0.21U
M4570 XCTRLA_XDEC3DY_0_Z3 XCTRLA_AC_0
+ XCTRLA_XDEC3DY_0_Z2 VSS nch l=0.06U
+ w=2U
M4571 XCTRLA_XDEC3DY_1_Z3 XCTRLA_AT_0
+ XCTRLA_XDEC3DY_1_Z2 VSS nch l=0.06U
+ w=2U
M4572 XCTRLA_XALTCH0_Z26 XCTRLA_CKP
+ XCTRLA_XALTCH0_Z1 VSS nch l=0.06U
+ w=0.21U
M4573 XCTRLA_XALTCH0_Z21 BISTT
+ XCTRLA_XALTCH0_AX VDD pch l=0.08U
+ w=0.42U
M4574 XCTRLA_XALTCH0_Z1 XCTRLA_XALTCH0_AX
+ XCTRLA_XALTCH0_Z25 VDD pch l=0.08U
+ w=0.42U
M4575 XCTRLA_XDEC3DY_0_Z4 XCTRLA_AC_1
+ XCTRLA_XDEC3DY_0_Z3 VSS nch l=0.06U
+ w=2U
M4576 XCTRLA_XDEC3DY_1_Z4 XCTRLA_AC_1
+ XCTRLA_XDEC3DY_1_Z3 VSS nch l=0.06U
+ w=2U
M4577 XCTRLA_RWT XCTRLA_RWC VSS VSS
+ nch l=0.06U
+ w=0.55U
M4578 VDD XCTRLA_RWC XCTRLA_RWT VDD
+ pch l=0.06U
+ w=1.1U
M4579 VDD XCTRLA_AC_1 XCTRLA_XDEC3DY_0_Z1
+ VDD pch l=0.06U
+ w=0.21U
M4580 VDD XCTRLA_AC_1 XCTRLA_XDEC3DY_1_Z1
+ VDD pch l=0.06U
+	 w=0.21U
M4581 VDD XCTRLA_RSP XCTRLA_XDEC3DY_0_Z1
+ VDD pch l=0.06U
+ w=0.75U
M4582 VDD XCTRLA_XDEC3DY_0_Z1 A_Y_0
+ VDD pch_hvt l=0.06U
+ w=5U
M4583 VDD XCTRLA_CKP XCTRLA_XALTCH0_Z25
+ VDD pch l=0.06U
+	 w=0.42U
M4584 VSS XCTRLA_RWC XCTRLA_XALTCH0_Z26
+ VSS nch l=0.06U
+ w=0.21U
M4585 XCTRLA_RWT XCTRLA_RWC VSS
+ VSS nch l=0.06U
+ w=0.55U
M4586 VDD XCTRLA_AC_2 XCTRLA_XDEC3DY_0_Z1
+ VDD pch l=0.06U
+ w=0.21U
M4587 VDD XCTRLA_AC_2 XCTRLA_XDEC3DY_1_Z1
+ VDD pch l=0.06U
+ w=0.21U
M4588 VDD XCTRLA_RSP XCTRLA_XDEC3DY_0_Z1
+ VDD pch l=0.06U
+ w=0.75U
M4589 VDD XCTRLA_XDEC3DY_0_Z1 A_Y_0
+ VDD pch_hvt l=0.06U
+ w=5U
M4590 XCTRLA_XALTCH0_Z21 WEBA VDD VDD
+ pch l=0.08U
+ w=0.42U
M4591 VSS XCTRLA_AC_2 XCTRLA_XDEC3DY_0_Z4
+ VSS nch l=0.06U
+ w=2U
M4592 VSS XCTRLA_AC_2 XCTRLA_XDEC3DY_1_Z4
+ VSS nch l=0.06U
+ w=2U
M4593 VDD XCTRLA_RWC XCTRLA_RWT
+ VDD pch l=0.06U
+ w=1.1U
M4594 XCTRLA_XGCDEC0_2_Z4 XCTRLA_RWT VSS
+ VSS nch l=0.06U
+ w=2U
M4595 XCTRLA_XGCDEC0_3_Z4 XCTRLA_RWT VSS
+ VSS nch l=0.06U
+ w=2U
M4596 VDD XCTRLA_RWT XCTRLA_XGCDEC0_2_Z1
+ VDD pch l=0.06U
+ w=0.21U
M4597 VDD XCTRLA_RWT XCTRLA_XGCDEC0_3_Z1
+ VDD pch l=0.06U
+ w=0.21U
M4598 VDD XCTRLA_RSP XCTRLA_XGCDEC0_2_Z1
+ VDD pch l=0.06U
+ w=0.75U
M4599 VDD XCTRLA_XGCDEC0_2_Z1
+ A_GCDEC_2 VDD pch_hvt l=0.06U
+ w=5U
M4600 VDD XCTRLA_CKMENB XCTRLA_XCKG_Z7 VDD
+ pch l=0.06U
+ w=0.41U
M4601 XCTRLA_XGCDEC0_2_Z3 XCTRLA_AT_4
+ XCTRLA_XGCDEC0_2_Z4 VSS nch l=0.06U
+ w=2U
M4602 XCTRLA_XGCDEC0_3_Z3 XCTRLA_AT_4
+ XCTRLA_XGCDEC0_3_Z4 VSS nch l=0.06U
+ w=2U
M4603 VDD XCTRLA_AT_4 XCTRLA_XGCDEC0_2_Z1
+ VDD pch l=0.06U
+ w=0.21U
M4604 VDD XCTRLA_AT_4 XCTRLA_XGCDEC0_3_Z1
+ VDD pch l=0.06U
+ w=0.21U
M4605 VDD XCTRLA_RSP XCTRLA_XGCDEC0_2_Z1
+ VDD pch l=0.06U
+ w=0.75U
M4606 VDD XCTRLA_XGCDEC0_2_Z1
+ A_GCDEC_2 VDD pch_hvt l=0.06U
+ w=5U
M4607 XCTRLA_XGCDEC0_2_Z3 XCTRLA_AC_3
+ XCTRLA_XGCDEC0_2_Z2 VSS nch l=0.06U
+ w=2U
M4608 XCTRLA_XGCDEC0_3_Z3 XCTRLA_AT_3
+ XCTRLA_XGCDEC0_3_Z2 VSS nch l=0.06U
+ w=2U
M4609 XCTRLA_XCKG_Z7 XCTRLA_CKENB XCTRLA_CKPC
+ VDD pch l=0.06U
+ w=0.41U
M4610 VDD XCTRLA_AC_3 XCTRLA_XGCDEC0_2_Z1
+ VDD pch l=0.06U
+ w=0.21U
M4611 VDD XCTRLA_AT_3 XCTRLA_XGCDEC0_3_Z1
+ VDD pch l=0.06U
+ w=0.21U
M4612 VDD XCTRLA_RSP XCTRLA_XGCDEC0_3_Z1
+ VDD pch l=0.06U
+ w=0.75U
M4613 VDD XCTRLA_XGCDEC0_3_Z1
+ A_GCDEC_3 VDD pch_hvt l=0.06U
+ w=5U
M4614 XCTRLA_CKPC XCTRLA_CKMENB XCTRLA_XCKG_Z6
+ VDD pch l=0.06U
+ w=0.41U
M4615 XCTRLA_XGCDEC0_2_Z2 XCTRLA_CKP
+ XCTRLA_XGCDEC0_2_Z1 VSS nch l=0.06U
+ w=2U
M4616 XCTRLA_XGCDEC0_3_Z2 XCTRLA_CKP
+ XCTRLA_XGCDEC0_3_Z1 VSS nch l=0.06U
+ w=2U
M4617 VDD XCTRLA_CKP XCTRLA_XGCDEC0_2_Z1
+ VDD pch l=0.06U
+ w=0.21U
M4618 VDD XCTRLA_CKP XCTRLA_XGCDEC0_3_Z1
+ VDD pch l=0.06U
+ w=0.21U
M4619 VDD XCTRLA_RSP XCTRLA_XGCDEC0_3_Z1
+ VDD pch l=0.06U
+ w=0.75U
M4620 VDD XCTRLA_XGCDEC0_3_Z1
+ A_GCDEC_3 VDD pch_hvt l=0.06U
+ w=5U
M4621 VDD XCTRLA_CKENB XCTRLA_XCKG_Z6 VDD
+ pch l=0.06U
+	 w=0.41U
M4622 VDD XCTRLA_CKP XCTRLA_XGCDEC0_0_Z1
+ VDD pch l=0.06U
+ w=0.21U
M4623 VDD XCTRLA_CKP XCTRLA_XGCDEC0_1_Z1
+ VDD pch l=0.06U
+ w=0.21U
M4624 VDD XCTRLA_RSP XCTRLA_XGCDEC0_1_Z1
+ VDD pch l=0.06U
+ w=0.75U
M4625 VDD XCTRLA_XGCDEC0_1_Z1
+ A_GCDEC_1 VDD pch_hvt l=0.06U
+ w=5U
M4626 XCTRLA_XCKG_Z11 BISTC VDD VDD pch
+ l=0.06U
+	 w=0.41U
M4627 XCTRLA_XGCDEC0_0_Z2 XCTRLA_CKP
+ XCTRLA_XGCDEC0_0_Z1 VSS nch l=0.06U
+ w=2U
M4628 XCTRLA_XGCDEC0_1_Z2 XCTRLA_CKP
+ XCTRLA_XGCDEC0_1_Z1 VSS nch l=0.06U
+ w=2U
M4629 VDD XCTRLA_AC_3 XCTRLA_XGCDEC0_0_Z1
+ VDD pch l=0.06U
+ w=0.21U
M4630 VDD XCTRLA_AT_3 XCTRLA_XGCDEC0_1_Z1
+ VDD pch l=0.06U
+ w=0.21U
M4631 VDD XCTRLA_RSP XCTRLA_XGCDEC0_1_Z1
+ VDD pch l=0.06U
+ w=0.75U
M4632 VDD XCTRLA_XGCDEC0_1_Z1
+ A_GCDEC_1 VDD pch_hvt l=0.06U
+ w=5U
M4633 XCTRLA_XCKG_Z11 CLKM XCTRLA_XCKG_Z12 VDD
+ pch l=0.06U
+	 w=0.41U
M4634 XCTRLA_XGCDEC0_0_Z3 XCTRLA_AC_3
+ XCTRLA_XGCDEC0_0_Z2 VSS nch l=0.06U
+ w=2U
M4635 XCTRLA_XGCDEC0_1_Z3 XCTRLA_AT_3
+ XCTRLA_XGCDEC0_1_Z2 VSS nch l=0.06U
+ w=2U
M4636 XCTRLA_XCKG_Z12 CLKA XCTRLA_XCKG_Z10 VDD
+ pch l=0.06U
+ w=0.41U
M4637 XCTRLA_XGCDEC0_0_Z3 XCTRLA_AC_4
+ XCTRLA_XGCDEC0_0_Z4 VSS nch l=0.06U
+ w=2U
M4638 XCTRLA_XGCDEC0_1_Z3 XCTRLA_AC_4
+ XCTRLA_XGCDEC0_1_Z4 VSS nch l=0.06U
+ w=2U
M4639 VDD XCTRLA_AC_4 XCTRLA_XGCDEC0_0_Z1
+ VDD pch l=0.06U
+	 w=0.21U
M4640 VDD XCTRLA_AC_4 XCTRLA_XGCDEC0_1_Z1
+ VDD pch l=0.06U
+ w=0.21U
M4641 VDD XCTRLA_RSP XCTRLA_XGCDEC0_0_Z1
+ VDD pch l=0.06U
+ w=0.75U
M4642 VDD XCTRLA_XGCDEC0_0_Z1
+ A_GCDEC_0 VDD pch_hvt l=0.06U
+ w=5U
M4643 VDD BISTT XCTRLA_XCKG_Z10 VDD pch
+ l=0.06U
+	 w=0.41U
M4644 VDD XCTRLA_RWT XCTRLA_XGCDEC0_0_Z1
+ VDD pch l=0.06U
+ w=0.21U
M4645 VDD XCTRLA_RWT XCTRLA_XGCDEC0_1_Z1
+ VDD pch l=0.06U
+ w=0.21U
M4646 VDD XCTRLA_RSP XCTRLA_XGCDEC0_0_Z1
+ VDD pch l=0.06U
+ w=0.75U
M4647 VDD XCTRLA_XGCDEC0_0_Z1
+ A_GCDEC_0 VDD pch_hvt l=0.06U
+ w=5U
M4648 VSS XCTRLA_RWT XCTRLA_XGCDEC0_0_Z4
+ VSS nch l=0.06U
+ w=2U
M4649 VSS XCTRLA_RWT XCTRLA_XGCDEC0_1_Z4
+ VSS nch l=0.06U
+ w=2U
M4650 VDD XCTRLA_XCKG_Z12 XCTRLA_XCKG_Z13 VDD
+ pch l=0.06U
+	 w=0.41U
M4651 XCTRLA_XWENB0_2_Z4 XCTRLA_RWC VSS
+ VSS nch l=0.06U
+ w=2U
M4652 XCTRLA_XWENB0_3_Z4 XCTRLA_RWC VSS
+ VSS nch l=0.06U
+ w=2U
M4653 VDD XCTRLA_RWC XCTRLA_XWENB0_2_Z1
+ VDD pch l=0.06U
+ w=0.21U
M4654 VDD XCTRLA_RWC XCTRLA_XWENB0_3_Z1
+ VDD pch l=0.06U
+ w=0.21U
M4655 VDD XCTRLA_RSP XCTRLA_XWENB0_2_Z1
+ VDD pch l=0.06U
+ w=0.75U
M4656 VDD XCTRLA_XWENB0_2_Z1
+ A_WENB_2 VDD pch_hvt l=0.06U
+ w=5U
M4657 XCTRLA_XWENB0_2_Z3 XCTRLA_AT_4
+ XCTRLA_XWENB0_2_Z4 VSS nch l=0.06U
+ w=2U
M4658 XCTRLA_XWENB0_3_Z3 XCTRLA_AT_4
+ XCTRLA_XWENB0_3_Z4 VSS nch l=0.06U
+ w=2U
M4659 VDD XCTRLA_AT_4 XCTRLA_XWENB0_2_Z1
+ VDD pch l=0.06U
+ w=0.21U
M4660 VDD XCTRLA_AT_4 XCTRLA_XWENB0_3_Z1
+ VDD pch l=0.06U
+	 w=0.21U
M4661 VDD XCTRLA_RSP XCTRLA_XWENB0_2_Z1
+ VDD pch l=0.06U
+ w=0.75U
M4662 VDD XCTRLA_XWENB0_2_Z1
+ A_WENB_2 VDD pch_hvt l=0.06U
+ w=5U
M4663 XCTRLA_XWENB0_2_Z3 XCTRLA_AC_3
+ XCTRLA_XWENB0_2_Z2 VSS nch l=0.06U
+ w=2U
M4664 XCTRLA_XWENB0_3_Z3 XCTRLA_AT_3
+ XCTRLA_XWENB0_3_Z2 VSS nch l=0.06U
+ w=2U
M4665 VDD XCTRLA_AC_3 XCTRLA_XWENB0_2_Z1
+ VDD pch l=0.06U
+ w=0.21U
M4666 VDD XCTRLA_AT_3 XCTRLA_XWENB0_3_Z1
+ VDD pch l=0.06U
+ w=0.21U
M4667 VDD XCTRLA_RSP XCTRLA_XWENB0_3_Z1
+ VDD pch l=0.06U
+ w=0.75U
M4668 VDD XCTRLA_XWENB0_3_Z1
+ A_WENB_3 VDD pch_hvt l=0.06U
+ w=5U
M4669 XCTRLA_XWENB0_2_Z1 XCTRLA_CKP
+ XCTRLA_XWENB0_2_Z2 VSS nch l=0.06U
+ w=2U
M4670 XCTRLA_XWENB0_3_Z1 XCTRLA_CKP
+ XCTRLA_XWENB0_3_Z2 VSS nch l=0.06U
+ w=2U
M4671 VDD XCTRLA_CKP XCTRLA_XWENB0_2_Z1
+ VDD pch l=0.06U
+ w=0.21U
M4672 VDD XCTRLA_CKP XCTRLA_XWENB0_3_Z1
+ VDD pch l=0.06U
+ w=0.21U
M4673 VDD XCTRLA_RSP XCTRLA_XWENB0_3_Z1
+ VDD pch l=0.06U
+ w=0.75U
M4674 VDD XCTRLA_XWENB0_3_Z1
+ A_WENB_3 VDD pch_hvt l=0.06U
+ w=5U
M4675 VDD XCTRLA_CKP XCTRLA_XWENB0_0_Z1
+ VDD pch l=0.06U
+ w=0.21U
M4676 VDD XCTRLA_CKP XCTRLA_XWENB0_1_Z1
+ VDD pch l=0.06U
+ w=0.21U
M4677 VDD XCTRLA_RSP XCTRLA_XWENB0_1_Z1
+ VDD pch l=0.06U
+ w=0.75U
M4678 VDD XCTRLA_XWENB0_1_Z1
+ A_WENB_1 VDD pch_hvt l=0.06U
+ w=5U
M4679 XCTRLA_XWENB0_0_Z2 XCTRLA_CKP
+ XCTRLA_XWENB0_0_Z1 VSS nch l=0.06U
+ w=2U
M4680 XCTRLA_XWENB0_1_Z2 XCTRLA_CKP
+ XCTRLA_XWENB0_1_Z1 VSS nch l=0.06U
+ w=2U
M4681 VDD XCTRLA_AC_3 XCTRLA_XWENB0_0_Z1
+ VDD pch l=0.06U
+ w=0.21U
M4682 VDD XCTRLA_AT_3 XCTRLA_XWENB0_1_Z1
+ VDD pch l=0.06U
+ w=0.21U
M4683 VDD XCTRLA_RSP XCTRLA_XWENB0_1_Z1
+ VDD pch l=0.06U
+ w=0.75U
M4684 VDD XCTRLA_XWENB0_1_Z1
+ A_WENB_1 VDD pch_hvt l=0.06U
+ w=5U
M4685 XCTRLA_XWENB0_0_Z3 XCTRLA_AC_3
+ XCTRLA_XWENB0_0_Z2 VSS nch l=0.06U
+ w=2U
M4686 XCTRLA_XWENB0_1_Z3 XCTRLA_AT_3
+ XCTRLA_XWENB0_1_Z2 VSS nch l=0.06U
+ w=2U
M4687 XCTRLA_XWENB0_0_Z3 XCTRLA_AC_4
+ XCTRLA_XWENB0_0_Z4 VSS nch l=0.06U
+ w=2U
M4688 XCTRLA_XWENB0_1_Z3 XCTRLA_AC_4
+ XCTRLA_XWENB0_1_Z4 VSS nch l=0.06U
+ w=2U
M4689 VDD XCTRLA_AC_4 XCTRLA_XWENB0_0_Z1
+ VDD pch l=0.06U
+ w=0.21U
M4690 VDD XCTRLA_AC_4 XCTRLA_XWENB0_1_Z1
+ VDD pch l=0.06U
+	 w=0.21U
M4691 VDD XCTRLA_RSP XCTRLA_XWENB0_0_Z1
+ VDD pch l=0.06U
+ w=0.75U
M4692 VDD XCTRLA_XWENB0_0_Z1
+ A_WENB_0 VDD pch_hvt l=0.06U
+ w=5U
M4693 VDD XCTRLA_RWC XCTRLA_XWENB0_0_Z1
+ VDD pch l=0.06U
+ w=0.21U
M4694 VDD XCTRLA_RSP XCTRLA_XWENB0_0_Z1
+ VDD pch l=0.06U
+ w=0.75U
M4695 VDD XCTRLA_XWENB0_0_Z1
+ A_WENB_0 VDD pch_hvt l=0.06U
+ w=5U
M4696 VDD XCTRLA_RWC XCTRLA_XWENB0_1_Z1
+ VDD pch l=0.06U
+ w=0.21U
M4697 XCTRLA_XWENB0_0_Z4 XCTRLA_RWC VSS
+ VSS nch l=0.06U
+ w=2U
M4698 XCTRLA_XWENB0_1_Z4 XCTRLA_RWC VSS
+ VSS nch l=0.06U
+ w=2U
M4699 VDD XCTRLA_RWT
+ XCTRLA_XDEC1DWR_1_Z1 VDD pch l=0.06U
+ w=0.21U
M4700 VDD XCTRLA_RSP XCTRLA_XDEC1DWR_1_Z1
+ VDD pch l=0.06U
+ w=0.75U
M4701 VDD XCTRLA_XDEC1DWR_1_Z1 A_RD
+ VDD pch_hvt l=0.06U
+ w=5U
M4702 XCTRLA_XDEC1DWR_1_XND0_NET9
+ XCTRLA_RWT VSS VSS nch l=0.06U
+ w=2U
M4703 XCTRLA_XDEC1DWR_0_XND0_NET9
+ XCTRLA_RWC VSS VSS nch l=0.06U
+ w=2U
M4704 VDD XCTRLA_RSP
+ XCTRLA_XDEC1DWR_1_Z1 VDD pch l=0.06U
+ w=0.75U
M4705 VDD XCTRLA_XDEC1DWR_1_Z1 A_RD
+ VDD pch_hvt l=0.06U
+ w=5U
M4706 VDD XCTRLA_CKP
+ XCTRLA_XDEC1DWR_1_Z1 VDD pch l=0.06U
+ w=0.21U
M4707 XCTRLA_XDEC1DWR_1_Z1 XCTRLA_CKP
+ XCTRLA_XDEC1DWR_1_XND0_NET9 VSS nch
+ l=0.06U
+ w=2U
M4708 XCTRLA_XDEC1DWR_0_Z1 XCTRLA_CKP
+ XCTRLA_XDEC1DWR_0_XND0_NET9 VSS nch
+ l=0.06U
+ w=2U
M4709 VDD XCTRLA_RSP
+ XCTRLA_XDEC1DWR_0_Z1 VDD pch l=0.06U
+ w=0.75U
M4710 VDD XCTRLA_XDEC1DWR_0_Z1 A_WRT
+ VDD pch_hvt l=0.06U
+ w=5U
M4711 VDD XCTRLA_RSP XCTRLA_XDEC1DWR_0_Z1
+ VDD pch l=0.06U
+ w=0.75U
M4712 VDD XCTRLA_XDEC1DWR_0_Z1 A_WRT
+ VDD pch_hvt l=0.06U
+ w=5U
M4713 VDD XCTRLA_RWC
+ XCTRLA_XDEC1DWR_0_Z1 VDD pch l=0.06U
+ w=0.21U
M4714 VDD XCTRLA_CKP
+ XCTRLA_XDEC1DWR_0_Z1 VDD pch l=0.06U
+ w=0.21U
M4715 VDD XCTRLA_XCKG_Z17 XCTRLA_XCKG_RS VDD
+ pch l=0.06U
+ w=0.9U
M4716 VDD XCTRLA_XCKG_Z17 XCTRLA_XCKG_RS VDD
+ pch l=0.06U
+ w=0.9U
M4717 VDD XCTRLA_XCKG_Z17 XCTRLA_XCKG_RS VDD
+ pch l=0.06U
+ w=0.9U
M4718 VDD XCTRLA_XCKG_Z16 XCTRLA_XCKG_Z17 VDD
+ pch l=0.06U
+	 w=0.64U
M4719 VDD XCTRLA_XCKG_Z17 XCTRLA_XCKG_Z14 VDD
+ pch l=0.06U
+ w=0.41U
M4720 VDD XCTRLA_XCKG_Z14 XCTRLA_XCKG_Z17 VDD
+ pch l=0.06U
+	 w=0.64U
M4721 VDD XCTRLA_XCKG_Z13 XCTRLA_XCKG_Z14 VDD
+ pch l=0.06U
+ w=0.41U
M4722 VDD XCTRLA_XCKG_Z15 XCTRLA_XCKG_Z16 VDD
+ pch l=0.06U
+ w=0.41U
M4723 VDD XCTRLA_RSTCK XCTRLA_XCKG_Z16 VDD
+ pch l=0.06U
+ w=0.41U
M4724 VDD XCTRLA_XCKG_Z13 XCTRLA_XCKG_Z15 VDD
+ pch l=0.06U
+ w=0.41U
M4725 VDD TM XCTRLA_XCKG_Z15 VDD pch
+ l=0.06U
+ w=0.41U
M4726 VDD XCTRLA_XCKG_Z18 XCTRLA_RSP
+ VDD pch l=0.06U
+	 w=3.25U
M4727 VDD XCTRLA_XCKG_Z18 XCTRLA_RSP VDD
+ pch l=0.06U
+ w=3.25U
M4728 VDD XCTRLA_RSP XCTRLA_RSN VDD
+ pch l=0.06U
+ w=3.25U
M4729 VDD XCTRLA_CKP XCTRLA_XCKD0_Z1 VDD
+ pch l=0.08U
+ w=1U
M4730 VDD XCTRLA_RSP XCTRLA_RSN
+ VDD pch l=0.06U
+	 w=3.25U
M4731 VDD XCTRLA_XCKG_RS XCTRLA_XCKG_Z18 VDD
+ pch l=0.06U
+ w=1.28U
M4732 VDD XCTRLA_XCKD0_Z1 A_CKD VDD pch
+ l=0.06U
+ w=3U
M4733 VDD XCTRLA_CKPC A_CKD VDD pch
+ l=0.06U
+	 w=3.75U
M4734 VSS XCTRLA_XCKENB0_CKC
+ XCTRLA_XCKENB0_Z1 VSS nch l=0.06U
+ w=1.6U
M4735 XCTRLA_XCKENB0_CKT
+ XCTRLA_XCKENB0_CKC VSS VSS nch
+ l=0.06U
+ w=0.41U
M4736 VDD XCTRLA_XCKG_RS XCTRLA_XCKG_Z19 VDD
+ pch l=0.06U
+ w=1.6U
M4737 VDD XCTRLA_XCKG_Z19 XCTRLA_CKP VDD
+ pch l=0.06U
+ w=1.2U
M4738 VDD XCTRLA_XCKG_Z19 XCTRLA_CKP VDD
+ pch l=0.06U
+ w=1.2U
M4739 VDD XCTRLA_CKP XCTRLA_XCKG_Z19 VDD
+ pch l=0.06U
+ w=1.6U
M4740 VDD XCTRLA_CKPC XCTRLA_CKP VDD
+ pch l=0.06U
+ w=3U
M4741 VDD XCTRLA_CKPC XCTRLA_CKP VDD
+ pch l=0.06U
+ w=3U
M4742 VDD XCTRLA_CKPC XCTRLA_CKP VDD
+ pch l=0.06U
+ w=3U
M4743 VDD XCTRLA_CKPC XCTRLA_CKP VDD
+ pch l=0.06U
+ w=3U
M4744 VDD XCTRLA_CKPC XCTRLA_CKP VDD
+ pch l=0.06U
+ w=3U
M4745 VDD XCTRLA_XCKG_RS XCTRLA_CKPC VDD
+ pch l=0.06U
+ w=3U
M4746 VDD XCTRLA_XCKG_RS XCTRLA_CKPC VDD
+ pch l=0.06U
+ w=3U
M4747 VDD BISTT XCTRLA_XCKG_Z4 VDD pch
+ l=0.06U
+ w=2.86U
M4748 XCTRLA_XCKG_Z4 BISTT VDD VDD pch
+ l=0.06U
+ w=2.86U
M4749 VDD XCTRLA_CKPC XCTRLA_CKP VDD
+ pch l=0.06U
+ w=3U
M4750 VDD XCTRLA_CKPC XCTRLA_CKP VDD
+ pch l=0.06U
+ w=3U
M4751 VDD XCTRLA_CKPC XCTRLA_CKP VDD
+ pch l=0.06U
+ w=3U
M4752 VDD BISTT XCTRLA_XCKG_Z4 VDD pch
+ l=0.06U
+ w=2.86U
M4753 XCTRLA_XCKG_Z4 CLKA XCTRLA_CKPC VDD
+ pch l=0.06U
+ w=2.86U
M4754 XCTRLA_CKPC CLKA XCTRLA_XCKG_Z4 VDD
+ pch l=0.06U
+ w=2.86U
M4755 XCTRLA_XCKG_Z4 CLKA XCTRLA_CKPC VDD
+ pch l=0.06U
+ w=2.86U
M4756 XCTRLA_XCKG_Z5 BISTC VDD VDD pch
+ l=0.06U
+ w=2.86U
M4757 XCTRLA_CKPC CLKM XCTRLA_XCKG_Z5 VDD
+ pch l=0.06U
+ w=2.86U
M4758 XCTRLA_XCKG_Z5 CLKM XCTRLA_CKPC VDD
+ pch l=0.06U
+ w=2.86U
M4759 XCTRLA_CKPC CLKM XCTRLA_XCKG_Z5 VDD
+ pch l=0.06U
+ w=2.86U
M4760 XCTRLA_XCKG_Z5 BISTC VDD VDD pch
+ l=0.06U
+ w=2.86U
M4761 VDD BISTC XCTRLA_XCKG_Z5 VDD pch
+ l=0.06U
+ w=2.86U
M4762 VDD XCTRLA_CKENB
+ XCTRLA_XCKENB0_Z5 VDD pch l=0.06U
+ w=0.42U
M4763 VDD CLKA XCTRLA_XCKENB0_CKC
+ VDD pch l=0.06U
+ w=0.42U
M4764 VDD XCTRLA_XCKENB0_CKC
+ XCTRLA_XCKENB0_CKT VDD pch l=0.06U
+ w=0.42U
M4765 VDD XCTRLA_XCKENB0_Z5
+ XCTRLA_XCKENB0_Z2 VDD pch l=0.06U
+ w=0.42U
M4766 VDD XCTRLA_CKPC A_CKD VDD pch
+ l=0.06U
+	 w=3.75U
M4767 VDD CLKA XCTRLA_XCKENB0_CKC
+ VDD pch l=0.06U
+ w=0.42U
M4768 VDD XCTRLA_XCKENB0_CKC
+ XCTRLA_XCKENB0_CKT VDD pch l=0.06U
+ w=0.42U
M4769 XCTRLA_CKENB XCTRLA_XCKENB0_CEX
+ XCTRLA_XCKENB0_Z1 VSS nch l=0.06U
+ w=1.6U
M4770 XCTRLA_CKENB XCTRLA_XCKENB0_CKC
+ XCTRLA_XCKENB0_Z2 VDD pch l=0.06U
+ w=0.42U
M4771 VDD XCTRLA_CKPC A_CKD VDD pch
+ l=0.06U
+	 w=3.75U
M4772 XCTRLA_XCKENB0_Z4 XCTRLA_XCKENB0_CKT
+ XCTRLA_CKENB VSS nch l=0.06U
+ w=0.21U
M4773 VDD XCTRLA_XCKENB0_CE
+ XCTRLA_XCKENB0_CEX VDD pch l=0.06U
+ w=0.42U
M4774 XCTRLA_XCKENB0_XI6_NET9 XCTRLA_XCKENB0_CE
+ XCTRLA_XCKENB0_CEX VSS nch l=0.06U
+ w=0.41U
M4775 XCTRLA_XCKENB0_Z3 XCTRLA_XCKENB0_CEX
+ XCTRLA_CKENB VDD pch l=0.06U
+ w=3.2U
M4776 VDD CEBA XCTRLA_XCKENB0_CE VDD
+ pch l=0.06U
+	 w=0.42U
M4777 VDD XCTRLA_CKPC A_CKD VDD pch
+ l=0.06U
+	 w=3.75U
M4778 VDD BISTC XCTRLA_XCKENB0_CEX VDD
+ pch l=0.06U
+ w=0.42U
M4779 XCTRLA_XCKENB0_XI6_NET9 BISTC VSS VSS
+ nch l=0.06U
+ w=0.41U
M4780 XCTRLA_XCKENB0_Z5 XCTRLA_CKENB
+ VSS VSS nch l=0.06U
+ w=0.21U
M4781 VDD XCTRLA_XCKENB0_CKT
+ XCTRLA_XCKENB0_Z3 VDD pch l=0.06U
+ w=3.2U
M4782 VSS XCTRLA_XCKENB0_Z5
+ XCTRLA_XCKENB0_Z4 VSS nch l=0.06U
+ w=0.21U
M4783 VDD XCTRLA_CKPC A_CKD VDD pch
+ l=0.06U
+	 w=3.75U
M4784 XCTRLA_XCKENB0_CKC CLKA VSS
+ VSS nch l=0.06U
+	 w=0.84U
M4785 VDD XCTRLA_XCKENB1_CKT
+ XCTRLA_XCKENB1_Z3 VDD pch l=0.06U
+ w=3.2U
M4786 XCTRLA_XCKENB1_XI6_NET9 BISTT VSS VSS
+ nch l=0.06U
+ w=0.41U
M4787 XCTRLA_XCKENB1_Z4 XCTRLA_XCKENB1_Z5
+ VSS VSS nch l=0.06U
+ w=0.21U
M4788 XCTRLA_XCKENB1_Z5 XCTRLA_CKMENB
+ VSS VSS nch l=0.06U
+ w=0.21U
M4789 VDD BISTT XCTRLA_XCKENB1_CEX VDD
+ pch l=0.06U
+ w=0.42U
M4790 VDD XCTRLA_CKPC A_CKD VDD pch
+ l=0.06U
+	 w=3.75U
M4791 XCTRLA_XCKENB1_CEX XCTRLA_XCKENB1_CE
+ XCTRLA_XCKENB1_XI6_NET9 VSS nch l=0.06U
+ w=0.41U
M4792 XCTRLA_XCKENB1_Z3 XCTRLA_XCKENB1_CEX
+ XCTRLA_CKMENB VDD pch l=0.06U
+ w=3.2U
M4793 VDD CEBMA XCTRLA_XCKENB1_CE VDD
+ pch l=0.06U
+ w=0.42U
M4794 VDD XCTRLA_XCKENB1_CE
+ XCTRLA_XCKENB1_CEX VDD pch l=0.06U
+ w=0.42U
M4795 XCTRLA_XCKENB1_Z4 XCTRLA_XCKENB1_CKT
+ XCTRLA_CKMENB VSS nch l=0.06U
+ w=0.21U
M4796 VDD XCTRLA_CKPC A_CKD VDD pch
+ l=0.06U
+ w=3.75U
M4797 XCTRLA_XCKENB1_Z2 XCTRLA_XCKENB1_CKC
+ XCTRLA_CKMENB VDD pch l=0.06U
+ w=0.42U
M4798 VDD CLKM XCTRLA_XCKENB1_CKC
+ VDD pch l=0.06U
+ w=0.42U
M4799 VDD XCTRLA_XCKENB1_CKC
+ XCTRLA_XCKENB1_CKT VDD pch l=0.06U
+ w=0.42U
M4800 XCTRLA_CKMENB XCTRLA_XCKENB1_CEX
+ XCTRLA_XCKENB1_Z1 VSS nch l=0.06U
+ w=1.6U
M4801 VDD XCTRLA_CKPC A_CKD VDD pch
+ l=0.06U
+ w=3.75U
M4802 XCTRLA_XCKG_XND3_NET9 XCTRLA_XCKG_Z19 VSS
+ VSS nch l=0.06U
+ w=2.66U
M4803 VSS XCTRLA_XCKG_Z19 XCTRLA_XCKG_XND3_NET9
+ VSS nch l=0.06U
+ w=2.66U
M4804 VSS XCTRLA_XCKG_Z19 XCTRLA_XCKG_XND3_NET9
+ VSS nch l=0.06U
+ w=2.66U
M4805 XCTRLA_XCKG_XND3_NET9 XCTRLA_CKPC
+ XCTRLA_CKP VSS nch l=0.06U
+ w=2.66U
M4806 XCTRLA_CKP XCTRLA_CKPC
+ XCTRLA_XCKG_XND3_NET9 VSS nch l=0.06U
+ w=2.66U
M4807 XCTRLA_XCKG_XND3_NET9 XCTRLA_CKPC
+ XCTRLA_CKP VSS nch l=0.06U
+ w=2.66U
M4808 VSS XCTRLA_XCKG_Z18 XCTRLA_CKP VSS
+ nch l=0.06U
+	 w=2.66U
M4809 VSS XCTRLA_XCKG_Z18 XCTRLA_CKP VSS
+ nch l=0.06U
+ w=2.66U
M4810 VSS XCTRLA_XCKG_Z18 XCTRLA_CKP VSS
+ nch l=0.06U
+	 w=2.66U
M4811 XCTRLA_XCKG_Z1 XCTRLA_XCKG_RS VSS VSS
+ nch l=0.06U
+	 w=2.86U
M4812 XCTRLA_XCKG_Z1 XCTRLA_XCKG_RS VSS VSS
+ nch l=0.06U
+	 w=2.86U
M4813 XCTRLA_XCKG_Z1 XCTRLA_XCKG_RS VSS VSS
+ nch l=0.06U
+ w=2.86U
M4814 XCTRLA_XCKG_Z1 XCTRLA_CKENB XCTRLA_XCKG_Z2
+ VSS nch l=0.06U
+ w=2.86U
M4815 XCTRLA_XCKG_Z2 XCTRLA_CKENB XCTRLA_XCKG_Z1
+ VSS nch l=0.06U
+ w=2.86U
M4816 XCTRLA_XCKG_Z1 XCTRLA_CKENB XCTRLA_XCKG_Z2
+ VSS nch l=0.06U
+ w=2.86U
M4817 XCTRLA_XCKG_Z2 CLKA XCTRLA_CKPC VSS
+ nch l=0.06U
+	 w=2.86U
M4818 XCTRLA_XCKG_Z2 CLKA XCTRLA_CKPC VSS
+ nch l=0.06U
+	 w=2.86U
M4819 XCTRLA_CKPC CLKA XCTRLA_XCKG_Z2 VSS
+ nch l=0.06U
+	 w=2.86U
M4820 XCTRLA_XCKG_Z3 XCTRLA_CKMENB XCTRLA_XCKG_Z1
+ VSS nch l=0.06U
+ w=2.86U
M4821 XCTRLA_CKPC CLKM XCTRLA_XCKG_Z3 VSS
+ nch l=0.06U
+	 w=2.86U
M4822 XCTRLA_CKPC CLKM XCTRLA_XCKG_Z3 VSS
+ nch l=0.06U
+	 w=2.86U
M4823 XCTRLA_XCKG_Z3 CLKM XCTRLA_CKPC VSS
+ nch l=0.06U
+	 w=2.86U
M4824 XCTRLA_XCKG_Z3 XCTRLA_CKMENB XCTRLA_XCKG_Z1
+ VSS nch l=0.06U
+ w=2.86U
M4825 XCTRLA_XCKG_Z1 XCTRLA_CKMENB XCTRLA_XCKG_Z3
+ VSS nch l=0.06U
+ w=2.86U
M4826 XCTRLA_XCKG_RS XCTRLA_XCKG_Z17 VSS VSS
+ nch l=0.06U
+ w=0.675U
M4827 XCTRLA_XCKG_RS XCTRLA_XCKG_Z17 VSS VSS
+ nch l=0.06U
+ w=0.675U
M4828 XCTRLA_RSN XCTRLA_RSP VSS VSS
+ nch l=0.06U
+ w=1.5U
M4829 XCTRLA_RSN XCTRLA_RSP VSS
+ VSS nch l=0.06U
+ w=1.5U
M4830 XCTRLA_RSP XCTRLA_XCKG_Z18 VSS VSS
+ nch l=0.06U
+ w=1.5U
M4831 XCTRLA_RSP XCTRLA_XCKG_Z18 VSS
+ VSS nch l=0.06U
+ w=1.5U
M4832 XCTRLA_XCKG_Z18 XCTRLA_XCKG_RS VSS VSS
+ nch l=0.06U
+ w=1.28U
M4833 XCTRLA_XCKG_XND4_NET9 XCTRLA_XCKG_RS
+ XCTRLA_XCKG_Z19 VSS nch l=0.06U
+ w=1.6U
M4834 XCTRLA_XCKG_XND4_NET9 XCTRLA_CKP VSS
+ VSS nch l=0.06U
+	 w=1.6U
M4835 VSS XCTRLA_XCKG_Z15 XCTRLA_XCKG_XI17_NET9
+ VSS nch l=0.06U
+ w=0.41U
M4836 XCTRLA_XCKG_XI17_NET9 XCTRLA_RSTCK
+ XCTRLA_XCKG_Z16 VSS nch l=0.06U
+ w=0.41U
M4837 XCTRLA_XCKG_XND1_NET9 XCTRLA_XCKG_Z16
+ XCTRLA_XCKG_Z17 VSS nch l=0.06U
+ w=0.64U
M4838 VSS XCTRLA_XCKG_Z17 XCTRLA_XCKG_XND0_NET9
+ VSS nch l=0.06U
+ w=0.41U
M4839 VSS XCTRLA_XCKG_Z14 XCTRLA_XCKG_XND1_NET9
+ VSS nch l=0.06U
+	 w=0.64U
M4840 XCTRLA_XCKG_XND0_NET9 XCTRLA_XCKG_Z13
+ XCTRLA_XCKG_Z14 VSS nch l=0.06U
+ w=0.41U
M4841 XCTRLA_XCKG_Z13 XCTRLA_XCKG_Z12 VSS VSS
+ nch l=0.06U
+ w=0.21U
M4842 XCTRLA_XCKG_Z8 BISTC VSS VSS nch
+ l=0.06U
+ w=0.41U
M4843 XCTRLA_XCKG_Z8 CLKA XCTRLA_XCKG_Z12 VSS
+ nch l=0.06U
+	 w=0.41U
M4844 XCTRLA_XCKG_Z12 CLKM XCTRLA_XCKG_Z9 VSS
+ nch l=0.06U
+ w=0.41U
M4845 XCTRLA_XCKG_XI13_NET9 XCTRLA_XCKG_Z13
+ XCTRLA_XCKG_Z15 VSS nch l=0.06U
+ w=0.41U
M4846 VSS TM XCTRLA_XCKG_XI13_NET9 VSS
+ nch l=0.06U
+ w=0.41U
M4847 XCTRLA_XCKG_Z9 BISTT VSS VSS nch
+ l=0.06U
+ w=0.41U
M4848 VDD CLKM XCTRLA_XCKENB1_CKC
+ VDD pch l=0.06U
+ w=0.42U
M4849 VDD XCTRLA_XCKENB1_CKC
+ XCTRLA_XCKENB1_CKT VDD pch l=0.06U
+ w=0.42U
M4850 XCTRLA_XCKENB1_CKT
+ XCTRLA_XCKENB1_CKC VSS VSS nch
+ l=0.06U
+ w=0.41U
M4851 XCTRLA_XCKENB1_Z1 XCTRLA_XCKENB1_CKC
+ VSS VSS nch l=0.06U
+ w=1.6U
M4852 VDD XCTRLA_CKMENB
+ XCTRLA_XCKENB1_Z5 VDD pch l=0.06U
+ w=0.42U
M4853 XCTRLA_XCKENB1_Z2 XCTRLA_XCKENB1_Z5
+ VDD VDD pch l=0.06U
+ w=0.42U
M4854 VDD XCTRLA_CKP XCTRLA_CKC VDD
+ pch l=0.06U
+ w=1.25U
M4855 VDD XCTRLA_CKP XCTRLA_CKC VDD
+ pch l=0.06U
+ w=1.25U
M4856 XCTRLA_XCKD0_XI3_NET9 XCTRLA_CKPC A_CKD
+ VSS nch l=0.06U
+ w=2.5U
M4857 A_CKD XCTRLA_CKPC XCTRLA_XCKD0_XI3_NET9
+ VSS nch l=0.06U
+	 w=2.5U
M4858 A_CKD XCTRLA_CKPC XCTRLA_XCKD0_XI3_NET9
+ VSS nch l=0.06U
+	 w=2.5U
M4859 XCTRLA_XCKD0_XI3_NET9 XCTRLA_CKPC A_CKD
+ VSS nch l=0.06U
+ w=2.5U
M4860 VSS XCTRLA_XCKD0_Z1 XCTRLA_XCKD0_XI3_NET9
+ VSS nch l=0.06U
+	 w=2.5U
M4861 XCTRLA_XCKD0_XI3_NET9 XCTRLA_XCKD0_Z1 VSS
+ VSS nch l=0.06U
+	 w=2.5U
M4862 VSS XCTRLA_XCKD0_Z1 XCTRLA_XCKD0_XI3_NET9
+ VSS nch l=0.06U
+	 w=2.5U
M4863 XCTRLA_XCKD0_XI3_NET9 XCTRLA_XCKD0_Z1 VSS
+ VSS nch l=0.06U
+	 w=2.5U
M4864 XCTRLA_XCKD0_XI3_NET9 XCTRLA_XCKD0_Z1 VSS
+ VSS nch l=0.06U
+ w=2.5U
M4865 XCTRLA_XCKD0_Z1 XCTRLA_CKP VSS VSS
+ nch l=0.06U
+ w=1U
M4866 XCTRLA_CKC XCTRLA_CKP VSS VSS
+ nch l=0.06U
+ w=2.5U
M4867 XCTRLA_XCKENB1_CKC CLKM VSS
+ VSS nch l=0.06U
+	 w=0.84U
M4868 VSS VR_0 XCTRLA_XXDEL_XI58_NET9 VSS
+ nch l=0.06U
+ w=0.41U
M4869 VSS VR_1 XCTRLA_XXDEL_XI56_NET9 VSS
+ nch l=0.06U
+ w=0.41U
M4870 VSS VW_0 XCTRLA_XXDEL_XI30_NET9 VSS
+ nch l=0.06U
+ w=0.41U
M4871 VSS VW_1 XCTRLA_XXDEL_XI32_NET9 VSS
+ nch l=0.06U
+ w=0.41U
M4872 XCTRLA_XXDEL_XI30_NET9 A_WRT
+ XCTRLA_XXDEL_VWRT0 VSS nch l=0.06U
+ w=0.41U
M4873 XCTRLA_XXDEL_XI32_NET9 A_WRT
+ XCTRLA_XXDEL_VWRT1 VSS nch l=0.06U
+ w=0.41U
M4874 XCTRLA_XXDEL_XI58_NET9 A_RD
+ XCTRLA_XXDEL_VRD0 VSS nch l=0.06U
+ w=0.41U
M4875 XCTRLA_XXDEL_XI56_NET9 A_RD
+ XCTRLA_XXDEL_VRD1 VSS nch l=0.06U
+ w=0.41U
M4876 VDD XCTRLA_RSTCK XCTRLA_XXDEL_Z3 VDD
+ pch l=0.06U
+ w=0.65U
M4877 VDD XCTRLA_RSTCK XCTRLA_XXDEL_Z3 VDD
+ pch l=0.06U
+ w=0.65U
M4878 XCTRLA_XXDEL_Z3 XCTRLA_XXDEL_VRD0 A_DBL
+ VDD pch l=0.06U
+	 w=0.18U
M4879 XCTRLA_XXDEL_Z3 XCTRLA_XXDEL_VWRT1 A_DBL
+ VDD pch l=0.06U
+ w=0.18U
M4880 XCTRLA_XXDEL_Z3 XCTRLA_XXDEL_VWRT1
+ A_DBL VDD pch l=0.06U
+ w=0.18U
M4881 VDD VR_0 XCTRLA_XXDEL_VRD0 VDD
+ pch l=0.06U
+ w=0.41U
M4882 VDD VR_1 XCTRLA_XXDEL_VRD1 VDD
+ pch l=0.06U
+ w=0.41U
M4883 VDD VW_0 XCTRLA_XXDEL_VWRT0 VDD
+ pch l=0.06U
+ w=0.41U
M4884 VDD VW_1 XCTRLA_XXDEL_VWRT1 VDD
+ pch l=0.06U
+ w=0.41U
M4885 VDD A_WRT XCTRLA_XXDEL_VWRT0 VDD
+ pch l=0.06U
+ w=0.41U
M4886 VDD A_WRT XCTRLA_XXDEL_VWRT1 VDD
+ pch l=0.06U
+ w=0.41U
M4887 XCTRLA_XXDEL_Z3 XCTRLA_XXDEL_VWRT0 A_DBL
+ VDD pch l=0.06U
+	 w=0.18U
M4888 VDD A_RD XCTRLA_XXDEL_VRD1 VDD
+ pch l=0.06U
+ w=0.41U
M4889 VDD A_RD XCTRLA_XXDEL_VRD0 VDD
+ pch l=0.06U
+ w=0.41U
M4890 XCTRLA_XXDEL_Z3 XCTRLA_XXDEL_VRD1 A_DBL
+ VDD pch l=0.06U
+ w=0.18U
M4891 XCTRLA_XXDEL_Z3 XCTRLA_XXDEL_VRD1
+ A_DBL VDD pch l=0.06U
+ w=0.18U
M4892 XCTRLA_RSTCK A_DBL XCTRLA_XXDEL_XI15_NET3
+ VDD pch l=0.06U
+ w=1.1U
M4893 XCTRLA_RSTCK A_DBL XCTRLA_XXDEL_XI15_NET3
+ VDD pch l=0.06U
+ w=1.1U
M4894 XCTRLA_XXDEL_XI15_NET3 XCTRLA_XXDEL_Z2 VDD
+ VDD pch l=0.06U
+	 w=1.1U
M4895 XCTRLA_XXDEL_XI15_NET3 XCTRLA_XXDEL_Z2 VDD
+ VDD pch l=0.06U
+	 w=1.1U
M4896 VDD XCTRLA_CKP XCTRLA_XXDEL_Z2 VDD
+ pch l=0.06U
+ w=0.41U
M4897 XCTRLA_RSTCK A_DBL VSS VSS nch
+ l=0.06U
+ w=1.1U
M4898 XCTRLA_RSTCK A_DBL VSS VSS nch
+ l=0.06U
+ w=1.1U
M4899 XCTRLA_RSTCK XCTRLA_XXDEL_Z2 VSS VSS
+ nch l=0.06U
+ w=0.55U
M4900 XCTRLA_RSTCK XCTRLA_XXDEL_Z2 VSS VSS
+ nch l=0.06U
+ w=0.55U
M4901 XCTRLA_XXDEL_Z2 XCTRLA_CKP VSS VSS
+ nch l=0.06U
+ w=0.21U
M4902 VSS XCTRLB_XCKENB1_CKC
+ XCTRLB_XCKENB1_Z1 VSS nch l=0.06U
+ w=1.6U
M4903 XCTRLB_XCKENB1_CKT
+ XCTRLB_XCKENB1_CKC VSS VSS nch
+ l=0.06U
+ w=0.41U
M4904 VDD XCTRLB_CKMENB
+ XCTRLB_XCKENB1_Z5 VDD pch l=0.06U
+ w=0.42U
M4905 VDD CLKM XCTRLB_XCKENB1_CKC
+ VDD pch l=0.06U
+ w=0.42U
M4906 VDD XCTRLB_XCKENB1_CKC
+ XCTRLB_XCKENB1_CKT VDD pch l=0.06U
+ w=0.42U
M4907 VDD XCTRLB_XCKENB1_Z5
+ XCTRLB_XCKENB1_Z2 VDD pch l=0.06U
+ w=0.42U
M4908 VDD XCTRLB_CKPC B_CKD VDD pch
+ l=0.06U
+ w=3.75U
M4909 VDD CLKM XCTRLB_XCKENB1_CKC
+ VDD pch l=0.06U
+ w=0.42U
M4910 VDD XCTRLB_XCKENB1_CKC
+ XCTRLB_XCKENB1_CKT VDD pch l=0.06U
+ w=0.42U
M4911 A_WENB_1 XCTRLA_XWENB0_1_Z1
+ VSS VSS nch_hvt l=0.06U
+ w=0.8U
M4912 A_WENB_1 XCTRLA_XWENB0_1_Z1
+ VSS VSS nch_hvt l=0.06U
+ w=0.8U
M4913 A_WENB_0 XCTRLA_XWENB0_0_Z1
+ VSS VSS nch_hvt l=0.06U
+ w=0.8U
M4914 A_WENB_0 XCTRLA_XWENB0_0_Z1
+ VSS VSS nch_hvt l=0.06U
+ w=0.8U
M4915 A_WENB_3 XCTRLA_XWENB0_3_Z1
+ VSS VSS nch_hvt l=0.06U
+ w=0.8U
M4916 A_WENB_3 XCTRLA_XWENB0_3_Z1
+ VSS VSS nch_hvt l=0.06U
+ w=0.8U
M4917 A_WENB_2 XCTRLA_XWENB0_2_Z1
+ VSS VSS nch_hvt l=0.06U
+ w=0.8U
M4918 A_WENB_2 XCTRLA_XWENB0_2_Z1
+ VSS VSS nch_hvt l=0.06U
+ w=0.8U
M4919 A_GCDEC_1 XCTRLA_XGCDEC0_1_Z1
+ VSS VSS nch_hvt l=0.06U
+ w=0.8U
M4920 A_GCDEC_0 XCTRLA_XGCDEC0_0_Z1
+ VSS VSS nch_hvt l=0.06U
+ w=0.8U
M4921 A_GCDEC_0 XCTRLA_XGCDEC0_0_Z1
+ VSS VSS nch_hvt l=0.06U
+ w=0.8U
M4922 A_WRT XCTRLA_XDEC1DWR_0_Z1 VSS
+ VSS nch_hvt l=0.06U
+	 w=0.8U
M4923 A_WRT XCTRLA_XDEC1DWR_0_Z1 VSS
+ VSS nch_hvt l=0.06U
+ w=0.8U
M4924 A_RD XCTRLA_XDEC1DWR_1_Z1 VSS
+ VSS nch_hvt l=0.06U
+ w=0.8U
M4925 A_RD XCTRLA_XDEC1DWR_1_Z1 VSS
+ VSS nch_hvt l=0.06U
+ w=0.8U
M4926 A_Y_4 XCTRLA_XDEC3DY_4_Z1 VSS
+ VSS nch_hvt l=0.06U
+ w=0.8U
M4927 A_Y_4 XCTRLA_XDEC3DY_4_Z1 VSS
+ VSS nch_hvt l=0.06U
+ w=0.8U
M4928 A_GCDEC_1 XCTRLA_XGCDEC0_1_Z1
+ VSS VSS nch_hvt l=0.06U
+ w=0.8U
M4929 A_GCDEC_3 XCTRLA_XGCDEC0_3_Z1
+ VSS VSS nch_hvt l=0.06U
+ w=0.8U
M4930 A_GCDEC_3 XCTRLA_XGCDEC0_3_Z1
+ VSS VSS nch_hvt l=0.06U
+ w=0.8U
M4931 A_GCDEC_2 XCTRLA_XGCDEC0_2_Z1
+ VSS VSS nch_hvt l=0.06U
+ w=0.8U
M4932 A_GCDEC_2 XCTRLA_XGCDEC0_2_Z1
+ VSS VSS nch_hvt l=0.06U
+ w=0.8U
M4933 A_Y_1 XCTRLA_XDEC3DY_1_Z1 VSS
+ VSS nch_hvt l=0.06U
+ w=0.8U
M4934 A_Y_1 XCTRLA_XDEC3DY_1_Z1 VSS
+ VSS nch_hvt l=0.06U
+ w=0.8U
M4935 A_Y_0 XCTRLA_XDEC3DY_0_Z1 VSS
+ VSS nch_hvt l=0.06U
+ w=0.8U
M4936 A_Y_0 XCTRLA_XDEC3DY_0_Z1 VSS
+ VSS nch_hvt l=0.06U
+ w=0.8U
M4937 A_Y_3 XCTRLA_XDEC3DY_3_Z1 VSS
+ VSS nch_hvt l=0.06U
+ w=0.8U
M4938 A_Y_3 XCTRLA_XDEC3DY_3_Z1 VSS
+ VSS nch_hvt l=0.06U
+ w=0.8U
M4939 A_Y_2 XCTRLA_XDEC3DY_2_Z1 VSS
+ VSS nch_hvt l=0.06U
+ w=0.8U
M4940 A_Y_2 XCTRLA_XDEC3DY_2_Z1 VSS
+ VSS nch_hvt l=0.06U
+ w=0.8U
M4941 A_XC_0 XCTRLA_XDEC3DXC_0_Z1 VSS
+ VSS nch_hvt l=0.06U
+	 w=0.8U
M4942 A_Y_7 XCTRLA_XDEC3DY_7_Z1 VSS
+ VSS nch_hvt l=0.06U
+ w=0.8U
M4943 A_Y_7 XCTRLA_XDEC3DY_7_Z1 VSS
+ VSS nch_hvt l=0.06U
+ w=0.8U
M4944 A_Y_6 XCTRLA_XDEC3DY_6_Z1 VSS
+ VSS nch_hvt l=0.06U
+ w=0.8U
M4945 A_Y_6 XCTRLA_XDEC3DY_6_Z1 VSS
+ VSS nch_hvt l=0.06U
+ w=0.8U
M4946 A_Y_5 XCTRLA_XDEC3DY_5_Z1 VSS
+ VSS nch_hvt l=0.06U
+ w=0.8U
M4947 A_Y_5 XCTRLA_XDEC3DY_5_Z1 VSS
+ VSS nch_hvt l=0.06U
+ w=0.8U
M4948 A_XB_3 XCTRLA_XDEC3DXB_3_Z1 VSS
+ VSS nch_hvt l=0.06U
+	 w=0.8U
M4949 A_XB_3 XCTRLA_XDEC3DXB_3_Z1 VSS
+ VSS nch_hvt l=0.06U
+	 w=0.8U
M4950 A_XB_2 XCTRLA_XDEC3DXB_2_Z1 VSS
+ VSS nch_hvt l=0.06U
+	 w=0.8U
M4951 A_XB_2 XCTRLA_XDEC3DXB_2_Z1 VSS
+ VSS nch_hvt l=0.06U
+	 w=0.8U
M4952 A_XB_1 XCTRLA_XDEC3DXB_1_Z1 VSS
+ VSS nch_hvt l=0.06U
+	 w=0.8U
M4953 A_XB_1 XCTRLA_XDEC3DXB_1_Z1 VSS
+ VSS nch_hvt l=0.06U
+	 w=0.8U
M4954 A_XB_0 XCTRLA_XDEC3DXB_0_Z1 VSS
+ VSS nch_hvt l=0.06U
+ w=0.8U
M4955 A_XB_0 XCTRLA_XDEC3DXB_0_Z1 VSS
+ VSS nch_hvt l=0.06U
+ w=0.8U
M4956 A_XC_7 XCTRLA_XDEC3DXC_7_Z1 VSS
+ VSS nch_hvt l=0.06U
+ w=0.8U
M4957 A_XC_7 XCTRLA_XDEC3DXC_7_Z1 VSS
+ VSS nch_hvt l=0.06U
+ w=0.8U
M4958 A_XC_6 XCTRLA_XDEC3DXC_6_Z1 VSS
+ VSS nch_hvt l=0.06U
+ w=0.8U
M4959 A_XC_6 XCTRLA_XDEC3DXC_6_Z1 VSS
+ VSS nch_hvt l=0.06U
+ w=0.8U
M4960 A_XC_5 XCTRLA_XDEC3DXC_5_Z1 VSS
+ VSS nch_hvt l=0.06U
+ w=0.8U
M4961 A_XC_5 XCTRLA_XDEC3DXC_5_Z1 VSS
+ VSS nch_hvt l=0.06U
+ w=0.8U
M4962 A_XC_4 XCTRLA_XDEC3DXC_4_Z1 VSS
+ VSS nch_hvt l=0.06U
+	 w=0.8U
M4963 A_XC_4 XCTRLA_XDEC3DXC_4_Z1 VSS
+ VSS nch_hvt l=0.06U
+	 w=0.8U
M4964 A_XC_3 XCTRLA_XDEC3DXC_3_Z1 VSS
+ VSS nch_hvt l=0.06U
+	 w=0.8U
M4965 A_XC_3 XCTRLA_XDEC3DXC_3_Z1 VSS
+ VSS nch_hvt l=0.06U
+	 w=0.8U
M4966 A_XC_2 XCTRLA_XDEC3DXC_2_Z1 VSS
+ VSS nch_hvt l=0.06U
+	 w=0.8U
M4967 A_XC_2 XCTRLA_XDEC3DXC_2_Z1 VSS
+ VSS nch_hvt l=0.06U
+	 w=0.8U
M4968 A_XC_1 XCTRLA_XDEC3DXC_1_Z1 VSS
+ VSS nch_hvt l=0.06U
+	 w=0.8U
M4969 A_XC_1 XCTRLA_XDEC3DXC_1_Z1 VSS
+ VSS nch_hvt l=0.06U
+	 w=0.8U
M4970 A_XC_0 XCTRLA_XDEC3DXC_0_Z1 VSS
+ VSS nch_hvt l=0.06U
+	 w=0.8U
M4971 A_XA_7 XCTRLA_XDEC3DXA_7_Z1 VSS
+ VSS nch_hvt l=0.06U
+ w=0.8U
M4972 A_XA_7 XCTRLA_XDEC3DXA_7_Z1 VSS
+ VSS nch_hvt l=0.06U
+ w=0.8U
M4973 A_XA_6 XCTRLA_XDEC3DXA_6_Z1 VSS
+ VSS nch_hvt l=0.06U
+ w=0.8U
M4974 A_XA_5 XCTRLA_XDEC3DXA_5_Z1 VSS
+ VSS nch_hvt l=0.06U
+ w=0.8U
M4975 A_XA_5 XCTRLA_XDEC3DXA_5_Z1 VSS
+ VSS nch_hvt l=0.06U
+ w=0.8U
M4976 A_XA_4 XCTRLA_XDEC3DXA_4_Z1 VSS
+ VSS nch_hvt l=0.06U
+ w=0.8U
M4977 A_XA_4 XCTRLA_XDEC3DXA_4_Z1 VSS
+ VSS nch_hvt l=0.06U
+ w=0.8U
M4978 A_XA_3 XCTRLA_XDEC3DXA_3_Z1 VSS
+ VSS nch_hvt l=0.06U
+ w=0.8U
M4979 A_XA_3 XCTRLA_XDEC3DXA_3_Z1 VSS
+ VSS nch_hvt l=0.06U
+ w=0.8U
M4980 A_XA_2 XCTRLA_XDEC3DXA_2_Z1 VSS
+ VSS nch_hvt l=0.06U
+ w=0.8U
M4981 A_XA_2 XCTRLA_XDEC3DXA_2_Z1 VSS
+ VSS nch_hvt l=0.06U
+ w=0.8U
M4982 A_XA_1 XCTRLA_XDEC3DXA_1_Z1 VSS
+ VSS nch_hvt l=0.06U
+ w=0.8U
M4983 A_XA_1 XCTRLA_XDEC3DXA_1_Z1 VSS
+ VSS nch_hvt l=0.06U
+ w=0.8U
M4984 A_XA_0 XCTRLA_XDEC3DXA_0_Z1 VSS
+ VSS nch_hvt l=0.06U
+ w=0.8U
M4985 A_XA_0 XCTRLA_XDEC3DXA_0_Z1 VSS
+ VSS nch_hvt l=0.06U
+ w=0.8U
M4986 A_Z_7 XCTRLA_XDEC3DZ_7_Z1 VSS
+ VSS nch_hvt l=0.06U
+ w=0.8U
M4987 A_Z_7 XCTRLA_XDEC3DZ_7_Z1 VSS
+ VSS nch_hvt l=0.06U
+ w=0.8U
M4988 A_Z_5 XCTRLA_XDEC3DZ_5_Z1 VSS
+ VSS nch_hvt l=0.06U
+ w=0.8U
M4989 A_Z_5 XCTRLA_XDEC3DZ_5_Z1 VSS
+ VSS nch_hvt l=0.06U
+ w=0.8U
M4990 A_Z_4 XCTRLA_XDEC3DZ_4_Z1 VSS
+ VSS nch_hvt l=0.06U
+ w=0.8U
M4991 A_Z_4 XCTRLA_XDEC3DZ_4_Z1 VSS
+ VSS nch_hvt l=0.06U
+ w=0.8U
M4992 A_Z_3 XCTRLA_XDEC3DZ_3_Z1 VSS
+ VSS nch_hvt l=0.06U
+ w=0.8U
M4993 A_Z_3 XCTRLA_XDEC3DZ_3_Z1 VSS
+ VSS nch_hvt l=0.06U
+ w=0.8U
M4994 A_Z_2 XCTRLA_XDEC3DZ_2_Z1 VSS
+ VSS nch_hvt l=0.06U
+ w=0.8U
M4995 A_Z_2 XCTRLA_XDEC3DZ_2_Z1 VSS
+ VSS nch_hvt l=0.06U
+ w=0.8U
M4996 A_Z_1 XCTRLA_XDEC3DZ_1_Z1 VSS
+ VSS nch_hvt l=0.06U
+ w=0.8U
M4997 A_Z_1 XCTRLA_XDEC3DZ_1_Z1 VSS
+ VSS nch_hvt l=0.06U
+ w=0.8U
M4998 A_Z_0 XCTRLA_XDEC3DZ_0_Z1 VSS
+ VSS nch_hvt l=0.06U
+ w=0.8U
M4999 A_Z_0 XCTRLA_XDEC3DZ_0_Z1 VSS
+ VSS nch_hvt l=0.06U
+ w=0.8U
M5000 A_XA_6 XCTRLA_XDEC3DXA_6_Z1 VSS
+ VSS nch_hvt l=0.06U
+ w=0.8U
M5001 A_Z_6 XCTRLA_XDEC3DZ_6_Z1 VSS
+ VSS nch_hvt l=0.06U
+ w=0.8U
M5002 A_Z_6 XCTRLA_XDEC3DZ_6_Z1 VSS
+ VSS nch_hvt l=0.06U
+ w=0.8U
M5003 XCTRLA_XCKENB0_CE CEBA VSS VSS
+ nch l=0.06U
+ w=0.21U
M5004 XCTRLA_XCKENB1_CE CEBMA VSS VSS
+ nch l=0.06U
+ w=0.21U
M5005 A_WRT XCTRLA_RSN VSS VSS nch
+ l=0.06U
+	 w=1U
M5006 A_WRT XCTRLA_RSN VSS VSS
+ nch l=0.06U
+	 w=1U
M5007 A_WENB_0 XCTRLA_RSN VSS VSS
+ nch l=0.06U
+	 w=1U
M5008 A_WENB_0 XCTRLA_RSN VSS VSS
+ nch l=0.06U
+	 w=1U
M5009 A_WENB_1 XCTRLA_RSN VSS VSS
+ nch l=0.06U
+	 w=1U
M5010 A_WENB_1 XCTRLA_RSN VSS VSS
+ nch l=0.06U
+	 w=1U
M5011 A_WENB_3 XCTRLA_RSN VSS VSS
+ nch l=0.06U
+	 w=1U
M5012 A_RD XCTRLA_RSN VSS VSS nch
+ l=0.06U
+	 w=1U
M5013 A_RD XCTRLA_RSN VSS VSS
+ nch l=0.06U
+	 w=1U
M5014 A_WENB_3 XCTRLA_RSN VSS VSS
+ nch l=0.06U
+	 w=1U
M5015 A_WENB_2 XCTRLA_RSN VSS VSS
+ nch l=0.06U
+	 w=1U
M5016 A_WENB_2 XCTRLA_RSN VSS VSS
+ nch l=0.06U
+	 w=1U
M5017 A_GCDEC_0 XCTRLA_RSN VSS VSS
+ nch l=0.06U
+	 w=1U
M5018 A_GCDEC_0 XCTRLA_RSN VSS VSS
+ nch l=0.06U
+	 w=1U
M5019 A_GCDEC_1 XCTRLA_RSN VSS VSS
+ nch l=0.06U
+	 w=1U
M5020 A_GCDEC_1 XCTRLA_RSN VSS VSS
+ nch l=0.06U
+	 w=1U
M5021 A_GCDEC_3 XCTRLA_RSN VSS VSS
+ nch l=0.06U
+	 w=1U
M5022 A_GCDEC_3 XCTRLA_RSN VSS VSS
+ nch l=0.06U
+	 w=1U
M5023 A_GCDEC_2 XCTRLA_RSN VSS VSS
+ nch l=0.06U
+	 w=1U
M5024 A_GCDEC_2 XCTRLA_RSN VSS VSS
+ nch l=0.06U
+	 w=1U
M5025 A_Y_0 XCTRLA_RSN VSS VSS nch
+ l=0.06U
+	 w=1U
M5026 A_Y_0 XCTRLA_RSN VSS VSS nch
+ l=0.06U
+	 w=1U
M5027 A_Y_1 XCTRLA_RSN VSS VSS nch
+ l=0.06U
+	 w=1U
M5028 A_Y_1 XCTRLA_RSN VSS VSS nch
+ l=0.06U
+	 w=1U
M5029 A_Y_3 XCTRLA_RSN VSS VSS nch
+ l=0.06U
+	 w=1U
M5030 A_Y_3 XCTRLA_RSN VSS VSS nch
+ l=0.06U
+	 w=1U
M5031 A_Y_2 XCTRLA_RSN VSS VSS nch
+ l=0.06U
+	 w=1U
M5032 A_Y_7 XCTRLA_RSN VSS VSS nch
+ l=0.06U
+	 w=1U
M5033 A_Y_7 XCTRLA_RSN VSS VSS nch
+ l=0.06U
+	 w=1U
M5034 A_Y_4 XCTRLA_RSN VSS VSS nch
+ l=0.06U
+	 w=1U
M5035 A_Y_4 XCTRLA_RSN VSS VSS nch
+ l=0.06U
+	 w=1U
M5036 A_Y_5 XCTRLA_RSN VSS VSS nch
+ l=0.06U
+	 w=1U
M5037 A_Y_5 XCTRLA_RSN VSS VSS nch
+ l=0.06U
+	 w=1U
M5038 A_Y_2 XCTRLA_RSN VSS VSS nch
+ l=0.06U
+	 w=1U
M5039 A_Y_6 XCTRLA_RSN VSS VSS nch
+ l=0.06U
+	 w=1U
M5040 A_Y_6 XCTRLA_RSN VSS VSS nch
+ l=0.06U
+	 w=1U
M5041 A_XB_3 XCTRLA_RSN VSS VSS nch
+ l=0.06U
+	 w=1U
M5042 A_XB_0 XCTRLA_RSN VSS VSS nch
+ l=0.06U
+	 w=1U
M5043 A_XB_0 XCTRLA_RSN VSS VSS
+ nch l=0.06U
+	 w=1U
M5044 A_XB_1 XCTRLA_RSN VSS VSS nch
+ l=0.06U
+	 w=1U
M5045 A_XB_1 XCTRLA_RSN VSS VSS
+ nch l=0.06U
+	 w=1U
M5046 A_XB_3 XCTRLA_RSN VSS VSS
+ nch l=0.06U
+	 w=1U
M5047 A_XB_2 XCTRLA_RSN VSS VSS nch
+ l=0.06U
+	 w=1U
M5048 A_XB_2 XCTRLA_RSN VSS VSS
+ nch l=0.06U
+	 w=1U
M5049 A_XC_3 XCTRLA_RSN VSS VSS nch
+ l=0.06U
+	 w=1U
M5050 A_XC_0 XCTRLA_RSN VSS VSS nch
+ l=0.06U
+	 w=1U
M5051 A_XC_0 XCTRLA_RSN VSS VSS
+ nch l=0.06U
+	 w=1U
M5052 A_XC_1 XCTRLA_RSN VSS VSS nch
+ l=0.06U
+	 w=1U
M5053 A_XC_1 XCTRLA_RSN VSS VSS
+ nch l=0.06U
+	 w=1U
M5054 A_XC_3 XCTRLA_RSN VSS VSS
+ nch l=0.06U
+	 w=1U
M5055 A_XC_2 XCTRLA_RSN VSS VSS nch
+ l=0.06U
+	 w=1U
M5056 A_XC_2 XCTRLA_RSN VSS VSS
+ nch l=0.06U
+	 w=1U
M5057 XCTRLA_XDWLDV_DWLC XCTRLA_CKP VSS
+ VSS nch l=0.06U
+	 w=0.61U
M5058 A_XC_7 XCTRLA_RSN VSS VSS nch
+ l=0.06U
+ w=1U
M5059 A_XC_4 XCTRLA_RSN VSS VSS nch
+ l=0.06U
+	 w=1U
M5060 A_XC_4 XCTRLA_RSN VSS VSS
+ nch l=0.06U
+	 w=1U
M5061 A_XC_5 XCTRLA_RSN VSS VSS nch
+ l=0.06U
+ w=1U
M5062 A_XC_5 XCTRLA_RSN VSS VSS
+ nch l=0.06U
+	 w=1U
M5063 A_XC_7 XCTRLA_RSN VSS VSS
+ nch l=0.06U
+ w=1U
M5064 A_XA_0 XCTRLA_RSN VSS VSS nch
+ l=0.06U
+ w=1U
M5065 A_XC_6 XCTRLA_RSN VSS VSS nch
+ l=0.06U
+ w=1U
M5066 A_XC_6 XCTRLA_RSN VSS VSS
+ nch l=0.06U
+ w=1U
M5067 A_XA_3 XCTRLA_RSN VSS VSS
+ nch l=0.06U
+ w=1U
M5068 A_XA_0 XCTRLA_RSN VSS VSS
+ nch l=0.06U
+ w=1U
M5069 A_XA_1 XCTRLA_RSN VSS VSS
+ nch l=0.06U
+ w=1U
M5070 A_XA_1 XCTRLA_RSN VSS VSS nch
+ l=0.06U
+ w=1U
M5071 A_XA_2 XCTRLA_RSN VSS VSS nch
+ l=0.06U
+ w=1U
M5072 A_XA_3 XCTRLA_RSN VSS VSS nch
+ l=0.06U
+ w=1U
M5073 A_XA_4 XCTRLA_RSN VSS VSS nch
+ l=0.06U
+ w=1U
M5074 A_XA_2 XCTRLA_RSN VSS VSS
+ nch l=0.06U
+ w=1U
M5075 A_XA_7 XCTRLA_RSN VSS VSS nch
+ l=0.06U
+ w=1U
M5076 A_XA_4 XCTRLA_RSN VSS VSS
+ nch l=0.06U
+ w=1U
M5077 A_XA_5 XCTRLA_RSN VSS VSS nch
+ l=0.06U
+ w=1U
M5078 A_XA_5 XCTRLA_RSN VSS VSS
+ nch l=0.06U
+ w=1U
M5079 A_XA_6 XCTRLA_RSN VSS VSS nch
+ l=0.06U
+ w=1U
M5080 A_XA_7 XCTRLA_RSN VSS VSS
+ nch l=0.06U
+	 w=1U
M5081 A_Z_0 XCTRLA_RSN VSS VSS nch
+ l=0.06U
+ w=1U
M5082 A_Z_0 XCTRLA_RSN VSS VSS nch
+ l=0.06U
+ w=1U
M5083 A_XA_6 XCTRLA_RSN VSS VSS
+ nch l=0.06U
+	 w=1U
M5084 A_Z_3 XCTRLA_RSN VSS VSS nch
+ l=0.06U
+ w=1U
M5085 A_Z_1 XCTRLA_RSN VSS VSS nch
+ l=0.06U
+ w=1U
M5086 A_Z_1 XCTRLA_RSN VSS VSS nch
+ l=0.06U
+ w=1U
M5087 A_Z_2 XCTRLA_RSN VSS VSS nch
+ l=0.06U
+ w=1U
M5088 A_Z_3 XCTRLA_RSN VSS VSS nch
+ l=0.06U
+ w=1U
M5089 A_Z_4 XCTRLA_RSN VSS VSS nch
+ l=0.06U
+ w=1U
M5090 A_Z_4 XCTRLA_RSN VSS VSS nch
+ l=0.06U
+ w=1U
M5091 A_Z_2 XCTRLA_RSN VSS VSS nch
+ l=0.06U
+ w=1U
M5092 A_Z_7 XCTRLA_RSN VSS VSS nch
+ l=0.06U
+ w=1U
M5093 A_Z_5 XCTRLA_RSN VSS VSS nch
+ l=0.06U
+ w=1U
M5094 A_Z_5 XCTRLA_RSN VSS VSS nch
+ l=0.06U
+ w=1U
M5095 A_Z_6 XCTRLA_RSN VSS VSS nch
+ l=0.06U
+ w=1U
M5096 A_Z_7 XCTRLA_RSN VSS VSS nch
+ l=0.06U
+ w=1U
M5097 A_Z_6 XCTRLA_RSN VSS VSS nch
+ l=0.06U
+	 w=1U
M5098 XCTRLB_CKMENB XCTRLB_XCKENB1_CEX
+ XCTRLB_XCKENB1_Z1 VSS nch l=0.06U
+ w=1.6U
M5099 XCTRLB_XCKENB1_Z2 XCTRLB_XCKENB1_CKC
+ XCTRLB_CKMENB VDD pch l=0.06U
+ w=0.42U
M5100 VDD XCTRLB_CKPC B_CKD VDD pch
+ l=0.06U
+ w=3.75U
M5101 XCTRLB_XCKENB1_Z4 XCTRLB_XCKENB1_CKT
+ XCTRLB_CKMENB VSS nch l=0.06U
+ w=0.21U
M5102 VDD XCTRLB_XCKENB1_CE
+ XCTRLB_XCKENB1_CEX VDD pch l=0.06U
+ w=0.42U
M5103 XCTRLB_XCKENB1_CEX XCTRLB_XCKENB1_CE
+ XCTRLB_XCKENB1_XI6_NET9 VSS nch l=0.06U
+ w=0.41U
M5104 XCTRLB_XCKENB1_Z3 XCTRLB_XCKENB1_CEX
+ XCTRLB_CKMENB VDD pch l=0.06U
+ w=3.2U
M5105 VDD CEBMB XCTRLB_XCKENB1_CE VDD
+ pch l=0.06U
+ w=0.42U
M5106 VDD XCTRLB_CKPC B_CKD VDD pch
+ l=0.06U
+	 w=3.75U
M5107 VDD BISTT XCTRLB_XCKENB1_CEX VDD
+ pch l=0.06U
+ w=0.42U
M5108 XCTRLB_XCKENB1_XI6_NET9 BISTT VSS VSS
+ nch l=0.06U
+ w=0.41U
M5109 XCTRLB_XCKENB1_Z5 XCTRLB_CKMENB
+ VSS VSS nch l=0.06U
+ w=0.21U
M5110 VDD XCTRLB_XCKENB1_CKT
+ XCTRLB_XCKENB1_Z3 VDD pch l=0.06U
+ w=3.2U
M5111 VSS XCTRLB_XCKENB1_Z5
+ XCTRLB_XCKENB1_Z4 VSS nch l=0.06U
+ w=0.21U
M5112 VDD XCTRLB_CKPC B_CKD VDD pch
+ l=0.06U
+	 w=3.75U
M5113 XCTRLB_XCKENB1_CKC CLKM VSS
+ VSS nch l=0.06U
+	 w=0.84U
M5114 VDD XCTRLB_XCKENB0_CKT
+ XCTRLB_XCKENB0_Z3 VDD pch l=0.06U
+ w=3.2U
M5115 XCTRLB_XCKENB0_XI6_NET9 BISTC VSS VSS
+ nch l=0.06U
+ w=0.41U
M5116 VSS XCTRLB_XCKENB0_Z5
+ XCTRLB_XCKENB0_Z4 VSS nch l=0.06U
+ w=0.21U
M5117 XCTRLB_XCKENB0_Z5 XCTRLB_CKENB
+ VSS VSS nch l=0.06U
+ w=0.21U
M5118 VDD BISTC XCTRLB_XCKENB0_CEX VDD
+ pch l=0.06U
+ w=0.42U
M5119 VDD XCTRLB_CKPC B_CKD VDD pch
+ l=0.06U
+	 w=3.75U
M5120 XCTRLB_XCKENB0_XI6_NET9 XCTRLB_XCKENB0_CE
+ XCTRLB_XCKENB0_CEX VSS nch l=0.06U
+ w=0.41U
M5121 XCTRLB_CKENB XCTRLB_XCKENB0_CEX
+ XCTRLB_XCKENB0_Z3 VDD pch l=0.06U
+ w=3.2U
M5122 VDD CEBB XCTRLB_XCKENB0_CE VDD
+ pch l=0.06U
+	 w=0.42U
M5123 VDD XCTRLB_XCKENB0_CE
+ XCTRLB_XCKENB0_CEX VDD pch l=0.06U
+ w=0.42U
M5124 XCTRLB_XCKENB0_Z4 XCTRLB_XCKENB0_CKT
+ XCTRLB_CKENB VSS nch l=0.06U
+ w=0.21U
M5125 VDD XCTRLB_CKPC B_CKD VDD pch
+ l=0.06U
+	 w=3.75U
M5126 XCTRLB_XCKENB0_Z2 XCTRLB_XCKENB0_CKC
+ XCTRLB_CKENB VDD pch l=0.06U
+ w=0.42U
M5127 VDD CLKB XCTRLB_XCKENB0_CKC
+ VDD pch l=0.06U
+ w=0.42U
M5128 VDD XCTRLB_XCKENB0_CKC
+ XCTRLB_XCKENB0_CKT VDD pch l=0.06U
+ w=0.42U
M5129 XCTRLB_CKENB XCTRLB_XCKENB0_CEX
+ XCTRLB_XCKENB0_Z1 VSS nch l=0.06U
+ w=1.6U
M5130 VDD XCTRLB_CKPC B_CKD VDD pch
+ l=0.06U
+	 w=3.75U
M5131 XCTRLB_XCKENB0_CKT
+ XCTRLB_XCKENB0_CKC VSS VSS nch
+ l=0.06U
+ w=0.41U
M5132 VSS XCTRLB_XCKENB0_CKC
+ XCTRLB_XCKENB0_Z1 VSS nch l=0.06U
+ w=1.6U
M5133 VDD XCTRLB_XCKENB0_Z5
+ XCTRLB_XCKENB0_Z2 VDD pch l=0.06U
+ w=0.42U
M5134 VDD XCTRLB_CKENB
+ XCTRLB_XCKENB0_Z5 VDD pch l=0.06U
+ w=0.42U
M5135 VDD CLKB XCTRLB_XCKENB0_CKC
+ VDD pch l=0.06U
+ w=0.42U
M5136 VDD XCTRLB_XCKENB0_CKC
+ XCTRLB_XCKENB0_CKT VDD pch l=0.06U
+ w=0.42U
M5137 XCTRLB_XCKENB0_CKC CLKB VSS
+ VSS nch l=0.06U
+	 w=0.84U
M5138 VDD XCTRLB_CKPC B_CKD VDD pch
+ l=0.06U
+	 w=3.75U
M5139 VDD XCTRLB_XCKD0_Z1 B_CKD VDD pch
+ l=0.06U
+ w=3U
M5140 VDD XCTRLB_XCKG_RS XCTRLB_XCKG_Z18 VDD
+ pch l=0.06U
+ w=1.28U
M5141 VDD XCTRLB_CKP XCTRLB_XCKD0_Z1 VDD
+ pch l=0.08U
+ w=1U
M5142 VDD XCTRLB_RSP XCTRLB_RSN
+ VDD pch l=0.06U
+	 w=3.25U
M5143 VDD XCTRLB_RSP XCTRLB_RSN VDD
+ pch l=0.06U
+ w=3.25U
M5144 VDD XCTRLB_XCKG_Z18 XCTRLB_RSP VDD
+ pch l=0.06U
+ w=3.25U
M5145 VDD XCTRLB_XCKG_Z18 XCTRLB_RSP
+ VDD pch l=0.06U
+	 w=3.25U
M5146 XCTRLB_RSTCK B_DBL XCTRLB_XXDEL_XI15_NET3
+ VDD pch l=0.06U
+ w=1.1U
M5147 XCTRLB_RSTCK B_DBL XCTRLB_XXDEL_XI15_NET3
+ VDD pch l=0.06U
+ w=1.1U
M5148 XCTRLB_XXDEL_XI15_NET3 XCTRLB_XXDEL_Z2 VDD
+ VDD pch l=0.06U
+	 w=1.1U
M5149 XCTRLB_XXDEL_XI15_NET3 XCTRLB_XXDEL_Z2 VDD
+ VDD pch l=0.06U
+	 w=1.1U
M5150 VDD XCTRLB_CKP XCTRLB_XXDEL_Z2 VDD
+ pch l=0.06U
+ w=0.41U
M5151 XCTRLB_XCKD0_XI3_NET9 XCTRLB_CKPC B_CKD
+ VSS nch l=0.06U
+ w=2.5U
M5152 B_CKD XCTRLB_CKPC XCTRLB_XCKD0_XI3_NET9
+ VSS nch l=0.06U
+	 w=2.5U
M5153 B_CKD XCTRLB_CKPC XCTRLB_XCKD0_XI3_NET9
+ VSS nch l=0.06U
+	 w=2.5U
M5154 XCTRLB_XCKD0_XI3_NET9 XCTRLB_CKPC B_CKD
+ VSS nch l=0.06U
+ w=2.5U
M5155 VSS XCTRLB_XCKD0_Z1 XCTRLB_XCKD0_XI3_NET9
+ VSS nch l=0.06U
+	 w=2.5U
M5156 XCTRLB_XCKD0_XI3_NET9 XCTRLB_XCKD0_Z1 VSS
+ VSS nch l=0.06U
+	 w=2.5U
M5157 VSS XCTRLB_XCKD0_Z1 XCTRLB_XCKD0_XI3_NET9
+ VSS nch l=0.06U
+	 w=2.5U
M5158 XCTRLB_XCKD0_XI3_NET9 XCTRLB_XCKD0_Z1 VSS
+ VSS nch l=0.06U
+	 w=2.5U
M5159 XCTRLB_XCKD0_XI3_NET9 XCTRLB_XCKD0_Z1 VSS
+ VSS nch l=0.06U
+ w=2.5U
M5160 XCTRLB_XCKD0_Z1 XCTRLB_CKP VSS VSS
+ nch l=0.06U
+ w=1U
M5161 XCTRLB_CKC XCTRLB_CKP VSS VSS
+ nch l=0.06U
+ w=2.5U
M5162 VSS VR_0 XCTRLB_XXDEL_XI58_NET9 VSS
+ nch l=0.06U
+ w=0.41U
M5163 VSS VR_1 XCTRLB_XXDEL_XI56_NET9 VSS
+ nch l=0.06U
+ w=0.41U
M5164 VSS VW_0 XCTRLB_XXDEL_XI30_NET9 VSS
+ nch l=0.06U
+ w=0.41U
M5165 VSS VW_1 XCTRLB_XXDEL_XI32_NET9 VSS
+ nch l=0.06U
+ w=0.41U
M5166 XCTRLB_XXDEL_XI30_NET9 B_WRT
+ XCTRLB_XXDEL_VWRT0 VSS nch l=0.06U
+ w=0.41U
M5167 XCTRLB_XXDEL_XI32_NET9 B_WRT
+ XCTRLB_XXDEL_VWRT1 VSS nch l=0.06U
+ w=0.41U
M5168 XCTRLB_XXDEL_XI58_NET9 B_RD
+ XCTRLB_XXDEL_VRD0 VSS nch l=0.06U
+ w=0.41U
M5169 XCTRLB_XXDEL_XI56_NET9 B_RD
+ XCTRLB_XXDEL_VRD1 VSS nch l=0.06U
+ w=0.41U
M5170 VDD XCTRLB_CKP XCTRLB_CKC VDD
+ pch l=0.06U
+ w=1.25U
M5171 VDD XCTRLB_CKP XCTRLB_CKC VDD
+ pch l=0.06U
+ w=1.25U
M5172 VDD XCTRLB_RSTCK XCTRLB_XXDEL_Z3 VDD
+ pch l=0.06U
+ w=0.65U
M5173 VDD XCTRLB_RSTCK XCTRLB_XXDEL_Z3 VDD
+ pch l=0.06U
+ w=0.65U
M5174 XCTRLB_XXDEL_Z3 XCTRLB_XXDEL_VRD0 B_DBL
+ VDD pch l=0.06U
+	 w=0.18U
M5175 XCTRLB_XXDEL_Z3 XCTRLB_XXDEL_VWRT1 B_DBL
+ VDD pch l=0.06U
+ w=0.18U
M5176 XCTRLB_XXDEL_Z3 XCTRLB_XXDEL_VWRT1
+ B_DBL VDD pch l=0.06U
+ w=0.18U
M5177 VDD VR_0 XCTRLB_XXDEL_VRD0 VDD
+ pch l=0.06U
+ w=0.41U
M5178 VDD VR_1 XCTRLB_XXDEL_VRD1 VDD
+ pch l=0.06U
+ w=0.41U
M5179 VDD VW_0 XCTRLB_XXDEL_VWRT0 VDD
+ pch l=0.06U
+ w=0.41U
M5180 VDD VW_1 XCTRLB_XXDEL_VWRT1 VDD
+ pch l=0.06U
+ w=0.41U
M5181 VDD B_WRT XCTRLB_XXDEL_VWRT0 VDD
+ pch l=0.06U
+ w=0.41U
M5182 VDD B_WRT XCTRLB_XXDEL_VWRT1 VDD
+ pch l=0.06U
+ w=0.41U
M5183 XCTRLB_XXDEL_Z3 XCTRLB_XXDEL_VWRT0 B_DBL
+ VDD pch l=0.06U
+	 w=0.18U
M5184 VDD B_RD XCTRLB_XXDEL_VRD1 VDD
+ pch l=0.06U
+ w=0.41U
M5185 VDD B_RD XCTRLB_XXDEL_VRD0 VDD
+ pch l=0.06U
+ w=0.41U
M5186 XCTRLB_XXDEL_Z3 XCTRLB_XXDEL_VRD1 B_DBL
+ VDD pch l=0.06U
+ w=0.18U
M5187 XCTRLB_XXDEL_Z3 XCTRLB_XXDEL_VRD1
+ B_DBL VDD pch l=0.06U
+ w=0.18U
M5188 XCTRLB_RSTCK B_DBL VSS VSS nch
+ l=0.06U
+ w=1.1U
M5189 XCTRLB_RSTCK B_DBL VSS VSS nch
+ l=0.06U
+ w=1.1U
M5190 XCTRLB_RSTCK XCTRLB_XXDEL_Z2 VSS VSS
+ nch l=0.06U
+ w=0.55U
M5191 XCTRLB_RSTCK XCTRLB_XXDEL_Z2 VSS VSS
+ nch l=0.06U
+ w=0.55U
M5192 XCTRLB_XXDEL_Z2 XCTRLB_CKP VSS VSS
+ nch l=0.06U
+ w=0.21U
M5193 VDD XCTRLB_RSP XCTRLB_XDEC1DWR_0_Z1
+ VDD pch l=0.06U
+ w=0.75U
M5194 VDD XCTRLB_XDEC1DWR_0_Z1 B_WRT
+ VDD pch_hvt l=0.06U
+ w=5U
M5195 VDD XCTRLB_RSP
+ XCTRLB_XDEC1DWR_0_Z1 VDD pch l=0.06U
+ w=0.75U
M5196 VDD XCTRLB_XDEC1DWR_0_Z1 B_WRT
+ VDD pch_hvt l=0.06U
+ w=5U
M5197 XCTRLB_XDEC1DWR_0_Z1 XCTRLB_CKP
+ XCTRLB_XDEC1DWR_0_XND0_NET9 VSS nch
+ l=0.06U
+ w=2U
M5198 XCTRLB_XDEC1DWR_1_Z1 XCTRLB_CKP
+ XCTRLB_XDEC1DWR_1_XND0_NET9 VSS nch
+ l=0.06U
+ w=2U
M5199 VDD XCTRLB_CKP
+ XCTRLB_XDEC1DWR_1_Z1 VDD pch l=0.06U
+ w=0.21U
M5200 VDD XCTRLB_RSP
+ XCTRLB_XDEC1DWR_1_Z1 VDD pch l=0.06U
+ w=0.75U
M5201 VDD XCTRLB_XDEC1DWR_1_Z1 B_RD
+ VDD pch_hvt l=0.06U
+ w=5U
M5202 VDD XCTRLB_RWT
+ XCTRLB_XDEC1DWR_1_Z1 VDD pch l=0.06U
+ w=0.21U
M5203 VDD XCTRLB_RSP XCTRLB_XDEC1DWR_1_Z1
+ VDD pch l=0.06U
+ w=0.75U
M5204 VDD XCTRLB_XDEC1DWR_1_Z1 B_RD
+ VDD pch_hvt l=0.06U
+ w=5U
M5205 XCTRLB_XDEC1DWR_1_XND0_NET9
+ XCTRLB_RWT VSS VSS nch l=0.06U
+ w=2U
M5206 XCTRLB_XDEC1DWR_0_XND0_NET9
+ XCTRLB_RWC VSS VSS nch l=0.06U
+ w=2U
M5207 VDD XCTRLB_RWC
+ XCTRLB_XDEC1DWR_0_Z1 VDD pch l=0.06U
+ w=0.21U
M5208 VDD XCTRLB_CKP
+ XCTRLB_XDEC1DWR_0_Z1 VDD pch l=0.06U
+ w=0.21U
M5209 XCTRLB_XWENB0_0_Z4 XCTRLB_RWC VSS
+ VSS nch l=0.06U
+ w=2U
M5210 XCTRLB_XWENB0_1_Z4 XCTRLB_RWC VSS
+ VSS nch l=0.06U
+ w=2U
M5211 VDD XCTRLB_RWC XCTRLB_XWENB0_0_Z1
+ VDD pch l=0.06U
+ w=0.21U
M5212 VDD XCTRLB_RWC XCTRLB_XWENB0_1_Z1
+ VDD pch l=0.06U
+ w=0.21U
M5213 VDD XCTRLB_RSP XCTRLB_XWENB0_0_Z1
+ VDD pch l=0.06U
+ w=0.75U
M5214 VDD XCTRLB_XWENB0_0_Z1
+ B_WENB_0 VDD pch_hvt l=0.06U
+ w=5U
M5215 XCTRLB_XWENB0_0_Z3 XCTRLB_AC_4
+ XCTRLB_XWENB0_0_Z4 VSS nch l=0.06U
+ w=2U
M5216 XCTRLB_XWENB0_1_Z3 XCTRLB_AC_4
+ XCTRLB_XWENB0_1_Z4 VSS nch l=0.06U
+ w=2U
M5217 VDD XCTRLB_AC_4 XCTRLB_XWENB0_0_Z1
+ VDD pch l=0.06U
+ w=0.21U
M5218 VDD XCTRLB_AC_4 XCTRLB_XWENB0_1_Z1
+ VDD pch l=0.06U
+	 w=0.21U
M5219 VDD XCTRLB_RSP XCTRLB_XWENB0_0_Z1
+ VDD pch l=0.06U
+ w=0.75U
M5220 VDD XCTRLB_XWENB0_0_Z1
+ B_WENB_0 VDD pch_hvt l=0.06U
+ w=5U
M5221 XCTRLB_XWENB0_0_Z3 XCTRLB_AC_3
+ XCTRLB_XWENB0_0_Z2 VSS nch l=0.06U
+ w=2U
M5222 XCTRLB_XWENB0_1_Z3 XCTRLB_AT_3
+ XCTRLB_XWENB0_1_Z2 VSS nch l=0.06U
+ w=2U
M5223 VDD XCTRLB_AC_3 XCTRLB_XWENB0_0_Z1
+ VDD pch l=0.06U
+ w=0.21U
M5224 VDD XCTRLB_AT_3 XCTRLB_XWENB0_1_Z1
+ VDD pch l=0.06U
+ w=0.21U
M5225 VDD XCTRLB_RSP XCTRLB_XWENB0_1_Z1
+ VDD pch l=0.06U
+ w=0.75U
M5226 VDD XCTRLB_XWENB0_1_Z1
+ B_WENB_1 VDD pch_hvt l=0.06U
+ w=5U
M5227 XCTRLB_XWENB0_0_Z2 XCTRLB_CKP
+ XCTRLB_XWENB0_0_Z1 VSS nch l=0.06U
+ w=2U
M5228 XCTRLB_XWENB0_1_Z2 XCTRLB_CKP
+ XCTRLB_XWENB0_1_Z1 VSS nch l=0.06U
+ w=2U
M5229 VDD XCTRLB_CKP XCTRLB_XWENB0_0_Z1
+ VDD pch l=0.06U
+ w=0.21U
M5230 VDD XCTRLB_CKP XCTRLB_XWENB0_1_Z1
+ VDD pch l=0.06U
+ w=0.21U
M5231 VDD XCTRLB_RSP XCTRLB_XWENB0_1_Z1
+ VDD pch l=0.06U
+ w=0.75U
M5232 VDD XCTRLB_XWENB0_1_Z1
+ B_WENB_1 VDD pch_hvt l=0.06U
+ w=5U
M5233 VDD XCTRLB_CKP XCTRLB_XWENB0_2_Z1
+ VDD pch l=0.06U
+ w=0.21U
M5234 VDD XCTRLB_CKP XCTRLB_XWENB0_3_Z1
+ VDD pch l=0.06U
+ w=0.21U
M5235 VDD XCTRLB_RSP XCTRLB_XWENB0_3_Z1
+ VDD pch l=0.06U
+ w=0.75U
M5236 VDD XCTRLB_XWENB0_3_Z1
+ B_WENB_3 VDD pch_hvt l=0.06U
+ w=5U
M5237 XCTRLB_XWENB0_2_Z1 XCTRLB_CKP
+ XCTRLB_XWENB0_2_Z2 VSS nch l=0.06U
+ w=2U
M5238 XCTRLB_XWENB0_3_Z1 XCTRLB_CKP
+ XCTRLB_XWENB0_3_Z2 VSS nch l=0.06U
+ w=2U
M5239 VDD XCTRLB_AC_3 XCTRLB_XWENB0_2_Z1
+ VDD pch l=0.06U
+ w=0.21U
M5240 VDD XCTRLB_AT_3 XCTRLB_XWENB0_3_Z1
+ VDD pch l=0.06U
+ w=0.21U
M5241 VDD XCTRLB_RSP XCTRLB_XWENB0_3_Z1
+ VDD pch l=0.06U
+ w=0.75U
M5242 VDD XCTRLB_XWENB0_3_Z1
+ B_WENB_3 VDD pch_hvt l=0.06U
+ w=5U
M5243 XCTRLB_XWENB0_2_Z3 XCTRLB_AC_3
+ XCTRLB_XWENB0_2_Z2 VSS nch l=0.06U
+ w=2U
M5244 XCTRLB_XWENB0_3_Z3 XCTRLB_AT_3
+ XCTRLB_XWENB0_3_Z2 VSS nch l=0.06U
+ w=2U
M5245 XCTRLB_XWENB0_2_Z3 XCTRLB_AT_4
+ XCTRLB_XWENB0_2_Z4 VSS nch l=0.06U
+ w=2U
M5246 XCTRLB_XWENB0_3_Z3 XCTRLB_AT_4
+ XCTRLB_XWENB0_3_Z4 VSS nch l=0.06U
+ w=2U
M5247 VDD XCTRLB_AT_4 XCTRLB_XWENB0_2_Z1
+ VDD pch l=0.06U
+ w=0.21U
M5248 VDD XCTRLB_AT_4 XCTRLB_XWENB0_3_Z1
+ VDD pch l=0.06U
+	 w=0.21U
M5249 VDD XCTRLB_RSP XCTRLB_XWENB0_2_Z1
+ VDD pch l=0.06U
+ w=0.75U
M5250 VDD XCTRLB_XWENB0_2_Z1
+ B_WENB_2 VDD pch_hvt l=0.06U
+ w=5U
M5251 VDD XCTRLB_RWC XCTRLB_XWENB0_2_Z1
+ VDD pch l=0.06U
+ w=0.21U
M5252 VDD XCTRLB_RWC XCTRLB_XWENB0_3_Z1
+ VDD pch l=0.06U
+ w=0.21U
M5253 VDD XCTRLB_RSP XCTRLB_XWENB0_2_Z1
+ VDD pch l=0.06U
+ w=0.75U
M5254 VDD XCTRLB_XWENB0_2_Z1
+ B_WENB_2 VDD pch_hvt l=0.06U
+ w=5U
M5255 XCTRLB_XWENB0_2_Z4 XCTRLB_RWC VSS
+ VSS nch l=0.06U
+ w=2U
M5256 XCTRLB_XWENB0_3_Z4 XCTRLB_RWC VSS
+ VSS nch l=0.06U
+ w=2U
M5257 VDD XCTRLB_XCKG_Z12 XCTRLB_XCKG_Z13 VDD
+ pch l=0.06U
+	 w=0.41U
M5258 VSS XCTRLB_RWT XCTRLB_XGCDEC0_0_Z4
+ VSS nch l=0.06U
+ w=2U
M5259 VSS XCTRLB_RWT XCTRLB_XGCDEC0_1_Z4
+ VSS nch l=0.06U
+ w=2U
M5260 VDD BISTT XCTRLB_XCKG_Z10 VDD pch
+ l=0.06U
+	 w=0.41U
M5261 VDD XCTRLB_RWT XCTRLB_XGCDEC0_0_Z1
+ VDD pch l=0.06U
+ w=0.21U
M5262 VDD XCTRLB_RWT XCTRLB_XGCDEC0_1_Z1
+ VDD pch l=0.06U
+ w=0.21U
M5263 VDD XCTRLB_RSP XCTRLB_XGCDEC0_0_Z1
+ VDD pch l=0.06U
+ w=0.75U
M5264 VDD XCTRLB_XGCDEC0_0_Z1
+ B_GCDEC_0 VDD pch_hvt l=0.06U
+ w=5U
M5265 XCTRLB_XGCDEC0_0_Z3 XCTRLB_AC_4
+ XCTRLB_XGCDEC0_0_Z4 VSS nch l=0.06U
+ w=2U
M5266 XCTRLB_XGCDEC0_1_Z3 XCTRLB_AC_4
+ XCTRLB_XGCDEC0_1_Z4 VSS nch l=0.06U
+ w=2U
M5267 XCTRLB_XCKG_Z12 CLKB XCTRLB_XCKG_Z10 VDD
+ pch l=0.06U
+ w=0.41U
M5268 VDD XCTRLB_AC_4 XCTRLB_XGCDEC0_0_Z1
+ VDD pch l=0.06U
+	 w=0.21U
M5269 VDD XCTRLB_AC_4 XCTRLB_XGCDEC0_1_Z1
+ VDD pch l=0.06U
+ w=0.21U
M5270 VDD XCTRLB_RSP XCTRLB_XGCDEC0_0_Z1
+ VDD pch l=0.06U
+ w=0.75U
M5271 VDD XCTRLB_XGCDEC0_0_Z1
+ B_GCDEC_0 VDD pch_hvt l=0.06U
+ w=5U
M5272 XCTRLB_XGCDEC0_0_Z3 XCTRLB_AC_3
+ XCTRLB_XGCDEC0_0_Z2 VSS nch l=0.06U
+ w=2U
M5273 XCTRLB_XGCDEC0_1_Z3 XCTRLB_AT_3
+ XCTRLB_XGCDEC0_1_Z2 VSS nch l=0.06U
+ w=2U
M5274 XCTRLB_XCKG_Z11 CLKM XCTRLB_XCKG_Z12 VDD
+ pch l=0.06U
+	 w=0.41U
M5275 VDD XCTRLB_AC_3 XCTRLB_XGCDEC0_0_Z1
+ VDD pch l=0.06U
+ w=0.21U
M5276 VDD XCTRLB_AT_3 XCTRLB_XGCDEC0_1_Z1
+ VDD pch l=0.06U
+ w=0.21U
M5277 VDD XCTRLB_RSP XCTRLB_XGCDEC0_1_Z1
+ VDD pch l=0.06U
+ w=0.75U
M5278 VDD XCTRLB_XGCDEC0_1_Z1
+ B_GCDEC_1 VDD pch_hvt l=0.06U
+ w=5U
M5279 XCTRLB_XGCDEC0_0_Z2 XCTRLB_CKP
+ XCTRLB_XGCDEC0_0_Z1 VSS nch l=0.06U
+ w=2U
M5280 XCTRLB_XGCDEC0_1_Z2 XCTRLB_CKP
+ XCTRLB_XGCDEC0_1_Z1 VSS nch l=0.06U
+ w=2U
M5281 VDD BISTC XCTRLB_XCKG_Z11 VDD pch
+ l=0.06U
+	 w=0.41U
M5282 VDD XCTRLB_CKP XCTRLB_XGCDEC0_0_Z1
+ VDD pch l=0.06U
+ w=0.21U
M5283 VDD XCTRLB_CKP XCTRLB_XGCDEC0_1_Z1
+ VDD pch l=0.06U
+ w=0.21U
M5284 VDD XCTRLB_RSP XCTRLB_XGCDEC0_1_Z1
+ VDD pch l=0.06U
+ w=0.75U
M5285 VDD XCTRLB_XGCDEC0_1_Z1
+ B_GCDEC_1 VDD pch_hvt l=0.06U
+ w=5U
M5286 XCTRLB_XCKG_Z6 XCTRLB_CKENB VDD VDD
+ pch l=0.06U
+	 w=0.41U
M5287 VDD XCTRLB_CKP XCTRLB_XGCDEC0_2_Z1
+ VDD pch l=0.06U
+ w=0.21U
M5288 VDD XCTRLB_CKP XCTRLB_XGCDEC0_3_Z1
+ VDD pch l=0.06U
+ w=0.21U
M5289 VDD XCTRLB_RSP XCTRLB_XGCDEC0_3_Z1
+ VDD pch l=0.06U
+ w=0.75U
M5290 VDD XCTRLB_XGCDEC0_3_Z1
+ B_GCDEC_3 VDD pch_hvt l=0.06U
+ w=5U
M5291 XCTRLB_XGCDEC0_2_Z2 XCTRLB_CKP
+ XCTRLB_XGCDEC0_2_Z1 VSS nch l=0.06U
+ w=2U
M5292 XCTRLB_XGCDEC0_3_Z2 XCTRLB_CKP
+ XCTRLB_XGCDEC0_3_Z1 VSS nch l=0.06U
+ w=2U
M5293 XCTRLB_CKPC XCTRLB_CKMENB XCTRLB_XCKG_Z6
+ VDD pch l=0.06U
+ w=0.41U
M5294 VDD XCTRLB_AC_3 XCTRLB_XGCDEC0_2_Z1
+ VDD pch l=0.06U
+ w=0.21U
M5295 VDD XCTRLB_AT_3 XCTRLB_XGCDEC0_3_Z1
+ VDD pch l=0.06U
+ w=0.21U
M5296 VDD XCTRLB_RSP XCTRLB_XGCDEC0_3_Z1
+ VDD pch l=0.06U
+ w=0.75U
M5297 VDD XCTRLB_XGCDEC0_3_Z1
+ B_GCDEC_3 VDD pch_hvt l=0.06U
+ w=5U
M5298 XCTRLB_XGCDEC0_2_Z3 XCTRLB_AC_3
+ XCTRLB_XGCDEC0_2_Z2 VSS nch l=0.06U
+ w=2U
M5299 XCTRLB_XGCDEC0_3_Z3 XCTRLB_AT_3
+ XCTRLB_XGCDEC0_3_Z2 VSS nch l=0.06U
+ w=2U
M5300 XCTRLB_XCKG_Z7 XCTRLB_CKENB XCTRLB_CKPC
+ VDD pch l=0.06U
+ w=0.41U
M5301 VDD XCTRLB_XCKG_RS XCTRLB_XCKG_Z19 VDD
+ pch l=0.06U
+ w=1.6U
M5302 VDD XCTRLB_XCKG_Z19 XCTRLB_CKP VDD
+ pch l=0.06U
+ w=1.2U
M5303 VDD XCTRLB_XCKG_Z19 XCTRLB_CKP VDD
+ pch l=0.06U
+ w=1.2U
M5304 VDD XCTRLB_CKP XCTRLB_XCKG_Z19 VDD
+ pch l=0.06U
+ w=1.6U
M5305 VDD XCTRLB_CKPC XCTRLB_CKP VDD
+ pch l=0.06U
+ w=3U
M5306 VDD XCTRLB_CKPC XCTRLB_CKP VDD
+ pch l=0.06U
+ w=3U
M5307 VDD XCTRLB_CKPC XCTRLB_CKP VDD
+ pch l=0.06U
+ w=3U
M5308 VDD XCTRLB_CKPC XCTRLB_CKP VDD
+ pch l=0.06U
+ w=3U
M5309 VDD XCTRLB_CKPC XCTRLB_CKP VDD
+ pch l=0.06U
+ w=3U
M5310 VDD XCTRLB_XCKG_RS XCTRLB_CKPC VDD
+ pch l=0.06U
+ w=3U
M5311 VDD XCTRLB_XCKG_RS XCTRLB_CKPC VDD
+ pch l=0.06U
+ w=3U
M5312 VDD BISTT XCTRLB_XCKG_Z4 VDD pch
+ l=0.06U
+ w=2.86U
M5313 XCTRLB_XCKG_Z4 BISTT VDD VDD pch
+ l=0.06U
+ w=2.86U
M5314 VDD XCTRLB_CKPC XCTRLB_CKP VDD
+ pch l=0.06U
+ w=3U
M5315 VDD XCTRLB_CKPC XCTRLB_CKP VDD
+ pch l=0.06U
+ w=3U
M5316 VDD XCTRLB_CKPC XCTRLB_CKP VDD
+ pch l=0.06U
+ w=3U
M5317 VDD BISTT XCTRLB_XCKG_Z4 VDD pch
+ l=0.06U
+ w=2.86U
M5318 XCTRLB_XCKG_Z4 CLKB XCTRLB_CKPC VDD
+ pch l=0.06U
+ w=2.86U
M5319 XCTRLB_CKPC CLKB XCTRLB_XCKG_Z4 VDD
+ pch l=0.06U
+ w=2.86U
M5320 XCTRLB_XCKG_Z4 CLKB XCTRLB_CKPC VDD
+ pch l=0.06U
+ w=2.86U
M5321 XCTRLB_XCKG_Z5 BISTC VDD VDD pch
+ l=0.06U
+ w=2.86U
M5322 XCTRLB_CKPC CLKM XCTRLB_XCKG_Z5 VDD
+ pch l=0.06U
+ w=2.86U
M5323 XCTRLB_XCKG_Z5 CLKM XCTRLB_CKPC VDD
+ pch l=0.06U
+ w=2.86U
M5324 XCTRLB_CKPC CLKM XCTRLB_XCKG_Z5 VDD
+ pch l=0.06U
+ w=2.86U
M5325 XCTRLB_XCKG_Z5 BISTC VDD VDD pch
+ l=0.06U
+ w=2.86U
M5326 VDD BISTC XCTRLB_XCKG_Z5 VDD pch
+ l=0.06U
+ w=2.86U
M5327 XCTRLB_XGCDEC0_2_Z3 XCTRLB_AT_4
+ XCTRLB_XGCDEC0_2_Z4 VSS nch l=0.06U
+ w=2U
M5328 XCTRLB_XGCDEC0_3_Z3 XCTRLB_AT_4
+ XCTRLB_XGCDEC0_3_Z4 VSS nch l=0.06U
+ w=2U
M5329 VDD XCTRLB_AT_4 XCTRLB_XGCDEC0_2_Z1
+ VDD pch l=0.06U
+ w=0.21U
M5330 VDD XCTRLB_AT_4 XCTRLB_XGCDEC0_3_Z1
+ VDD pch l=0.06U
+ w=0.21U
M5331 VDD XCTRLB_RSP XCTRLB_XGCDEC0_2_Z1
+ VDD pch l=0.06U
+ w=0.75U
M5332 VDD XCTRLB_XGCDEC0_2_Z1
+ B_GCDEC_2 VDD pch_hvt l=0.06U
+ w=5U
M5333 VDD XCTRLB_CKMENB XCTRLB_XCKG_Z7 VDD
+ pch l=0.06U
+ w=0.41U
M5334 VDD XCTRLB_RWT XCTRLB_XGCDEC0_2_Z1
+ VDD pch l=0.06U
+ w=0.21U
M5335 VDD XCTRLB_RWT XCTRLB_XGCDEC0_3_Z1
+ VDD pch l=0.06U
+ w=0.21U
M5336 VDD XCTRLB_RSP XCTRLB_XGCDEC0_2_Z1
+ VDD pch l=0.06U
+ w=0.75U
M5337 VDD XCTRLB_XGCDEC0_2_Z1
+ B_GCDEC_2 VDD pch_hvt l=0.06U
+ w=5U
M5338 XCTRLB_XGCDEC0_2_Z4 XCTRLB_RWT VSS
+ VSS nch l=0.06U
+ w=2U
M5339 XCTRLB_XGCDEC0_3_Z4 XCTRLB_RWT VSS
+ VSS nch l=0.06U
+ w=2U
M5340 VDD XCTRLB_XCKG_Z17 XCTRLB_XCKG_RS VDD
+ pch l=0.06U
+ w=0.9U
M5341 VDD XCTRLB_XCKG_Z17 XCTRLB_XCKG_RS VDD
+ pch l=0.06U
+ w=0.9U
M5342 VDD XCTRLB_XCKG_Z17 XCTRLB_XCKG_RS VDD
+ pch l=0.06U
+ w=0.9U
M5343 VDD XCTRLB_XCKG_Z16 XCTRLB_XCKG_Z17 VDD
+ pch l=0.06U
+	 w=0.64U
M5344 VDD XCTRLB_XCKG_Z17 XCTRLB_XCKG_Z14 VDD
+ pch l=0.06U
+ w=0.41U
M5345 VDD XCTRLB_XCKG_Z14 XCTRLB_XCKG_Z17 VDD
+ pch l=0.06U
+	 w=0.64U
M5346 VDD XCTRLB_XCKG_Z13 XCTRLB_XCKG_Z14 VDD
+ pch l=0.06U
+ w=0.41U
M5347 VDD XCTRLB_XCKG_Z15 XCTRLB_XCKG_Z16 VDD
+ pch l=0.06U
+ w=0.41U
M5348 VDD XCTRLB_RSTCK XCTRLB_XCKG_Z16 VDD
+ pch l=0.06U
+ w=0.41U
M5349 VDD XCTRLB_XCKG_Z13 XCTRLB_XCKG_Z15 VDD
+ pch l=0.06U
+ w=0.41U
M5350 VDD TM XCTRLB_XCKG_Z15 VDD pch
+ l=0.06U
+ w=0.41U
M5351 XCTRLB_XCKG_XND3_NET9 XCTRLB_XCKG_Z19 VSS
+ VSS nch l=0.06U
+ w=2.66U
M5352 VSS XCTRLB_XCKG_Z19 XCTRLB_XCKG_XND3_NET9
+ VSS nch l=0.06U
+ w=2.66U
M5353 VSS XCTRLB_XCKG_Z19 XCTRLB_XCKG_XND3_NET9
+ VSS nch l=0.06U
+ w=2.66U
M5354 XCTRLB_XCKG_XND3_NET9 XCTRLB_CKPC
+ XCTRLB_CKP VSS nch l=0.06U
+ w=2.66U
M5355 XCTRLB_CKP XCTRLB_CKPC
+ XCTRLB_XCKG_XND3_NET9 VSS nch l=0.06U
+ w=2.66U
M5356 XCTRLB_XCKG_XND3_NET9 XCTRLB_CKPC
+ XCTRLB_CKP VSS nch l=0.06U
+ w=2.66U
M5357 VSS XCTRLB_XCKG_Z18 XCTRLB_CKP VSS
+ nch l=0.06U
+	 w=2.66U
M5358 VSS XCTRLB_XCKG_Z18 XCTRLB_CKP VSS
+ nch l=0.06U
+ w=2.66U
M5359 VSS XCTRLB_XCKG_Z18 XCTRLB_CKP VSS
+ nch l=0.06U
+	 w=2.66U
M5360 XCTRLB_XCKG_Z1 XCTRLB_XCKG_RS VSS VSS
+ nch l=0.06U
+	 w=2.86U
M5361 XCTRLB_XCKG_Z1 XCTRLB_XCKG_RS VSS VSS
+ nch l=0.06U
+	 w=2.86U
M5362 XCTRLB_XCKG_Z1 XCTRLB_XCKG_RS VSS VSS
+ nch l=0.06U
+ w=2.86U
M5363 XCTRLB_XCKG_Z1 XCTRLB_CKENB XCTRLB_XCKG_Z2
+ VSS nch l=0.06U
+ w=2.86U
M5364 XCTRLB_XCKG_Z2 XCTRLB_CKENB XCTRLB_XCKG_Z1
+ VSS nch l=0.06U
+ w=2.86U
M5365 XCTRLB_XCKG_Z1 XCTRLB_CKENB XCTRLB_XCKG_Z2
+ VSS nch l=0.06U
+ w=2.86U
M5366 XCTRLB_XCKG_Z2 CLKB XCTRLB_CKPC VSS
+ nch l=0.06U
+	 w=2.86U
M5367 XCTRLB_XCKG_Z2 CLKB XCTRLB_CKPC VSS
+ nch l=0.06U
+	 w=2.86U
M5368 XCTRLB_CKPC CLKB XCTRLB_XCKG_Z2 VSS
+ nch l=0.06U
+	 w=2.86U
M5369 XCTRLB_XCKG_Z3 XCTRLB_CKMENB XCTRLB_XCKG_Z1
+ VSS nch l=0.06U
+ w=2.86U
M5370 XCTRLB_CKPC CLKM XCTRLB_XCKG_Z3 VSS
+ nch l=0.06U
+	 w=2.86U
M5371 XCTRLB_CKPC CLKM XCTRLB_XCKG_Z3 VSS
+ nch l=0.06U
+	 w=2.86U
M5372 XCTRLB_XCKG_Z3 CLKM XCTRLB_CKPC VSS
+ nch l=0.06U
+	 w=2.86U
M5373 XCTRLB_XCKG_Z3 XCTRLB_CKMENB XCTRLB_XCKG_Z1
+ VSS nch l=0.06U
+ w=2.86U
M5374 XCTRLB_XCKG_Z1 XCTRLB_CKMENB XCTRLB_XCKG_Z3
+ VSS nch l=0.06U
+ w=2.86U
M5375 XCTRLB_XCKG_RS XCTRLB_XCKG_Z17 VSS VSS
+ nch l=0.06U
+ w=0.675U
M5376 XCTRLB_XCKG_RS XCTRLB_XCKG_Z17 VSS VSS
+ nch l=0.06U
+ w=0.675U
M5377 XCTRLB_RSN XCTRLB_RSP VSS VSS
+ nch l=0.06U
+ w=1.5U
M5378 XCTRLB_RSN XCTRLB_RSP VSS
+ VSS nch l=0.06U
+ w=1.5U
M5379 XCTRLB_RSP XCTRLB_XCKG_Z18 VSS VSS
+ nch l=0.06U
+ w=1.5U
M5380 XCTRLB_RSP XCTRLB_XCKG_Z18 VSS
+ VSS nch l=0.06U
+ w=1.5U
M5381 XCTRLB_XCKG_Z18 XCTRLB_XCKG_RS VSS VSS
+ nch l=0.06U
+ w=1.28U
M5382 XCTRLB_XCKG_XND4_NET9 XCTRLB_XCKG_RS
+ XCTRLB_XCKG_Z19 VSS nch l=0.06U
+ w=1.6U
M5383 XCTRLB_XCKG_XND4_NET9 XCTRLB_CKP VSS
+ VSS nch l=0.06U
+	 w=1.6U
M5384 VSS XCTRLB_XCKG_Z15 XCTRLB_XCKG_XI17_NET9
+ VSS nch l=0.06U
+ w=0.41U
M5385 XCTRLB_XCKG_XI17_NET9 XCTRLB_RSTCK
+ XCTRLB_XCKG_Z16 VSS nch l=0.06U
+ w=0.41U
M5386 XCTRLB_XCKG_XND1_NET9 XCTRLB_XCKG_Z16
+ XCTRLB_XCKG_Z17 VSS nch l=0.06U
+ w=0.64U
M5387 VSS XCTRLB_XCKG_Z17 XCTRLB_XCKG_XND0_NET9
+ VSS nch l=0.06U
+ w=0.41U
M5388 VSS XCTRLB_XCKG_Z14 XCTRLB_XCKG_XND1_NET9
+ VSS nch l=0.06U
+	 w=0.64U
M5389 XCTRLB_XCKG_XND0_NET9 XCTRLB_XCKG_Z13
+ XCTRLB_XCKG_Z14 VSS nch l=0.06U
+ w=0.41U
M5390 XCTRLB_XCKG_Z13 XCTRLB_XCKG_Z12 VSS VSS
+ nch l=0.06U
+ w=0.21U
M5391 XCTRLB_XCKG_Z8 BISTC VSS VSS nch
+ l=0.06U
+ w=0.41U
M5392 XCTRLB_XCKG_Z8 CLKB XCTRLB_XCKG_Z12 VSS
+ nch l=0.06U
+	 w=0.41U
M5393 XCTRLB_XCKG_Z12 CLKM XCTRLB_XCKG_Z9 VSS
+ nch l=0.06U
+ w=0.41U
M5394 XCTRLB_XCKG_XI13_NET9 XCTRLB_XCKG_Z13
+ XCTRLB_XCKG_Z15 VSS nch l=0.06U
+ w=0.41U
M5395 VSS TM XCTRLB_XCKG_XI13_NET9 VSS
+ nch l=0.06U
+ w=0.41U
M5396 XCTRLB_XCKG_Z9 BISTT VSS VSS nch
+ l=0.06U
+ w=0.41U
M5397 VSS XCTRLB_AC_2 XCTRLB_XDEC3DY_0_Z4
+ VSS nch l=0.06U
+ w=2U
M5398 VSS XCTRLB_AC_2 XCTRLB_XDEC3DY_1_Z4
+ VSS nch l=0.06U
+ w=2U
M5399 XCTRLB_XALTCH0_Z26 XCTRLB_RWC VSS
+ VSS nch l=0.06U
+	 w=0.21U
M5400 XCTRLB_XALTCH0_Z25 XCTRLB_CKP VDD
+ VDD pch l=0.06U
+	 w=0.42U
M5401 VDD WEBB XCTRLB_XALTCH0_Z21 VDD
+ pch l=0.08U
+	 w=0.42U
M5402 XCTRLB_RWT XCTRLB_RWC VSS VSS
+ nch l=0.06U
+ w=0.55U
M5403 VDD XCTRLB_RWC XCTRLB_RWT
+ VDD pch l=0.06U
+ w=1.1U
M5404 VDD XCTRLB_AC_2 XCTRLB_XDEC3DY_0_Z1
+ VDD pch l=0.06U
+ w=0.21U
M5405 VDD XCTRLB_AC_2 XCTRLB_XDEC3DY_1_Z1
+ VDD pch l=0.06U
+ w=0.21U
M5406 VDD XCTRLB_RSP XCTRLB_XDEC3DY_0_Z1
+ VDD pch l=0.06U
+ w=0.75U
M5407 VDD XCTRLB_XDEC3DY_0_Z1 B_Y_0
+ VDD pch_hvt l=0.06U
+ w=5U
M5408 XCTRLB_XDEC3DY_0_Z4 XCTRLB_AC_1
+ XCTRLB_XDEC3DY_0_Z3 VSS nch l=0.06U
+ w=2U
M5409 XCTRLB_XDEC3DY_1_Z4 XCTRLB_AC_1
+ XCTRLB_XDEC3DY_1_Z3 VSS nch l=0.06U
+ w=2U
M5410 XCTRLB_XALTCH0_Z1 XCTRLB_CKP
+ XCTRLB_XALTCH0_Z26 VSS nch l=0.06U
+ w=0.21U
M5411 XCTRLB_XALTCH0_AX BISTT
+ XCTRLB_XALTCH0_Z21 VDD pch l=0.08U
+ w=0.42U
M5412 XCTRLB_RWT XCTRLB_RWC VSS
+ VSS nch l=0.06U
+ w=0.55U
M5413 VDD XCTRLB_RWC XCTRLB_RWT VDD
+ pch l=0.06U
+ w=1.1U
M5414 VDD XCTRLB_AC_1 XCTRLB_XDEC3DY_0_Z1
+ VDD pch l=0.06U
+ w=0.21U
M5415 VDD XCTRLB_AC_1 XCTRLB_XDEC3DY_1_Z1
+ VDD pch l=0.06U
+	 w=0.21U
M5416 VDD XCTRLB_RSP XCTRLB_XDEC3DY_0_Z1
+ VDD pch l=0.06U
+ w=0.75U
M5417 VDD XCTRLB_XDEC3DY_0_Z1 B_Y_0
+ VDD pch_hvt l=0.06U
+ w=5U
M5418 XCTRLB_XALTCH0_Z25 XCTRLB_XALTCH0_AX
+ XCTRLB_XALTCH0_Z1 VDD pch l=0.08U
+ w=0.42U
M5419 XCTRLB_XDEC3DY_0_Z3 XCTRLB_AC_0
+ XCTRLB_XDEC3DY_0_Z2 VSS nch l=0.06U
+ w=2U
M5420 XCTRLB_XDEC3DY_1_Z3 XCTRLB_AT_0
+ XCTRLB_XDEC3DY_1_Z2 VSS nch l=0.06U
+ w=2U
M5421 XCTRLB_XALTCH0_Z1 XCTRLB_CKC
+ XCTRLB_XALTCH0_Z28 VDD pch l=0.06U
+ w=0.21U
M5422 XCTRLB_XALTCH0_Z27 XCTRLB_XALTCH0_AX
+ XCTRLB_XALTCH0_Z1 VSS nch l=0.08U
+ w=0.21U
M5423 XCTRLB_XALTCH0_AX BISTC
+ XCTRLB_XALTCH0_Z22 VDD pch l=0.08U
+ w=0.42U
M5424 XCTRLB_RWC XCTRLB_XALTCH0_Z1
+ VSS VSS nch l=0.06U
+ w=0.55U
M5425 VDD XCTRLB_XALTCH0_Z1
+ XCTRLB_RWC VDD pch l=0.06U
+ w=1.1U
M5426 VDD XCTRLB_AC_0 XCTRLB_XDEC3DY_0_Z1
+ VDD pch l=0.06U
+ w=0.21U
M5427 VDD XCTRLB_AT_0 XCTRLB_XDEC3DY_1_Z1
+ VDD pch l=0.06U
+	 w=0.21U
M5428 VDD XCTRLB_RSP XCTRLB_XDEC3DY_1_Z1
+ VDD pch l=0.06U
+ w=0.75U
M5429 VDD XCTRLB_XDEC3DY_1_Z1 B_Y_1
+ VDD pch_hvt l=0.06U
+ w=5U
M5430 XCTRLB_XDEC3DY_0_Z2 XCTRLB_CKP
+ XCTRLB_XDEC3DY_0_Z1 VSS nch l=0.06U
+ w=2U
M5431 XCTRLB_XDEC3DY_1_Z2 XCTRLB_CKP
+ XCTRLB_XDEC3DY_1_Z1 VSS nch l=0.06U
+ w=2U
M5432 XCTRLB_XALTCH0_Z22 WEBMB VDD VDD
+ pch l=0.08U
+	 w=0.42U
M5433 XCTRLB_RWC XCTRLB_XALTCH0_Z1
+ VSS VSS nch l=0.06U
+ w=0.55U
M5434 VDD XCTRLB_XALTCH0_Z1
+ XCTRLB_RWC VDD pch l=0.06U
+ w=1.1U
M5435 VDD XCTRLB_CKP XCTRLB_XDEC3DY_0_Z1
+ VDD pch l=0.06U
+ w=0.21U
M5436 VDD XCTRLB_CKP XCTRLB_XDEC3DY_1_Z1
+ VDD pch l=0.06U
+	 w=0.21U
M5437 VDD XCTRLB_RSP XCTRLB_XDEC3DY_1_Z1
+ VDD pch l=0.06U
+ w=0.75U
M5438 VDD XCTRLB_XDEC3DY_1_Z1 B_Y_1
+ VDD pch_hvt l=0.06U
+ w=5U
M5439 XCTRLB_XALTCH0_Z28 XCTRLB_RWC VDD
+ VDD pch l=0.06U
+ w=0.21U
M5440 XCTRLB_XALTCH0_Z27 XCTRLB_CKC VSS
+ VSS nch l=0.06U
+	 w=0.21U
M5441 XCTRLB_XALTCH_4_Z28 XCTRLB_AC_4 VDD
+ VDD pch l=0.06U
+ w=0.21U
M5442 VDD AMB_4 XCTRLB_XALTCH_4_Z22 VDD
+ pch l=0.08U
+	 w=0.42U
M5443 VSS XCTRLB_CKC XCTRLB_XALTCH_4_Z27
+ VSS nch l=0.06U
+	 w=0.21U
M5444 XCTRLB_AC_4 XCTRLB_XALTCH_4_Z1
+ VSS VSS nch l=0.06U
+ w=0.55U
M5445 VDD XCTRLB_XALTCH_4_Z1
+ XCTRLB_AC_4 VDD pch l=0.06U
+ w=1.1U
M5446 VDD XCTRLB_CKP XCTRLB_XDEC3DY_2_Z1
+ VDD pch l=0.06U
+ w=0.21U
M5447 VDD XCTRLB_CKP XCTRLB_XDEC3DY_3_Z1
+ VDD pch l=0.06U
+ w=0.21U
M5448 VDD XCTRLB_RSP XCTRLB_XDEC3DY_3_Z1
+ VDD pch l=0.06U
+ w=0.75U
M5449 VDD XCTRLB_XDEC3DY_3_Z1 B_Y_3
+ VDD pch_hvt l=0.06U
+ w=5U
M5450 XCTRLB_XDEC3DY_2_Z2 XCTRLB_CKP
+ XCTRLB_XDEC3DY_2_Z1 VSS nch l=0.06U
+ w=2U
M5451 XCTRLB_XDEC3DY_3_Z2 XCTRLB_CKP
+ XCTRLB_XDEC3DY_3_Z1 VSS nch l=0.06U
+ w=2U
M5452 XCTRLB_XALTCH_4_Z22 BISTC
+ XCTRLB_XALTCH_4_AX VDD pch l=0.08U
+ w=0.42U
M5453 XCTRLB_AC_4 XCTRLB_XALTCH_4_Z1
+ VSS VSS nch l=0.06U
+ w=0.55U
M5454 VDD XCTRLB_XALTCH_4_Z1
+ XCTRLB_AC_4 VDD pch l=0.06U
+ w=1.1U
M5455 VDD XCTRLB_AC_0 XCTRLB_XDEC3DY_2_Z1
+ VDD pch l=0.06U
+ w=0.21U
M5456 VDD XCTRLB_AT_0 XCTRLB_XDEC3DY_3_Z1
+ VDD pch l=0.06U
+ w=0.21U
M5457 VDD XCTRLB_RSP XCTRLB_XDEC3DY_3_Z1
+ VDD pch l=0.06U
+ w=0.75U
M5458 VDD XCTRLB_XDEC3DY_3_Z1 B_Y_3
+ VDD pch_hvt l=0.06U
+ w=5U
M5459 XCTRLB_XALTCH_4_Z28 XCTRLB_CKC
+ XCTRLB_XALTCH_4_Z1 VDD pch l=0.06U
+ w=0.21U
M5460 XCTRLB_XALTCH_4_Z27 XCTRLB_XALTCH_4_AX
+ XCTRLB_XALTCH_4_Z1 VSS nch l=0.08U
+ w=0.21U
M5461 XCTRLB_XDEC3DY_2_Z2 XCTRLB_AC_0
+ XCTRLB_XDEC3DY_2_Z3 VSS nch l=0.06U
+ w=2U
M5462 XCTRLB_XDEC3DY_3_Z2 XCTRLB_AT_0
+ XCTRLB_XDEC3DY_3_Z3 VSS nch l=0.06U
+ w=2U
M5463 XCTRLB_XALTCH_4_Z1 XCTRLB_CKP
+ XCTRLB_XALTCH_4_Z26 VSS nch l=0.06U
+ w=0.21U
M5464 XCTRLB_XALTCH_4_AX BISTT
+ XCTRLB_XALTCH_4_Z21 VDD pch l=0.08U
+ w=0.42U
M5465 XCTRLB_XALTCH_4_Z25 XCTRLB_XALTCH_4_AX
+ XCTRLB_XALTCH_4_Z1 VDD pch l=0.08U
+ w=0.42U
M5466 XCTRLB_XDEC3DY_2_Z3 XCTRLB_AT_1
+ XCTRLB_XDEC3DY_2_Z4 VSS nch l=0.06U
+ w=2U
M5467 XCTRLB_XDEC3DY_3_Z3 XCTRLB_AT_1
+ XCTRLB_XDEC3DY_3_Z4 VSS nch l=0.06U
+ w=2U
M5468 XCTRLB_AT_4 XCTRLB_AC_4 VSS VSS
+ nch l=0.06U
+ w=0.55U
M5469 VDD XCTRLB_AC_4 XCTRLB_AT_4
+ VDD pch l=0.06U
+ w=1.1U
M5470 VDD XCTRLB_AT_1 XCTRLB_XDEC3DY_2_Z1
+ VDD pch l=0.06U
+	 w=0.21U
M5471 VDD XCTRLB_AT_1 XCTRLB_XDEC3DY_3_Z1
+ VDD pch l=0.06U
+ w=0.21U
M5472 VDD XCTRLB_RSP XCTRLB_XDEC3DY_2_Z1
+ VDD pch l=0.06U
+ w=0.75U
M5473 VDD XCTRLB_XDEC3DY_2_Z1 B_Y_2
+ VDD pch_hvt l=0.06U
+ w=5U
M5474 XCTRLB_XALTCH_4_Z21 AB_4 VDD VDD
+ pch l=0.08U
+	 w=0.42U
M5475 XCTRLB_AT_4 XCTRLB_AC_4 VSS
+ VSS nch l=0.06U
+ w=0.55U
M5476 VDD XCTRLB_AC_4 XCTRLB_AT_4 VDD
+ pch l=0.06U
+ w=1.1U
M5477 VDD XCTRLB_AC_2 XCTRLB_XDEC3DY_2_Z1
+ VDD pch l=0.06U
+ w=0.21U
M5478 VDD XCTRLB_AC_2 XCTRLB_XDEC3DY_3_Z1
+ VDD pch l=0.06U
+ w=0.21U
M5479 VDD XCTRLB_RSP XCTRLB_XDEC3DY_2_Z1
+ VDD pch l=0.06U
+ w=0.75U
M5480 VDD XCTRLB_XDEC3DY_2_Z1 B_Y_2
+ VDD pch_hvt l=0.06U
+ w=5U
M5481 XCTRLB_XALTCH_4_Z25 XCTRLB_CKP VDD
+ VDD pch l=0.06U
+ w=0.42U
M5482 XCTRLB_XDEC3DY_2_Z4 XCTRLB_AC_2 VSS
+ VSS nch l=0.06U
+ w=2U
M5483 XCTRLB_XDEC3DY_3_Z4 XCTRLB_AC_2 VSS
+ VSS nch l=0.06U
+ w=2U
M5484 XCTRLB_XALTCH_4_Z26 XCTRLB_AC_4 VSS
+ VSS nch l=0.06U
+	 w=0.21U
M5485 XCTRLB_XDEC3DY_4_Z4 XCTRLB_AT_2 VSS
+ VSS nch l=0.06U
+ w=2U
M5486 XCTRLB_XDEC3DY_5_Z4 XCTRLB_AT_2 VSS
+ VSS nch l=0.06U
+ w=2U
M5487 XCTRLB_XALTCH_3_Z26 XCTRLB_AC_3 VSS
+ VSS nch l=0.06U
+	 w=0.21U
M5488 XCTRLB_XALTCH_3_Z25 XCTRLB_CKP VDD
+ VDD pch l=0.06U
+	 w=0.42U
M5489 XCTRLB_XALTCH_3_Z21 AB_3 VDD VDD
+ pch l=0.08U
+	 w=0.42U
M5490 XCTRLB_AT_3 XCTRLB_AC_3 VSS VSS
+ nch l=0.06U
+ w=0.55U
M5491 VDD XCTRLB_AC_3 XCTRLB_AT_3
+ VDD pch l=0.06U
+ w=1.1U
M5492 VDD XCTRLB_AT_2 XCTRLB_XDEC3DY_4_Z1
+ VDD pch l=0.06U
+ w=0.21U
M5493 VDD XCTRLB_AT_2 XCTRLB_XDEC3DY_5_Z1
+ VDD pch l=0.06U
+ w=0.21U
M5494 VDD XCTRLB_RSP XCTRLB_XDEC3DY_4_Z1
+ VDD pch l=0.06U
+ w=0.75U
M5495 VDD XCTRLB_XDEC3DY_4_Z1 B_Y_4
+ VDD pch_hvt l=0.06U
+ w=5U
M5496 XCTRLB_XDEC3DY_4_Z3 XCTRLB_AC_1
+ XCTRLB_XDEC3DY_4_Z4 VSS nch l=0.06U
+ w=2U
M5497 XCTRLB_XDEC3DY_5_Z3 XCTRLB_AC_1
+ XCTRLB_XDEC3DY_5_Z4 VSS nch l=0.06U
+ w=2U
M5498 XCTRLB_XALTCH_3_Z26 XCTRLB_CKP
+ XCTRLB_XALTCH_3_Z1 VSS nch l=0.06U
+ w=0.21U
M5499 XCTRLB_XALTCH_3_AX BISTT
+ XCTRLB_XALTCH_3_Z21 VDD pch l=0.08U
+ w=0.42U
M5500 XCTRLB_AT_3 XCTRLB_AC_3 VSS
+ VSS nch l=0.06U
+ w=0.55U
M5501 VDD XCTRLB_AC_3 XCTRLB_AT_3 VDD
+ pch l=0.06U
+ w=1.1U
M5502 VDD XCTRLB_AC_1 XCTRLB_XDEC3DY_4_Z1
+ VDD pch l=0.06U
+ w=0.21U
M5503 VDD XCTRLB_AC_1 XCTRLB_XDEC3DY_5_Z1
+ VDD pch l=0.06U
+ w=0.21U
M5504 VDD XCTRLB_RSP XCTRLB_XDEC3DY_4_Z1
+ VDD pch l=0.06U
+ w=0.75U
M5505 VDD XCTRLB_XDEC3DY_4_Z1 B_Y_4
+ VDD pch_hvt l=0.06U
+ w=5U
M5506 XCTRLB_XALTCH_3_Z1 XCTRLB_XALTCH_3_AX
+ XCTRLB_XALTCH_3_Z25 VDD pch l=0.08U
+ w=0.42U
M5507 XCTRLB_XDEC3DY_4_Z3 XCTRLB_AC_0
+ XCTRLB_XDEC3DY_4_Z2 VSS nch l=0.06U
+ w=2U
M5508 XCTRLB_XDEC3DY_5_Z3 XCTRLB_AT_0
+ XCTRLB_XDEC3DY_5_Z2 VSS nch l=0.06U
+ w=2U
M5509 XCTRLB_XALTCH_3_Z1 XCTRLB_CKC
+ XCTRLB_XALTCH_3_Z28 VDD pch l=0.06U
+ w=0.21U
M5510 XCTRLB_XALTCH_3_Z1 XCTRLB_XALTCH_3_AX
+ XCTRLB_XALTCH_3_Z27 VSS nch l=0.08U
+ w=0.21U
M5511 XCTRLB_XALTCH_3_AX BISTC
+ XCTRLB_XALTCH_3_Z22 VDD pch l=0.08U
+ w=0.42U
M5512 XCTRLB_AC_3 XCTRLB_XALTCH_3_Z1
+ VSS VSS nch l=0.06U
+ w=0.55U
M5513 VDD XCTRLB_XALTCH_3_Z1
+ XCTRLB_AC_3 VDD pch l=0.06U
+ w=1.1U
M5514 VDD XCTRLB_AC_0 XCTRLB_XDEC3DY_4_Z1
+ VDD pch l=0.06U
+ w=0.21U
M5515 VDD XCTRLB_AT_0 XCTRLB_XDEC3DY_5_Z1
+ VDD pch l=0.06U
+ w=0.21U
M5516 VDD XCTRLB_RSP XCTRLB_XDEC3DY_5_Z1
+ VDD pch l=0.06U
+ w=0.75U
M5517 VDD XCTRLB_XDEC3DY_5_Z1 B_Y_5
+ VDD pch_hvt l=0.06U
+ w=5U
M5518 XCTRLB_XDEC3DY_4_Z2 XCTRLB_CKP
+ XCTRLB_XDEC3DY_4_Z1 VSS nch l=0.06U
+ w=2U
M5519 XCTRLB_XDEC3DY_5_Z2 XCTRLB_CKP
+ XCTRLB_XDEC3DY_5_Z1 VSS nch l=0.06U
+ w=2U
M5520 XCTRLB_XALTCH_3_Z22 AMB_3 VDD VDD
+ pch l=0.08U
+ w=0.42U
M5521 XCTRLB_AC_3 XCTRLB_XALTCH_3_Z1
+ VSS VSS nch l=0.06U
+ w=0.55U
M5522 VDD XCTRLB_XALTCH_3_Z1
+ XCTRLB_AC_3 VDD pch l=0.06U
+ w=1.1U
M5523 VDD XCTRLB_CKP XCTRLB_XDEC3DY_4_Z1
+ VDD pch l=0.06U
+ w=0.21U
M5524 VDD XCTRLB_CKP XCTRLB_XDEC3DY_5_Z1
+ VDD pch l=0.06U
+ w=0.21U
M5525 VDD XCTRLB_RSP XCTRLB_XDEC3DY_5_Z1
+ VDD pch l=0.06U
+ w=0.75U
M5526 VDD XCTRLB_XDEC3DY_5_Z1 B_Y_5
+ VDD pch_hvt l=0.06U
+ w=5U
M5527 XCTRLB_XALTCH_3_Z28 XCTRLB_AC_3 VDD
+ VDD pch l=0.06U
+ w=0.21U
M5528 VSS XCTRLB_CKC XCTRLB_XALTCH_3_Z27
+ VSS nch l=0.06U
+	 w=0.21U
M5529 XCTRLB_XALTCH_2_Z28 XCTRLB_AC_2 VDD
+ VDD pch l=0.06U
+ w=0.21U
M5530 VDD AMB_2 XCTRLB_XALTCH_2_Z22 VDD
+ pch l=0.08U
+	 w=0.42U
M5531 VSS XCTRLB_CKC XCTRLB_XALTCH_2_Z27
+ VSS nch l=0.06U
+	 w=0.21U
M5532 XCTRLB_AC_2 XCTRLB_XALTCH_2_Z1
+ VSS VSS nch l=0.06U
+ w=0.55U
M5533 VDD XCTRLB_XALTCH_2_Z1
+ XCTRLB_AC_2 VDD pch l=0.06U
+ w=1.1U
M5534 VDD XCTRLB_CKP XCTRLB_XDEC3DY_6_Z1
+ VDD pch l=0.06U
+ w=0.21U
M5535 VDD XCTRLB_CKP XCTRLB_XDEC3DY_7_Z1
+ VDD pch l=0.06U
+ w=0.21U
M5536 VDD XCTRLB_RSP XCTRLB_XDEC3DY_7_Z1
+ VDD pch l=0.06U
+ w=0.75U
M5537 VDD XCTRLB_XDEC3DY_7_Z1 B_Y_7
+ VDD pch_hvt l=0.06U
+ w=5U
M5538 XCTRLB_XDEC3DY_6_Z1 XCTRLB_CKP
+ XCTRLB_XDEC3DY_6_Z2 VSS nch l=0.06U
+ w=2U
M5539 XCTRLB_XDEC3DY_7_Z1 XCTRLB_CKP
+ XCTRLB_XDEC3DY_7_Z2 VSS nch l=0.06U
+ w=2U
M5540 XCTRLB_XALTCH_2_AX BISTC
+ XCTRLB_XALTCH_2_Z22 VDD pch l=0.08U
+ w=0.42U
M5541 XCTRLB_AC_2 XCTRLB_XALTCH_2_Z1
+ VSS VSS nch l=0.06U
+ w=0.55U
M5542 VDD XCTRLB_XALTCH_2_Z1
+ XCTRLB_AC_2 VDD pch l=0.06U
+ w=1.1U
M5543 VDD XCTRLB_AC_0 XCTRLB_XDEC3DY_6_Z1
+ VDD pch l=0.06U
+ w=0.21U
M5544 VDD XCTRLB_AT_0 XCTRLB_XDEC3DY_7_Z1
+ VDD pch l=0.06U
+ w=0.21U
M5545 VDD XCTRLB_RSP XCTRLB_XDEC3DY_7_Z1
+ VDD pch l=0.06U
+ w=0.75U
M5546 VDD XCTRLB_XDEC3DY_7_Z1 B_Y_7
+ VDD pch_hvt l=0.06U
+ w=5U
M5547 XCTRLB_XALTCH_2_Z1 XCTRLB_CKC
+ XCTRLB_XALTCH_2_Z28 VDD pch l=0.06U
+ w=0.21U
M5548 XCTRLB_XALTCH_2_Z27 XCTRLB_XALTCH_2_AX
+ XCTRLB_XALTCH_2_Z1 VSS nch l=0.08U
+ w=0.21U
M5549 XCTRLB_XDEC3DY_6_Z3 XCTRLB_AC_0
+ XCTRLB_XDEC3DY_6_Z2 VSS nch l=0.06U
+ w=2U
M5550 XCTRLB_XDEC3DY_7_Z3 XCTRLB_AT_0
+ XCTRLB_XDEC3DY_7_Z2 VSS nch l=0.06U
+ w=2U
M5551 XCTRLB_XALTCH_2_Z1 XCTRLB_CKP
+ XCTRLB_XALTCH_2_Z26 VSS nch l=0.06U
+ w=0.21U
M5552 XCTRLB_XALTCH_2_AX BISTT
+ XCTRLB_XALTCH_2_Z21 VDD pch l=0.08U
+ w=0.42U
M5553 XCTRLB_XALTCH_2_Z25 XCTRLB_XALTCH_2_AX
+ XCTRLB_XALTCH_2_Z1 VDD pch l=0.08U
+ w=0.42U
M5554 XCTRLB_XDEC3DY_6_Z3 XCTRLB_AT_1
+ XCTRLB_XDEC3DY_6_Z4 VSS nch l=0.06U
+ w=2U
M5555 XCTRLB_XDEC3DY_7_Z3 XCTRLB_AT_1
+ XCTRLB_XDEC3DY_7_Z4 VSS nch l=0.06U
+ w=2U
M5556 XCTRLB_AT_2 XCTRLB_AC_2 VSS VSS
+ nch l=0.06U
+ w=0.55U
M5557 VDD XCTRLB_AC_2 XCTRLB_AT_2 VDD
+ pch l=0.06U
+ w=1.1U
M5558 VDD XCTRLB_AT_1 XCTRLB_XDEC3DY_6_Z1
+ VDD pch l=0.06U
+ w=0.21U
M5559 VDD XCTRLB_AT_1 XCTRLB_XDEC3DY_7_Z1
+ VDD pch l=0.06U
+ w=0.21U
M5560 VDD XCTRLB_RSP XCTRLB_XDEC3DY_6_Z1
+ VDD pch l=0.06U
+ w=0.75U
M5561 VDD XCTRLB_XDEC3DY_6_Z1 B_Y_6
+ VDD pch_hvt l=0.06U
+ w=5U
M5562 VDD AB_2 XCTRLB_XALTCH_2_Z21 VDD
+ pch l=0.08U
+ w=0.42U
M5563 XCTRLB_AT_2 XCTRLB_AC_2 VSS
+ VSS nch l=0.06U
+	 w=0.55U
M5564 VDD XCTRLB_AC_2 XCTRLB_AT_2
+ VDD pch l=0.06U
+ w=1.1U
M5565 VDD XCTRLB_AT_2 XCTRLB_XDEC3DY_6_Z1
+ VDD pch l=0.06U
+ w=0.21U
M5566 XCTRLB_XDEC3DY_6_Z4 XCTRLB_AT_2 VSS
+ VSS nch l=0.06U
+ w=2U
M5567 XCTRLB_XDEC3DY_7_Z4 XCTRLB_AT_2 VSS
+ VSS nch l=0.06U
+ w=2U
M5568 VDD XCTRLB_AT_2 XCTRLB_XDEC3DY_7_Z1
+ VDD pch l=0.06U
+ w=0.21U
M5569 VDD XCTRLB_RSP XCTRLB_XDEC3DY_6_Z1
+ VDD pch l=0.06U
+ w=0.75U
M5570 VDD XCTRLB_XDEC3DY_6_Z1 B_Y_6
+ VDD pch_hvt l=0.06U
+ w=5U
M5571 XCTRLB_XALTCH_2_Z25 XCTRLB_CKP VDD
+ VDD pch l=0.06U
+ w=0.42U
M5572 XCTRLB_XALTCH_2_Z26 XCTRLB_AC_2 VSS
+ VSS nch l=0.06U
+	 w=0.21U
M5573 XCTRLB_XALTCH_1_Z26 XCTRLB_AC_1 VSS
+ VSS nch l=0.06U
+	 w=0.21U
M5574 XCTRLB_XALTCH_1_Z25 XCTRLB_CKP VDD
+ VDD pch l=0.06U
+ w=0.42U
M5575 XCTRLB_XALTCH_1_Z21 AB_1 VDD VDD
+ pch l=0.08U
+	 w=0.42U
M5576 XCTRLB_AT_1 XCTRLB_AC_1 VSS VSS
+ nch l=0.06U
+ w=0.55U
M5577 VDD XCTRLB_AC_1 XCTRLB_AT_1
+ VDD pch l=0.06U
+ w=1.1U
M5578 VDD XCTRLB_AC_9
+ XCTRLB_XDEC3DXB_0_Z1 VDD pch l=0.06U
+ w=0.21U
M5579 VSS XCTRLB_AC_9
+ XCTRLB_XDEC3DXB_0_XND0_NET14 VSS nch
+ l=0.06U
+ w=2U
M5580 VSS XCTRLB_AC_9
+ XCTRLB_XDEC3DXB_1_XND0_NET14 VSS nch
+ l=0.06U
+ w=2U
M5581 VDD XCTRLB_AC_9
+ XCTRLB_XDEC3DXB_1_Z1 VDD pch l=0.06U
+ w=0.21U
M5582 VDD XCTRLB_RSP XCTRLB_XDEC3DXB_0_Z1
+ VDD pch l=0.06U
+ w=0.75U
M5583 VDD XCTRLB_XDEC3DXB_0_Z1 B_XB_0
+ VDD pch_hvt l=0.06U
+ w=5U
M5584 XCTRLB_XALTCH_1_Z26 XCTRLB_CKP
+ XCTRLB_XALTCH_1_Z1 VSS nch l=0.06U
+ w=0.21U
M5585 XCTRLB_XALTCH_1_AX BISTT
+ XCTRLB_XALTCH_1_Z21 VDD pch l=0.08U
+ w=0.42U
M5586 XCTRLB_AT_1 XCTRLB_AC_1 VSS
+ VSS nch l=0.06U
+ w=0.55U
M5587 VDD XCTRLB_AC_1 XCTRLB_AT_1 VDD
+ pch l=0.06U
+ w=1.1U
M5588 VDD XCTRLB_AC_8
+ XCTRLB_XDEC3DXB_0_Z1 VDD pch l=0.06U
+ w=0.21U
M5589 VDD XCTRLB_AT_8
+ XCTRLB_XDEC3DXB_1_Z1 VDD pch l=0.06U
+ w=0.21U
M5590 VDD XCTRLB_RSP
+ XCTRLB_XDEC3DXB_0_Z1 VDD pch l=0.06U
+ w=0.75U
M5591 VDD XCTRLB_XDEC3DXB_0_Z1 B_XB_0
+ VDD pch_hvt l=0.06U
+ w=5U
M5592 XCTRLB_XALTCH_1_Z25 XCTRLB_XALTCH_1_AX
+ XCTRLB_XALTCH_1_Z1 VDD pch l=0.08U
+ w=0.42U
M5593 XCTRLB_XDEC3DXB_0_XND0_NET14
+	XCTRLB_AC_8 XCTRLB_XDEC3DXB_0_XND0_NET17 VSS nch
+ l=0.06U
+ w=2U
M5594 XCTRLB_XDEC3DXB_1_XND0_NET14
+	XCTRLB_AT_8 XCTRLB_XDEC3DXB_1_XND0_NET17 VSS nch
+ l=0.06U
+ w=2U
M5595 XCTRLB_XALTCH_1_Z1 XCTRLB_CKC
+ XCTRLB_XALTCH_1_Z28 VDD pch l=0.06U
+ w=0.21U
M5596 XCTRLB_XALTCH_1_Z1 XCTRLB_XALTCH_1_AX
+ XCTRLB_XALTCH_1_Z27 VSS nch l=0.08U
+ w=0.21U
M5597 XCTRLB_XALTCH_1_AX BISTC
+ XCTRLB_XALTCH_1_Z22 VDD pch l=0.08U
+ w=0.42U
M5598 XCTRLB_AC_1 XCTRLB_XALTCH_1_Z1
+ VSS VSS nch l=0.06U
+ w=0.55U
M5599 VDD XCTRLB_XALTCH_1_Z1
+ XCTRLB_AC_1 VDD pch l=0.06U
+ w=1.1U
M5600 VDD XCTRLB_RSP
+ XCTRLB_XDEC3DXB_1_Z1 VDD pch l=0.06U
+ w=0.75U
M5601 VDD XCTRLB_XDEC3DXB_1_Z1 B_XB_1
+ VDD pch_hvt l=0.06U
+ w=5U
M5602 VDD XCTRLB_CKP
+ XCTRLB_XDEC3DXB_0_Z1 VDD pch l=0.06U
+ w=0.21U
M5603 VDD XCTRLB_CKP
+ XCTRLB_XDEC3DXB_1_Z1 VDD pch l=0.06U
+ w=0.21U
M5604 XCTRLB_XDEC3DXB_0_XND0_NET17
+ XCTRLB_CKP XCTRLB_XDEC3DXB_0_Z1 VSS nch
+ l=0.06U
+ w=2U
M5605 XCTRLB_XDEC3DXB_1_XND0_NET17
+ XCTRLB_CKP XCTRLB_XDEC3DXB_1_Z1 VSS nch
+ l=0.06U
+ w=2U
M5606 VDD AMB_1 XCTRLB_XALTCH_1_Z22 VDD
+ pch l=0.08U
+	 w=0.42U
M5607 XCTRLB_AC_1 XCTRLB_XALTCH_1_Z1
+ VSS VSS nch l=0.06U
+ w=0.55U
M5608 VDD XCTRLB_XALTCH_1_Z1
+ XCTRLB_AC_1 VDD pch l=0.06U
+ w=1.1U
M5609 VDD XCTRLB_RSP XCTRLB_XDEC3DXB_1_Z1
+ VDD pch l=0.06U
+ w=0.75U
M5610 VDD XCTRLB_XDEC3DXB_1_Z1 B_XB_1
+ VDD pch_hvt l=0.06U
+ w=5U
M5611 XCTRLB_XALTCH_1_Z28 XCTRLB_AC_1 VDD
+ VDD pch l=0.06U
+ w=0.21U
M5612 VSS XCTRLB_CKC XCTRLB_XALTCH_1_Z27
+ VSS nch l=0.06U
+	 w=0.21U
M5613 XCTRLB_XALTCH_0_Z28 XCTRLB_AC_0 VDD
+ VDD pch l=0.06U
+ w=0.21U
M5614 XCTRLB_XALTCH_0_Z22 AMB_0 VDD VDD
+ pch l=0.08U
+	 w=0.42U
M5615 XCTRLB_XALTCH_0_Z27 XCTRLB_CKC VSS
+ VSS nch l=0.06U
+	 w=0.21U
M5616 XCTRLB_AC_0 XCTRLB_XALTCH_0_Z1
+ VSS VSS nch l=0.06U
+ w=0.55U
M5617 VDD XCTRLB_XALTCH_0_Z1
+ XCTRLB_AC_0 VDD pch l=0.06U
+ w=1.1U
M5618 VDD XCTRLB_RSP XCTRLB_XDEC3DXB_3_Z1
+ VDD pch l=0.06U
+ w=0.75U
M5619 VDD XCTRLB_XDEC3DXB_3_Z1 B_XB_3
+ VDD pch_hvt l=0.06U
+ w=5U
M5620 XCTRLB_XALTCH_0_AX BISTC
+ XCTRLB_XALTCH_0_Z22 VDD pch l=0.08U
+ w=0.42U
M5621 XCTRLB_AC_0 XCTRLB_XALTCH_0_Z1
+ VSS VSS nch l=0.06U
+ w=0.55U
M5622 VDD XCTRLB_XALTCH_0_Z1
+ XCTRLB_AC_0 VDD pch l=0.06U
+ w=1.1U
M5623 VDD XCTRLB_CKP
+ XCTRLB_XDEC3DXB_2_Z1 VDD pch l=0.06U
+ w=0.21U
M5624 XCTRLB_XDEC3DXB_2_Z1 XCTRLB_CKP
+ XCTRLB_XDEC3DXB_2_XND0_NET17 VSS nch
+ l=0.06U
+ w=2U
M5625 XCTRLB_XDEC3DXB_3_Z1 XCTRLB_CKP
+ XCTRLB_XDEC3DXB_3_XND0_NET17 VSS nch
+ l=0.06U
+ w=2U
M5626 VDD XCTRLB_CKP
+ XCTRLB_XDEC3DXB_3_Z1 VDD pch l=0.06U
+ w=0.21U
M5627 VDD XCTRLB_RSP
+ XCTRLB_XDEC3DXB_3_Z1 VDD pch l=0.06U
+ w=0.75U
M5628 VDD XCTRLB_XDEC3DXB_3_Z1 B_XB_3
+ VDD pch_hvt l=0.06U
+ w=5U
M5629 XCTRLB_XALTCH_0_Z1 XCTRLB_CKC
+ XCTRLB_XALTCH_0_Z28 VDD pch l=0.06U
+ w=0.21U
M5630 XCTRLB_XALTCH_0_Z27 XCTRLB_XALTCH_0_AX
+ XCTRLB_XALTCH_0_Z1 VSS nch l=0.08U
+ w=0.21U
M5631 XCTRLB_XALTCH_0_Z1 XCTRLB_CKP
+ XCTRLB_XALTCH_0_Z26 VSS nch l=0.06U
+ w=0.21U
M5632 XCTRLB_XALTCH_0_AX BISTT
+ XCTRLB_XALTCH_0_Z21 VDD pch l=0.08U
+ w=0.42U
M5633 XCTRLB_XALTCH_0_Z25 XCTRLB_XALTCH_0_AX
+ XCTRLB_XALTCH_0_Z1 VDD pch l=0.08U
+ w=0.42U
M5634 XCTRLB_AT_0 XCTRLB_AC_0 VSS
+ VSS nch l=0.06U
+ w=0.55U
M5635 VDD XCTRLB_AC_0 XCTRLB_AT_0 VDD
+ pch l=0.06U
+ w=1.1U
M5636 VDD XCTRLB_AC_8
+ XCTRLB_XDEC3DXB_2_Z1 VDD pch l=0.06U
+ w=0.21U
M5637 XCTRLB_XDEC3DXB_2_XND0_NET17
+	XCTRLB_AC_8 XCTRLB_XDEC3DXB_2_XND0_NET14 VSS nch
+ l=0.06U
+ w=2U
M5638 XCTRLB_XDEC3DXB_3_XND0_NET17
+	XCTRLB_AT_8 XCTRLB_XDEC3DXB_3_XND0_NET14 VSS nch
+ l=0.06U
+ w=2U
M5639 VDD XCTRLB_AT_8
+ XCTRLB_XDEC3DXB_3_Z1 VDD pch l=0.06U
+ w=0.21U
M5640 VDD XCTRLB_RSP
+ XCTRLB_XDEC3DXB_2_Z1 VDD pch l=0.06U
+ w=0.75U
M5641 VDD XCTRLB_XDEC3DXB_2_Z1 B_XB_2
+ VDD pch_hvt l=0.06U
+ w=5U
M5642 VDD AB_0 XCTRLB_XALTCH_0_Z21 VDD
+ pch l=0.08U
+	 w=0.42U
M5643 XCTRLB_AT_0 XCTRLB_AC_0 VSS VSS
+ nch l=0.06U
+ w=0.55U
M5644 VDD XCTRLB_AC_0 XCTRLB_AT_0
+ VDD pch l=0.06U
+ w=1.1U
M5645 VDD XCTRLB_AT_9
+ XCTRLB_XDEC3DXB_2_Z1 VDD pch l=0.06U
+ w=0.21U
M5646 VDD XCTRLB_AT_9
+ XCTRLB_XDEC3DXB_3_Z1 VDD pch l=0.06U
+ w=0.21U
M5647 VDD XCTRLB_RSP XCTRLB_XDEC3DXB_2_Z1
+ VDD pch l=0.06U
+ w=0.75U
M5648 VDD XCTRLB_XDEC3DXB_2_Z1 B_XB_2
+ VDD pch_hvt l=0.06U
+ w=5U
M5649 XCTRLB_XALTCH_0_Z25 XCTRLB_CKP VDD
+ VDD pch l=0.06U
+	 w=0.42U
M5650 XCTRLB_XDEC3DXB_2_XND0_NET14
+ XCTRLB_AT_9 VSS VSS nch l=0.06U
+ w=2U
M5651 XCTRLB_XDEC3DXB_3_XND0_NET14
+ XCTRLB_AT_9 VSS VSS nch l=0.06U
+ w=2U
M5652 XCTRLB_XALTCH_0_Z26 XCTRLB_AC_0 VSS
+ VSS nch l=0.06U
+	 w=0.21U
M5653 VSS XCTRLB_AC_12 XCTRLB_XDEC3DXC_0_Z4
+ VSS nch l=0.06U
+ w=2U
M5654 VSS XCTRLB_AC_12 XCTRLB_XDEC3DXC_1_Z4
+ VSS nch l=0.06U
+ w=2U
M5655 VSS XCTRLB_AC_9 XCTRLB_XALTCH_9_Z26
+ VSS nch l=0.06U
+	 w=0.21U
M5656 VDD XCTRLB_CKP XCTRLB_XALTCH_9_Z25
+ VDD pch l=0.06U
+ w=0.42U
M5657 VDD AB_9 XCTRLB_XALTCH_9_Z21 VDD
+ pch l=0.08U
+ w=0.42U
M5658 XCTRLB_AT_9 XCTRLB_AC_9 VSS VSS
+ nch l=0.06U
+ w=0.55U
M5659 VDD XCTRLB_AC_9 XCTRLB_AT_9
+ VDD pch l=0.06U
+ w=1.1U
M5660 VDD XCTRLB_AC_12 XCTRLB_XDEC3DXC_0_Z1
+ VDD pch l=0.06U
+ w=0.21U
M5661 VDD XCTRLB_AC_12 XCTRLB_XDEC3DXC_1_Z1
+ VDD pch l=0.06U
+ w=0.21U
M5662 VDD XCTRLB_RSP XCTRLB_XDEC3DXC_0_Z1
+ VDD pch l=0.06U
+ w=0.75U
M5663 VDD XCTRLB_XDEC3DXC_0_Z1 B_XC_0
+ VDD pch_hvt l=0.06U
+ w=5U
M5664 XCTRLB_XDEC3DXC_0_Z4 XCTRLB_AC_11
+ XCTRLB_XDEC3DXC_0_Z3 VSS nch l=0.06U
+ w=2U
M5665 XCTRLB_XDEC3DXC_1_Z4 XCTRLB_AC_11
+ XCTRLB_XDEC3DXC_1_Z3 VSS nch l=0.06U
+ w=2U
M5666 XCTRLB_XALTCH_9_Z26 XCTRLB_CKP
+ XCTRLB_XALTCH_9_Z1 VSS nch l=0.06U
+ w=0.21U
M5667 XCTRLB_XALTCH_9_AX BISTT
+ XCTRLB_XALTCH_9_Z21 VDD pch l=0.08U
+ w=0.42U
M5668 XCTRLB_AT_9 XCTRLB_AC_9 VSS
+ VSS nch l=0.06U
+	 w=0.55U
M5669 VDD XCTRLB_AC_9 XCTRLB_AT_9 VDD
+ pch l=0.06U
+ w=1.1U
M5670 VDD XCTRLB_AC_11 XCTRLB_XDEC3DXC_0_Z1
+ VDD pch l=0.06U
+ w=0.21U
M5671 VDD XCTRLB_AC_11 XCTRLB_XDEC3DXC_1_Z1
+ VDD pch l=0.06U
+ w=0.21U
M5672 VDD XCTRLB_RSP
+ XCTRLB_XDEC3DXC_0_Z1 VDD pch l=0.06U
+ w=0.75U
M5673 VDD XCTRLB_XDEC3DXC_0_Z1 B_XC_0
+ VDD pch_hvt l=0.06U
+ w=5U
M5674 XCTRLB_XALTCH_9_Z25 XCTRLB_XALTCH_9_AX
+ XCTRLB_XALTCH_9_Z1 VDD pch l=0.08U
+ w=0.42U
M5675 XCTRLB_XDEC3DXC_0_Z3 XCTRLB_AC_10
+ XCTRLB_XDEC3DXC_0_Z2 VSS nch l=0.06U
+ w=2U
M5676 XCTRLB_XDEC3DXC_1_Z3 XCTRLB_AT_10
+ XCTRLB_XDEC3DXC_1_Z2 VSS nch l=0.06U
+ w=2U
M5677 XCTRLB_XALTCH_9_Z1 XCTRLB_CKC
+ XCTRLB_XALTCH_9_Z28 VDD pch l=0.06U
+ w=0.21U
M5678 XCTRLB_XALTCH_9_Z1 XCTRLB_XALTCH_9_AX
+ XCTRLB_XALTCH_9_Z27 VSS nch l=0.08U
+ w=0.21U
M5679 XCTRLB_XALTCH_9_AX BISTC
+ XCTRLB_XALTCH_9_Z22 VDD pch l=0.08U
+ w=0.42U
M5680 XCTRLB_AC_9 XCTRLB_XALTCH_9_Z1
+ VSS VSS nch l=0.06U
+ w=0.55U
M5681 VDD XCTRLB_XALTCH_9_Z1
+ XCTRLB_AC_9 VDD pch l=0.06U
+ w=1.1U
M5682 VDD XCTRLB_AC_10 XCTRLB_XDEC3DXC_0_Z1
+ VDD pch l=0.06U
+ w=0.21U
M5683 VDD XCTRLB_AT_10 XCTRLB_XDEC3DXC_1_Z1
+ VDD pch l=0.06U
+ w=0.21U
M5684 VDD XCTRLB_RSP XCTRLB_XDEC3DXC_1_Z1
+ VDD pch l=0.06U
+ w=0.75U
M5685 VDD XCTRLB_XDEC3DXC_1_Z1 B_XC_1
+ VDD pch_hvt l=0.06U
+ w=5U
M5686 XCTRLB_XDEC3DXC_0_Z2 XCTRLB_CKP
+ XCTRLB_XDEC3DXC_0_Z1 VSS nch l=0.06U
+ w=2U
M5687 XCTRLB_XDEC3DXC_1_Z2 XCTRLB_CKP
+ XCTRLB_XDEC3DXC_1_Z1 VSS nch l=0.06U
+ w=2U
M5688 VDD AMB_9 XCTRLB_XALTCH_9_Z22 VDD
+ pch l=0.08U
+	 w=0.42U
M5689 XCTRLB_AC_9 XCTRLB_XALTCH_9_Z1
+ VSS VSS nch l=0.06U
+ w=0.55U
M5690 VDD XCTRLB_XALTCH_9_Z1
+ XCTRLB_AC_9 VDD pch l=0.06U
+ w=1.1U
M5691 VDD XCTRLB_CKP XCTRLB_XDEC3DXC_0_Z1
+ VDD pch l=0.06U
+ w=0.21U
M5692 VDD XCTRLB_CKP XCTRLB_XDEC3DXC_1_Z1
+ VDD pch l=0.06U
+ w=0.21U
M5693 VDD XCTRLB_RSP
+ XCTRLB_XDEC3DXC_1_Z1 VDD pch l=0.06U
+ w=0.75U
M5694 VDD XCTRLB_XDEC3DXC_1_Z1 B_XC_1
+ VDD pch_hvt l=0.06U
+ w=5U
M5695 XCTRLB_XALTCH_9_Z28 XCTRLB_AC_9 VDD
+ VDD pch l=0.06U
+ w=0.21U
M5696 VSS XCTRLB_CKC XCTRLB_XALTCH_9_Z27
+ VSS nch l=0.06U
+	 w=0.21U
M5697 XCTRLB_XALTCH_8_Z28 XCTRLB_AC_8 VDD
+ VDD pch l=0.06U
+ w=0.21U
M5698 XCTRLB_XALTCH_8_Z22 AMB_8 VDD VDD
+ pch l=0.08U
+	 w=0.42U
M5699 XCTRLB_XALTCH_8_Z27 XCTRLB_CKC VSS
+ VSS nch l=0.06U
+	 w=0.21U
M5700 XCTRLB_AC_8 XCTRLB_XALTCH_8_Z1
+ VSS VSS nch l=0.06U
+ w=0.55U
M5701 VDD XCTRLB_XALTCH_8_Z1
+ XCTRLB_AC_8 VDD pch l=0.06U
+ w=1.1U
M5702 VDD XCTRLB_CKP XCTRLB_XDEC3DXC_2_Z1
+ VDD pch l=0.06U
+ w=0.21U
M5703 VDD XCTRLB_CKP XCTRLB_XDEC3DXC_3_Z1
+ VDD pch l=0.06U
+ w=0.21U
M5704 VDD XCTRLB_RSP XCTRLB_XDEC3DXC_3_Z1
+ VDD pch l=0.06U
+ w=0.75U
M5705 VDD XCTRLB_XDEC3DXC_3_Z1 B_XC_3
+ VDD pch_hvt l=0.06U
+ w=5U
M5706 XCTRLB_XDEC3DXC_2_Z2 XCTRLB_CKP
+ XCTRLB_XDEC3DXC_2_Z1 VSS nch l=0.06U
+ w=2U
M5707 XCTRLB_XDEC3DXC_3_Z2 XCTRLB_CKP
+ XCTRLB_XDEC3DXC_3_Z1 VSS nch l=0.06U
+ w=2U
M5708 XCTRLB_XALTCH_8_AX BISTC
+ XCTRLB_XALTCH_8_Z22 VDD pch l=0.08U
+ w=0.42U
M5709 XCTRLB_AC_8 XCTRLB_XALTCH_8_Z1
+ VSS VSS nch l=0.06U
+ w=0.55U
M5710 VDD XCTRLB_XALTCH_8_Z1
+ XCTRLB_AC_8 VDD pch l=0.06U
+ w=1.1U
M5711 VDD XCTRLB_AC_10 XCTRLB_XDEC3DXC_2_Z1
+ VDD pch l=0.06U
+ w=0.21U
M5712 VDD XCTRLB_AT_10 XCTRLB_XDEC3DXC_3_Z1
+ VDD pch l=0.06U
+ w=0.21U
M5713 VDD XCTRLB_RSP
+ XCTRLB_XDEC3DXC_3_Z1 VDD pch l=0.06U
+ w=0.75U
M5714 VDD XCTRLB_XDEC3DXC_3_Z1 B_XC_3
+ VDD pch_hvt l=0.06U
+ w=5U
M5715 XCTRLB_XALTCH_8_Z1 XCTRLB_CKC
+ XCTRLB_XALTCH_8_Z28 VDD pch l=0.06U
+ w=0.21U
M5716 XCTRLB_XALTCH_8_Z27 XCTRLB_XALTCH_8_AX
+ XCTRLB_XALTCH_8_Z1 VSS nch l=0.08U
+ w=0.21U
M5717 XCTRLB_XDEC3DXC_2_Z2 XCTRLB_AC_10
+ XCTRLB_XDEC3DXC_2_Z3 VSS nch l=0.06U
+ w=2U
M5718 XCTRLB_XDEC3DXC_3_Z2 XCTRLB_AT_10
+ XCTRLB_XDEC3DXC_3_Z3 VSS nch l=0.06U
+ w=2U
M5719 XCTRLB_XALTCH_8_Z1 XCTRLB_CKP
+ XCTRLB_XALTCH_8_Z26 VSS nch l=0.06U
+ w=0.21U
M5720 XCTRLB_XALTCH_8_AX BISTT
+ XCTRLB_XALTCH_8_Z21 VDD pch l=0.08U
+ w=0.42U
M5721 XCTRLB_XALTCH_8_Z1 XCTRLB_XALTCH_8_AX
+ XCTRLB_XALTCH_8_Z25 VDD pch l=0.08U
+ w=0.42U
M5722 XCTRLB_XDEC3DXC_2_Z3 XCTRLB_AT_11
+ XCTRLB_XDEC3DXC_2_Z4 VSS nch l=0.06U
+ w=2U
M5723 XCTRLB_XDEC3DXC_3_Z3 XCTRLB_AT_11
+ XCTRLB_XDEC3DXC_3_Z4 VSS nch l=0.06U
+ w=2U
M5724 XCTRLB_AT_8 XCTRLB_AC_8 VSS
+ VSS nch l=0.06U
+	 w=0.55U
M5725 VDD XCTRLB_AC_8 XCTRLB_AT_8
+ VDD pch l=0.06U
+ w=1.1U
M5726 VDD XCTRLB_AT_11 XCTRLB_XDEC3DXC_2_Z1
+ VDD pch l=0.06U
+ w=0.21U
M5727 VDD XCTRLB_AT_11 XCTRLB_XDEC3DXC_3_Z1
+ VDD pch l=0.06U
+ w=0.21U
M5728 VDD XCTRLB_RSP XCTRLB_XDEC3DXC_2_Z1
+ VDD pch l=0.06U
+ w=0.75U
M5729 VDD XCTRLB_XDEC3DXC_2_Z1 B_XC_2
+ VDD pch_hvt l=0.06U
+ w=5U
M5730 VDD AB_8 XCTRLB_XALTCH_8_Z21 VDD
+ pch l=0.08U
+ w=0.42U
M5731 XCTRLB_AT_8 XCTRLB_AC_8 VSS VSS
+ nch l=0.06U
+ w=0.55U
M5732 VDD XCTRLB_AC_8 XCTRLB_AT_8 VDD
+ pch l=0.06U
+ w=1.1U
M5733 VDD XCTRLB_AC_12 XCTRLB_XDEC3DXC_2_Z1
+ VDD pch l=0.06U
+ w=0.21U
M5734 VDD XCTRLB_AC_12 XCTRLB_XDEC3DXC_3_Z1
+ VDD pch l=0.06U
+ w=0.21U
M5735 VDD XCTRLB_RSP
+ XCTRLB_XDEC3DXC_2_Z1 VDD pch l=0.06U
+ w=0.75U
M5736 VDD XCTRLB_XDEC3DXC_2_Z1 B_XC_2
+ VDD pch_hvt l=0.06U
+ w=5U
M5737 XCTRLB_XALTCH_8_Z25 XCTRLB_CKP VDD
+ VDD pch l=0.06U
+ w=0.42U
M5738 XCTRLB_XDEC3DXC_2_Z4 XCTRLB_AC_12 VSS
+ VSS nch l=0.06U
+ w=2U
M5739 XCTRLB_XDEC3DXC_3_Z4 XCTRLB_AC_12 VSS
+ VSS nch l=0.06U
+ w=2U
M5740 XCTRLB_XALTCH_8_Z26 XCTRLB_AC_8 VSS
+ VSS nch l=0.06U
+	 w=0.21U
M5741 VSS XCTRLB_AT_12 XCTRLB_XDEC3DXC_4_Z4
+ VSS nch l=0.06U
+ w=2U
M5742 VSS XCTRLB_AT_12 XCTRLB_XDEC3DXC_5_Z4
+ VSS nch l=0.06U
+ w=2U
M5743 XCTRLB_XALTCH_10_Z26 XCTRLB_AC_10 VSS
+ VSS nch l=0.06U
+	 w=0.21U
M5744 XCTRLB_XALTCH_10_Z25 XCTRLB_CKP VDD
+ VDD pch l=0.06U
+ w=0.42U
M5745 XCTRLB_XALTCH_10_Z21 AB_10 VDD VDD
+ pch l=0.08U
+ w=0.42U
M5746 XCTRLB_AT_10 XCTRLB_AC_10 VSS
+ VSS nch l=0.06U
+	 w=0.55U
M5747 VDD XCTRLB_AC_10 XCTRLB_AT_10
+ VDD pch l=0.06U
+ w=1.1U
M5748 VDD XCTRLB_AT_12 XCTRLB_XDEC3DXC_4_Z1
+ VDD pch l=0.06U
+ w=0.21U
M5749 VDD XCTRLB_AT_12 XCTRLB_XDEC3DXC_5_Z1
+ VDD pch l=0.06U
+ w=0.21U
M5750 VDD XCTRLB_RSP XCTRLB_XDEC3DXC_4_Z1
+ VDD pch l=0.06U
+ w=0.75U
M5751 VDD XCTRLB_XDEC3DXC_4_Z1 B_XC_4
+ VDD pch_hvt l=0.06U
+ w=5U
M5752 XCTRLB_XDEC3DXC_4_Z3 XCTRLB_AC_11
+ XCTRLB_XDEC3DXC_4_Z4 VSS nch l=0.06U
+ w=2U
M5753 XCTRLB_XDEC3DXC_5_Z3 XCTRLB_AC_11
+ XCTRLB_XDEC3DXC_5_Z4 VSS nch l=0.06U
+ w=2U
M5754 XCTRLB_XALTCH_10_Z1 XCTRLB_CKP
+ XCTRLB_XALTCH_10_Z26 VSS nch l=0.06U
+ w=0.21U
M5755 XCTRLB_XALTCH_10_AX BISTT
+ XCTRLB_XALTCH_10_Z21 VDD pch l=0.08U
+ w=0.42U
M5756 XCTRLB_AT_10 XCTRLB_AC_10 VSS
+ VSS nch l=0.06U
+	 w=0.55U
M5757 VDD XCTRLB_AC_10 XCTRLB_AT_10
+ VDD pch l=0.06U
+ w=1.1U
M5758 VDD XCTRLB_AC_11 XCTRLB_XDEC3DXC_4_Z1
+ VDD pch l=0.06U
+ w=0.21U
M5759 VDD XCTRLB_AC_11 XCTRLB_XDEC3DXC_5_Z1
+ VDD pch l=0.06U
+ w=0.21U
M5760 VDD XCTRLB_RSP
+ XCTRLB_XDEC3DXC_4_Z1 VDD pch l=0.06U
+ w=0.75U
M5761 VDD XCTRLB_XDEC3DXC_4_Z1 B_XC_4
+ VDD pch_hvt l=0.06U
+ w=5U
M5762 XCTRLB_XALTCH_10_Z25 XCTRLB_XALTCH_10_AX
+ XCTRLB_XALTCH_10_Z1 VDD pch l=0.08U
+ w=0.42U
M5763 XCTRLB_XDEC3DXC_4_Z3 XCTRLB_AC_10
+ XCTRLB_XDEC3DXC_4_Z2 VSS nch l=0.06U
+ w=2U
M5764 XCTRLB_XDEC3DXC_5_Z3 XCTRLB_AT_10
+ XCTRLB_XDEC3DXC_5_Z2 VSS nch l=0.06U
+ w=2U
M5765 XCTRLB_XALTCH_10_Z28 XCTRLB_CKC
+ XCTRLB_XALTCH_10_Z1 VDD pch l=0.06U
+ w=0.21U
M5766 XCTRLB_XALTCH_10_Z1 XCTRLB_XALTCH_10_AX
+ XCTRLB_XALTCH_10_Z27 VSS nch l=0.08U
+ w=0.21U
M5767 XCTRLB_XALTCH_10_Z22 BISTC
+ XCTRLB_XALTCH_10_AX VDD pch l=0.08U
+ w=0.42U
M5768 XCTRLB_AC_10 XCTRLB_XALTCH_10_Z1
+ VSS VSS nch l=0.06U
+ w=0.55U
M5769 VDD XCTRLB_XALTCH_10_Z1
+ XCTRLB_AC_10 VDD pch l=0.06U
+ w=1.1U
M5770 VDD XCTRLB_AC_10 XCTRLB_XDEC3DXC_4_Z1
+ VDD pch l=0.06U
+ w=0.21U
M5771 VDD XCTRLB_AT_10 XCTRLB_XDEC3DXC_5_Z1
+ VDD pch l=0.06U
+	 w=0.21U
M5772 VDD XCTRLB_RSP XCTRLB_XDEC3DXC_5_Z1
+ VDD pch l=0.06U
+ w=0.75U
M5773 VDD XCTRLB_XDEC3DXC_5_Z1 B_XC_5
+ VDD pch_hvt l=0.06U
+ w=5U
M5774 XCTRLB_XDEC3DXC_4_Z2 XCTRLB_CKP
+ XCTRLB_XDEC3DXC_4_Z1 VSS nch l=0.06U
+ w=2U
M5775 XCTRLB_XDEC3DXC_5_Z2 XCTRLB_CKP
+ XCTRLB_XDEC3DXC_5_Z1 VSS nch l=0.06U
+ w=2U
M5776 VDD AMB_10 XCTRLB_XALTCH_10_Z22 VDD
+ pch l=0.08U
+ w=0.42U
M5777 XCTRLB_AC_10 XCTRLB_XALTCH_10_Z1
+ VSS VSS nch l=0.06U
+ w=0.55U
M5778 VDD XCTRLB_XALTCH_10_Z1
+ XCTRLB_AC_10 VDD pch l=0.06U
+ w=1.1U
M5779 VDD XCTRLB_CKP XCTRLB_XDEC3DXC_4_Z1
+ VDD pch l=0.06U
+ w=0.21U
M5780 VDD XCTRLB_CKP XCTRLB_XDEC3DXC_5_Z1
+ VDD pch l=0.06U
+ w=0.21U
M5781 VDD XCTRLB_RSP
+ XCTRLB_XDEC3DXC_5_Z1 VDD pch l=0.06U
+ w=0.75U
M5782 VDD XCTRLB_XDEC3DXC_5_Z1 B_XC_5
+ VDD pch_hvt l=0.06U
+ w=5U
M5783 XCTRLB_XALTCH_10_Z28 XCTRLB_AC_10 VDD
+ VDD pch l=0.06U
+ w=0.21U
M5784 VSS XCTRLB_CKC XCTRLB_XALTCH_10_Z27
+ VSS nch l=0.06U
+	 w=0.21U
M5785 VDD XCTRLB_AC_11 XCTRLB_XALTCH_11_Z28
+ VDD pch l=0.06U
+ w=0.21U
M5786 VDD AMB_11 XCTRLB_XALTCH_11_Z22 VDD
+ pch l=0.08U
+ w=0.42U
M5787 XCTRLB_XALTCH_11_Z27 XCTRLB_CKC VSS
+ VSS nch l=0.06U
+	 w=0.21U
M5788 XCTRLB_AC_11 XCTRLB_XALTCH_11_Z1
+ VSS VSS nch l=0.06U
+ w=0.55U
M5789 VDD XCTRLB_XALTCH_11_Z1
+ XCTRLB_AC_11 VDD pch l=0.06U
+ w=1.1U
M5790 VDD XCTRLB_CKP XCTRLB_XDEC3DXC_6_Z1
+ VDD pch l=0.06U
+ w=0.21U
M5791 VDD XCTRLB_CKP XCTRLB_XDEC3DXC_7_Z1
+ VDD pch l=0.06U
+ w=0.21U
M5792 VDD XCTRLB_RSP XCTRLB_XDEC3DXC_7_Z1
+ VDD pch l=0.06U
+ w=0.75U
M5793 VDD XCTRLB_XDEC3DXC_7_Z1 B_XC_7
+ VDD pch_hvt l=0.06U
+ w=5U
M5794 XCTRLB_XDEC3DXC_6_Z1 XCTRLB_CKP
+ XCTRLB_XDEC3DXC_6_Z2 VSS nch l=0.06U
+ w=2U
M5795 XCTRLB_XDEC3DXC_7_Z1 XCTRLB_CKP
+ XCTRLB_XDEC3DXC_7_Z2 VSS nch l=0.06U
+ w=2U
M5796 XCTRLB_XALTCH_11_AX BISTC
+ XCTRLB_XALTCH_11_Z22 VDD pch l=0.08U
+ w=0.42U
M5797 XCTRLB_AC_11 XCTRLB_XALTCH_11_Z1
+ VSS VSS nch l=0.06U
+ w=0.55U
M5798 VDD XCTRLB_XALTCH_11_Z1
+ XCTRLB_AC_11 VDD pch l=0.06U
+ w=1.1U
M5799 VDD XCTRLB_AC_10 XCTRLB_XDEC3DXC_6_Z1
+ VDD pch l=0.06U
+ w=0.21U
M5800 VDD XCTRLB_AT_10 XCTRLB_XDEC3DXC_7_Z1
+ VDD pch l=0.06U
+ w=0.21U
M5801 VDD XCTRLB_RSP
+ XCTRLB_XDEC3DXC_7_Z1 VDD pch l=0.06U
+ w=0.75U
M5802 VDD XCTRLB_XDEC3DXC_7_Z1 B_XC_7
+ VDD pch_hvt l=0.06U
+ w=5U
M5803 XCTRLB_XALTCH_11_Z1 XCTRLB_CKC
+ XCTRLB_XALTCH_11_Z28 VDD pch l=0.06U
+ w=0.21U
M5804 XCTRLB_XALTCH_11_Z1 XCTRLB_XALTCH_11_AX
+ XCTRLB_XALTCH_11_Z27 VSS nch l=0.08U
+ w=0.21U
M5805 XCTRLB_XDEC3DXC_6_Z3 XCTRLB_AC_10
+ XCTRLB_XDEC3DXC_6_Z2 VSS nch l=0.06U
+ w=2U
M5806 XCTRLB_XDEC3DXC_7_Z3 XCTRLB_AT_10
+ XCTRLB_XDEC3DXC_7_Z2 VSS nch l=0.06U
+ w=2U
M5807 XCTRLB_XALTCH_11_Z1 XCTRLB_CKP
+ XCTRLB_XALTCH_11_Z26 VSS nch l=0.06U
+ w=0.21U
M5808 XCTRLB_XALTCH_11_AX BISTT
+ XCTRLB_XALTCH_11_Z21 VDD pch l=0.08U
+ w=0.42U
M5809 XCTRLB_XALTCH_11_Z25 XCTRLB_XALTCH_11_AX
+ XCTRLB_XALTCH_11_Z1 VDD pch l=0.08U
+ w=0.42U
M5810 XCTRLB_XDEC3DXC_6_Z3 XCTRLB_AT_11
+ XCTRLB_XDEC3DXC_6_Z4 VSS nch l=0.06U
+ w=2U
M5811 XCTRLB_XDEC3DXC_7_Z3 XCTRLB_AT_11
+ XCTRLB_XDEC3DXC_7_Z4 VSS nch l=0.06U
+ w=2U
M5812 XCTRLB_AT_11 XCTRLB_AC_11 VSS
+ VSS nch l=0.06U
+ w=0.55U
M5813 VDD XCTRLB_AC_11 XCTRLB_AT_11
+ VDD pch l=0.06U
+ w=1.1U
M5814 VDD XCTRLB_AT_11 XCTRLB_XDEC3DXC_6_Z1
+ VDD pch l=0.06U
+ w=0.21U
M5815 VDD XCTRLB_AT_11 XCTRLB_XDEC3DXC_7_Z1
+ VDD pch l=0.06U
+ w=0.21U
M5816 VDD XCTRLB_RSP XCTRLB_XDEC3DXC_6_Z1
+ VDD pch l=0.06U
+ w=0.75U
M5817 VDD XCTRLB_XDEC3DXC_6_Z1 B_XC_6
+ VDD pch_hvt l=0.06U
+ w=5U
M5818 VDD AB_11 XCTRLB_XALTCH_11_Z21 VDD
+ pch l=0.08U
+	 w=0.42U
M5819 XCTRLB_AT_11 XCTRLB_AC_11 VSS
+ VSS nch l=0.06U
+ w=0.55U
M5820 VDD XCTRLB_AC_11 XCTRLB_AT_11
+ VDD pch l=0.06U
+ w=1.1U
M5821 VDD XCTRLB_AT_12 XCTRLB_XDEC3DXC_6_Z1
+ VDD pch l=0.06U
+ w=0.21U
M5822 VDD XCTRLB_AT_12 XCTRLB_XDEC3DXC_7_Z1
+ VDD pch l=0.06U
+ w=0.21U
M5823 VDD XCTRLB_RSP
+ XCTRLB_XDEC3DXC_6_Z1 VDD pch l=0.06U
+ w=0.75U
M5824 VDD XCTRLB_XDEC3DXC_6_Z1 B_XC_6
+ VDD pch_hvt l=0.06U
+ w=5U
M5825 XCTRLB_XALTCH_11_Z25 XCTRLB_CKP VDD
+ VDD pch l=0.06U
+ w=0.42U
M5826 XCTRLB_XDEC3DXC_6_Z4 XCTRLB_AT_12 VSS
+ VSS nch l=0.06U
+ w=2U
M5827 XCTRLB_XDEC3DXC_7_Z4 XCTRLB_AT_12 VSS
+ VSS nch l=0.06U
+ w=2U
M5828 XCTRLB_XALTCH_11_Z26 XCTRLB_AC_11 VSS
+ VSS nch l=0.06U
+	 w=0.21U
M5829 XCTRLB_XDEC3DXA_0_Z4 XCTRLB_AC_7 VSS
+ VSS nch l=0.06U
+ w=2U
M5830 XCTRLB_XDEC3DXA_1_Z4 XCTRLB_AC_7 VSS
+ VSS nch l=0.06U
+ w=2U
M5831 VSS XCTRLB_AC_12 XCTRLB_XALTCH_12_Z26
+ VSS nch l=0.06U
+	 w=0.21U
M5832 XCTRLB_XALTCH_12_Z25 XCTRLB_CKP VDD
+ VDD pch l=0.06U
+	 w=0.42U
M5833 XCTRLB_XALTCH_12_Z21 AB_12 VDD VDD
+ pch l=0.08U
+	 w=0.42U
M5834 XCTRLB_AT_12 XCTRLB_AC_12 VSS
+ VSS nch l=0.06U
+	 w=0.55U
M5835 VDD XCTRLB_AC_12 XCTRLB_AT_12
+ VDD pch l=0.06U
+ w=1.1U
M5836 VDD XCTRLB_AC_7 XCTRLB_XDEC3DXA_0_Z1
+ VDD pch l=0.06U
+ w=0.21U
M5837 VDD XCTRLB_AC_7 XCTRLB_XDEC3DXA_1_Z1
+ VDD pch l=0.06U
+ w=0.21U
M5838 VDD XCTRLB_RSP XCTRLB_XDEC3DXA_0_Z1
+ VDD pch l=0.06U
+ w=0.75U
M5839 VDD XCTRLB_XDEC3DXA_0_Z1 B_XA_0
+ VDD pch_hvt l=0.06U
+ w=5U
M5840 XCTRLB_XDEC3DXA_0_Z3 XCTRLB_AC_6
+ XCTRLB_XDEC3DXA_0_Z4 VSS nch l=0.06U
+ w=2U
M5841 XCTRLB_XDEC3DXA_1_Z3 XCTRLB_AC_6
+ XCTRLB_XDEC3DXA_1_Z4 VSS nch l=0.06U
+ w=2U
M5842 XCTRLB_XALTCH_12_Z26 XCTRLB_CKP
+ XCTRLB_XALTCH_12_Z1 VSS nch l=0.06U
+ w=0.21U
M5843 XCTRLB_XALTCH_12_AX BISTT
+ XCTRLB_XALTCH_12_Z21 VDD pch l=0.08U
+ w=0.42U
M5844 XCTRLB_AT_12 XCTRLB_AC_12 VSS
+ VSS nch l=0.06U
+ w=0.55U
M5845 VDD XCTRLB_AC_12 XCTRLB_AT_12
+ VDD pch l=0.06U
+ w=1.1U
M5846 VDD XCTRLB_AC_6 XCTRLB_XDEC3DXA_0_Z1
+ VDD pch l=0.06U
+ w=0.21U
M5847 VDD XCTRLB_AC_6 XCTRLB_XDEC3DXA_1_Z1
+ VDD pch l=0.06U
+ w=0.21U
M5848 VDD XCTRLB_RSP
+ XCTRLB_XDEC3DXA_0_Z1 VDD pch l=0.06U
+ w=0.75U
M5849 VDD XCTRLB_XDEC3DXA_0_Z1 B_XA_0
+ VDD pch_hvt l=0.06U
+ w=5U
M5850 XCTRLB_XALTCH_12_Z25 XCTRLB_XALTCH_12_AX
+ XCTRLB_XALTCH_12_Z1 VDD pch l=0.08U
+ w=0.42U
M5851 XCTRLB_XDEC3DXA_0_Z3 XCTRLB_AC_5
+ XCTRLB_XDEC3DXA_0_Z2 VSS nch l=0.06U
+ w=2U
M5852 XCTRLB_XDEC3DXA_1_Z3 XCTRLB_AT_5
+ XCTRLB_XDEC3DXA_1_Z2 VSS nch l=0.06U
+ w=2U
M5853 XCTRLB_XALTCH_12_Z1 XCTRLB_CKC
+ XCTRLB_XALTCH_12_Z28 VDD pch l=0.06U
+ w=0.21U
M5854 XCTRLB_XALTCH_12_Z1 XCTRLB_XALTCH_12_AX
+ XCTRLB_XALTCH_12_Z27 VSS nch l=0.08U
+ w=0.21U
M5855 XCTRLB_XALTCH_12_AX BISTC
+ XCTRLB_XALTCH_12_Z22 VDD pch l=0.08U
+ w=0.42U
M5856 XCTRLB_AC_12 XCTRLB_XALTCH_12_Z1
+ VSS VSS nch l=0.06U
+ w=0.55U
M5857 VDD XCTRLB_XALTCH_12_Z1
+ XCTRLB_AC_12 VDD pch l=0.06U
+ w=1.1U
M5858 VDD XCTRLB_AC_5 XCTRLB_XDEC3DXA_0_Z1
+ VDD pch l=0.06U
+ w=0.21U
M5859 VDD XCTRLB_AT_5 XCTRLB_XDEC3DXA_1_Z1
+ VDD pch l=0.06U
+ w=0.21U
M5860 VDD XCTRLB_RSP XCTRLB_XDEC3DXA_1_Z1
+ VDD pch l=0.06U
+ w=0.75U
M5861 VDD XCTRLB_XDEC3DXA_1_Z1 B_XA_1
+ VDD pch_hvt l=0.06U
+ w=5U
M5862 XCTRLB_XDEC3DXA_0_Z2 XCTRLB_CKP
+ XCTRLB_XDEC3DXA_0_Z1 VSS nch l=0.06U
+ w=2U
M5863 XCTRLB_XDEC3DXA_1_Z2 XCTRLB_CKP
+ XCTRLB_XDEC3DXA_1_Z1 VSS nch l=0.06U
+ w=2U
M5864 VDD AMB_12 XCTRLB_XALTCH_12_Z22 VDD
+ pch l=0.08U
+	 w=0.42U
M5865 XCTRLB_AC_12 XCTRLB_XALTCH_12_Z1
+ VSS VSS nch l=0.06U
+ w=0.55U
M5866 VDD XCTRLB_XALTCH_12_Z1
+ XCTRLB_AC_12 VDD pch l=0.06U
+ w=1.1U
M5867 VDD XCTRLB_CKP XCTRLB_XDEC3DXA_0_Z1
+ VDD pch l=0.06U
+ w=0.21U
M5868 VDD XCTRLB_CKP XCTRLB_XDEC3DXA_1_Z1
+ VDD pch l=0.06U
+ w=0.21U
M5869 VDD XCTRLB_RSP
+ XCTRLB_XDEC3DXA_1_Z1 VDD pch l=0.06U
+ w=0.75U
M5870 VDD XCTRLB_XDEC3DXA_1_Z1 B_XA_1
+ VDD pch_hvt l=0.06U
+ w=5U
M5871 XCTRLB_XALTCH_12_Z28 XCTRLB_AC_12 VDD
+ VDD pch l=0.06U
+ w=0.21U
M5872 VSS XCTRLB_CKC XCTRLB_XALTCH_12_Z27
+ VSS nch l=0.06U
+	 w=0.21U
M5873 XCTRLB_XALTCH_7_Z28 XCTRLB_AC_7 VDD
+ VDD pch l=0.06U
+ w=0.21U
M5874 XCTRLB_XALTCH_7_Z22 AMB_7 VDD VDD
+ pch l=0.08U
+	 w=0.42U
M5875 XCTRLB_XALTCH_7_Z27 XCTRLB_CKC VSS
+ VSS nch l=0.06U
+	 w=0.21U
M5876 XCTRLB_AC_7 XCTRLB_XALTCH_7_Z1
+ VSS VSS nch l=0.06U
+ w=0.55U
M5877 VDD XCTRLB_XALTCH_7_Z1
+ XCTRLB_AC_7 VDD pch l=0.06U
+ w=1.1U
M5878 VDD XCTRLB_CKP XCTRLB_XDEC3DXA_2_Z1
+ VDD pch l=0.06U
+ w=0.21U
M5879 VDD XCTRLB_CKP XCTRLB_XDEC3DXA_3_Z1
+ VDD pch l=0.06U
+ w=0.21U
M5880 VDD XCTRLB_RSP XCTRLB_XDEC3DXA_3_Z1
+ VDD pch l=0.06U
+ w=0.75U
M5881 VDD XCTRLB_XDEC3DXA_3_Z1 B_XA_3
+ VDD pch_hvt l=0.06U
+ w=5U
M5882 XCTRLB_XDEC3DXA_2_Z2 XCTRLB_CKP
+ XCTRLB_XDEC3DXA_2_Z1 VSS nch l=0.06U
+ w=2U
M5883 XCTRLB_XDEC3DXA_3_Z2 XCTRLB_CKP
+ XCTRLB_XDEC3DXA_3_Z1 VSS nch l=0.06U
+ w=2U
M5884 XCTRLB_XALTCH_7_AX BISTC
+ XCTRLB_XALTCH_7_Z22 VDD pch l=0.08U
+ w=0.42U
M5885 XCTRLB_AC_7 XCTRLB_XALTCH_7_Z1
+ VSS VSS nch l=0.06U
+ w=0.55U
M5886 VDD XCTRLB_XALTCH_7_Z1
+ XCTRLB_AC_7 VDD pch l=0.06U
+ w=1.1U
M5887 VDD XCTRLB_AC_5 XCTRLB_XDEC3DXA_2_Z1
+ VDD pch l=0.06U
+	 w=0.21U
M5888 VDD XCTRLB_AT_5 XCTRLB_XDEC3DXA_3_Z1
+ VDD pch l=0.06U
+ w=0.21U
M5889 VDD XCTRLB_RSP
+ XCTRLB_XDEC3DXA_3_Z1 VDD pch l=0.06U
+ w=0.75U
M5890 VDD XCTRLB_XDEC3DXA_3_Z1 B_XA_3
+ VDD pch_hvt l=0.06U
+ w=5U
M5891 XCTRLB_XALTCH_7_Z1 XCTRLB_CKC
+ XCTRLB_XALTCH_7_Z28 VDD pch l=0.06U
+ w=0.21U
M5892 XCTRLB_XALTCH_7_Z27 XCTRLB_XALTCH_7_AX
+ XCTRLB_XALTCH_7_Z1 VSS nch l=0.08U
+ w=0.21U
M5893 XCTRLB_XDEC3DXA_2_Z2 XCTRLB_AC_5
+ XCTRLB_XDEC3DXA_2_Z3 VSS nch l=0.06U
+ w=2U
M5894 XCTRLB_XDEC3DXA_3_Z2 XCTRLB_AT_5
+ XCTRLB_XDEC3DXA_3_Z3 VSS nch l=0.06U
+ w=2U
M5895 XCTRLB_XALTCH_7_Z26 XCTRLB_CKP
+ XCTRLB_XALTCH_7_Z1 VSS nch l=0.06U
+ w=0.21U
M5896 XCTRLB_XALTCH_7_AX BISTT
+ XCTRLB_XALTCH_7_Z21 VDD pch l=0.08U
+ w=0.42U
M5897 XCTRLB_XALTCH_7_Z1 XCTRLB_XALTCH_7_AX
+ XCTRLB_XALTCH_7_Z25 VDD pch l=0.08U
+ w=0.42U
M5898 XCTRLB_XDEC3DXA_2_Z3 XCTRLB_AT_6
+ XCTRLB_XDEC3DXA_2_Z4 VSS nch l=0.06U
+ w=2U
M5899 XCTRLB_XDEC3DXA_3_Z3 XCTRLB_AT_6
+ XCTRLB_XDEC3DXA_3_Z4 VSS nch l=0.06U
+ w=2U
M5900 XCTRLB_AT_7 XCTRLB_AC_7 VSS
+ VSS nch l=0.06U
+ w=0.55U
M5901 VDD XCTRLB_AC_7 XCTRLB_AT_7
+ VDD pch l=0.06U
+ w=1.1U
M5902 VDD XCTRLB_AT_6 XCTRLB_XDEC3DXA_2_Z1
+ VDD pch l=0.06U
+ w=0.21U
M5903 VDD XCTRLB_AT_6 XCTRLB_XDEC3DXA_3_Z1
+ VDD pch l=0.06U
+	 w=0.21U
M5904 VDD XCTRLB_RSP XCTRLB_XDEC3DXA_2_Z1
+ VDD pch l=0.06U
+ w=0.75U
M5905 VDD XCTRLB_XDEC3DXA_2_Z1 B_XA_2
+ VDD pch_hvt l=0.06U
+ w=5U
M5906 VDD AB_7 XCTRLB_XALTCH_7_Z21 VDD
+ pch l=0.08U
+	 w=0.42U
M5907 XCTRLB_AT_7 XCTRLB_AC_7 VSS VSS
+ nch l=0.06U
+ w=0.55U
M5908 VDD XCTRLB_AC_7 XCTRLB_AT_7 VDD
+ pch l=0.06U
+ w=1.1U
M5909 VDD XCTRLB_AC_7 XCTRLB_XDEC3DXA_2_Z1
+ VDD pch l=0.06U
+ w=0.21U
M5910 VDD XCTRLB_AC_7 XCTRLB_XDEC3DXA_3_Z1
+ VDD pch l=0.06U
+ w=0.21U
M5911 VDD XCTRLB_RSP
+ XCTRLB_XDEC3DXA_2_Z1 VDD pch l=0.06U
+ w=0.75U
M5912 VDD XCTRLB_XDEC3DXA_2_Z1 B_XA_2
+ VDD pch_hvt l=0.06U
+ w=5U
M5913 VDD XCTRLB_CKP XCTRLB_XALTCH_7_Z25
+ VDD pch l=0.06U
+ w=0.42U
M5914 XCTRLB_XDEC3DXA_2_Z4 XCTRLB_AC_7 VSS
+ VSS nch l=0.06U
+ w=2U
M5915 XCTRLB_XDEC3DXA_3_Z4 XCTRLB_AC_7 VSS
+ VSS nch l=0.06U
+ w=2U
M5916 XCTRLB_XALTCH_7_Z26 XCTRLB_AC_7 VSS
+ VSS nch l=0.06U
+	 w=0.21U
M5917 VSS XCTRLB_AT_7 XCTRLB_XDEC3DXA_4_Z4
+ VSS nch l=0.06U
+ w=2U
M5918 VSS XCTRLB_AT_7 XCTRLB_XDEC3DXA_5_Z4
+ VSS nch l=0.06U
+ w=2U
M5919 VSS XCTRLB_AC_6 XCTRLB_XALTCH_6_Z26
+ VSS nch l=0.06U
+	 w=0.21U
M5920 VDD XCTRLB_CKP XCTRLB_XALTCH_6_Z25
+ VDD pch l=0.06U
+ w=0.42U
M5921 VDD AB_6 XCTRLB_XALTCH_6_Z21 VDD
+ pch l=0.08U
+	 w=0.42U
M5922 XCTRLB_AT_6 XCTRLB_AC_6 VSS
+ VSS nch l=0.06U
+ w=0.55U
M5923 VDD XCTRLB_AC_6 XCTRLB_AT_6
+ VDD pch l=0.06U
+ w=1.1U
M5924 VDD XCTRLB_AT_7 XCTRLB_XDEC3DXA_4_Z1
+ VDD pch l=0.06U
+ w=0.21U
M5925 VDD XCTRLB_AT_7 XCTRLB_XDEC3DXA_5_Z1
+ VDD pch l=0.06U
+ w=0.21U
M5926 VDD XCTRLB_RSP XCTRLB_XDEC3DXA_4_Z1
+ VDD pch l=0.06U
+ w=0.75U
M5927 VDD XCTRLB_XDEC3DXA_4_Z1 B_XA_4
+ VDD pch_hvt l=0.06U
+ w=5U
M5928 XCTRLB_XDEC3DXA_4_Z4 XCTRLB_AC_6
+ XCTRLB_XDEC3DXA_4_Z3 VSS nch l=0.06U
+ w=2U
M5929 XCTRLB_XDEC3DXA_5_Z4 XCTRLB_AC_6
+ XCTRLB_XDEC3DXA_5_Z3 VSS nch l=0.06U
+ w=2U
M5930 XCTRLB_XALTCH_6_Z26 XCTRLB_CKP
+ XCTRLB_XALTCH_6_Z1 VSS nch l=0.06U
+ w=0.21U
M5931 XCTRLB_XALTCH_6_AX BISTT
+ XCTRLB_XALTCH_6_Z21 VDD pch l=0.08U
+ w=0.42U
M5932 XCTRLB_AT_6 XCTRLB_AC_6 VSS VSS
+ nch l=0.06U
+ w=0.55U
M5933 VDD XCTRLB_AC_6 XCTRLB_AT_6 VDD
+ pch l=0.06U
+ w=1.1U
M5934 VDD XCTRLB_AC_6 XCTRLB_XDEC3DXA_4_Z1
+ VDD pch l=0.06U
+ w=0.21U
M5935 VDD XCTRLB_AC_6 XCTRLB_XDEC3DXA_5_Z1
+ VDD pch l=0.06U
+ w=0.21U
M5936 VDD XCTRLB_RSP
+ XCTRLB_XDEC3DXA_4_Z1 VDD pch l=0.06U
+ w=0.75U
M5937 VDD XCTRLB_XDEC3DXA_4_Z1 B_XA_4
+ VDD pch_hvt l=0.06U
+ w=5U
M5938 XCTRLB_XALTCH_6_Z25 XCTRLB_XALTCH_6_AX
+ XCTRLB_XALTCH_6_Z1 VDD pch l=0.08U
+ w=0.42U
M5939 XCTRLB_XDEC3DXA_4_Z3 XCTRLB_AC_5
+ XCTRLB_XDEC3DXA_4_Z2 VSS nch l=0.06U
+ w=2U
M5940 XCTRLB_XDEC3DXA_5_Z3 XCTRLB_AT_5
+ XCTRLB_XDEC3DXA_5_Z2 VSS nch l=0.06U
+ w=2U
M5941 XCTRLB_XALTCH_6_Z1 XCTRLB_CKC
+ XCTRLB_XALTCH_6_Z28 VDD pch l=0.06U
+ w=0.21U
M5942 XCTRLB_XALTCH_6_Z1 XCTRLB_XALTCH_6_AX
+ XCTRLB_XALTCH_6_Z27 VSS nch l=0.08U
+ w=0.21U
M5943 XCTRLB_XALTCH_6_AX BISTC
+ XCTRLB_XALTCH_6_Z22 VDD pch l=0.08U
+ w=0.42U
M5944 XCTRLB_AC_6 XCTRLB_XALTCH_6_Z1
+ VSS VSS nch l=0.06U
+ w=0.55U
M5945 VDD XCTRLB_XALTCH_6_Z1
+ XCTRLB_AC_6 VDD pch l=0.06U
+ w=1.1U
M5946 VDD XCTRLB_AC_5 XCTRLB_XDEC3DXA_4_Z1
+ VDD pch l=0.06U
+ w=0.21U
M5947 VDD XCTRLB_AT_5 XCTRLB_XDEC3DXA_5_Z1
+ VDD pch l=0.06U
+ w=0.21U
M5948 VDD XCTRLB_RSP XCTRLB_XDEC3DXA_5_Z1
+ VDD pch l=0.06U
+ w=0.75U
M5949 VDD XCTRLB_XDEC3DXA_5_Z1 B_XA_5
+ VDD pch_hvt l=0.06U
+ w=5U
M5950 XCTRLB_XDEC3DXA_4_Z2 XCTRLB_CKP
+ XCTRLB_XDEC3DXA_4_Z1 VSS nch l=0.06U
+ w=2U
M5951 XCTRLB_XDEC3DXA_5_Z2 XCTRLB_CKP
+ XCTRLB_XDEC3DXA_5_Z1 VSS nch l=0.06U
+ w=2U
M5952 VDD XCTRLB_CKP XCTRLB_XDWLDV_DWLC
+ VDD pch l=0.06U
+	 w=0.61U
M5953 VDD XCTRLB_XDWLDV_DWLC B_DWL VDD
+ pch_hvt l=0.06U
+	 w=2.5U
M5954 VDD XCTRLB_XDWLDV_DWLC B_DWL
+ VDD pch_hvt l=0.06U
+	 w=2.5U
M5955 VDD XCTRLB_XDWLDV_DWLC B_DWL
+ VDD pch_hvt l=0.06U
+	 w=2.5U
M5956 VDD AMB_6 XCTRLB_XALTCH_6_Z22 VDD
+ pch l=0.08U
+	 w=0.42U
M5957 XCTRLB_AC_6 XCTRLB_XALTCH_6_Z1
+ VSS VSS nch l=0.06U
+ w=0.55U
M5958 VDD XCTRLB_XALTCH_6_Z1
+ XCTRLB_AC_6 VDD pch l=0.06U
+ w=1.1U
M5959 VDD XCTRLB_CKP XCTRLB_XDEC3DXA_4_Z1
+ VDD pch l=0.06U
+ w=0.21U
M5960 VDD XCTRLB_CKP XCTRLB_XDEC3DXA_5_Z1
+ VDD pch l=0.06U
+ w=0.21U
M5961 VDD XCTRLB_RSP
+ XCTRLB_XDEC3DXA_5_Z1 VDD pch l=0.06U
+ w=0.75U
M5962 VDD XCTRLB_XDEC3DXA_5_Z1 B_XA_5
+ VDD pch_hvt l=0.06U
+ w=5U
M5963 XCTRLB_XALTCH_6_Z28 XCTRLB_AC_6 VDD
+ VDD pch l=0.06U
+ w=0.21U
M5964 VSS XCTRLB_CKC XCTRLB_XALTCH_6_Z27
+ VSS nch l=0.06U
+	 w=0.21U
M5965 XCTRLB_XALTCH_5_Z28 XCTRLB_AC_5 VDD
+ VDD pch l=0.06U
+ w=0.21U
M5966 XCTRLB_XALTCH_5_Z22 AMB_5 VDD VDD
+ pch l=0.08U
+ w=0.42U
M5967 XCTRLB_XALTCH_5_Z27 XCTRLB_CKC VSS
+ VSS nch l=0.06U
+	 w=0.21U
M5968 XCTRLB_AC_5 XCTRLB_XALTCH_5_Z1
+ VSS VSS nch l=0.06U
+ w=0.55U
M5969 VDD XCTRLB_XALTCH_5_Z1
+ XCTRLB_AC_5 VDD pch l=0.06U
+ w=1.1U
M5970 VDD XCTRLB_CKP XCTRLB_XDEC3DXA_6_Z1
+ VDD pch l=0.06U
+ w=0.21U
M5971 VDD XCTRLB_CKP XCTRLB_XDEC3DXA_7_Z1
+ VDD pch l=0.06U
+ w=0.21U
M5972 VDD XCTRLB_RSP XCTRLB_XDEC3DXA_7_Z1
+ VDD pch l=0.06U
+ w=0.75U
M5973 VDD XCTRLB_XDEC3DXA_7_Z1 B_XA_7
+ VDD pch_hvt l=0.06U
+ w=5U
M5974 XCTRLB_XDEC3DXA_6_Z2 XCTRLB_CKP
+ XCTRLB_XDEC3DXA_6_Z1 VSS nch l=0.06U
+ w=2U
M5975 XCTRLB_XDEC3DXA_7_Z2 XCTRLB_CKP
+ XCTRLB_XDEC3DXA_7_Z1 VSS nch l=0.06U
+ w=2U
M5976 XCTRLB_XALTCH_5_AX BISTC
+ XCTRLB_XALTCH_5_Z22 VDD pch l=0.08U
+ w=0.42U
M5977 XCTRLB_AC_5 XCTRLB_XALTCH_5_Z1
+ VSS VSS nch l=0.06U
+ w=0.55U
M5978 VDD XCTRLB_XALTCH_5_Z1
+ XCTRLB_AC_5 VDD pch l=0.06U
+ w=1.1U
M5979 VDD XCTRLB_AC_5 XCTRLB_XDEC3DXA_6_Z1
+ VDD pch l=0.06U
+ w=0.21U
M5980 VDD XCTRLB_AT_5 XCTRLB_XDEC3DXA_7_Z1
+ VDD pch l=0.06U
+ w=0.21U
M5981 VDD XCTRLB_RSP
+ XCTRLB_XDEC3DXA_7_Z1 VDD pch l=0.06U
+ w=0.75U
M5982 VDD XCTRLB_XDEC3DXA_7_Z1 B_XA_7
+ VDD pch_hvt l=0.06U
+ w=5U
M5983 XCTRLB_XALTCH_5_Z1 XCTRLB_CKC
+ XCTRLB_XALTCH_5_Z28 VDD pch l=0.06U
+ w=0.21U
M5984 XCTRLB_XALTCH_5_Z1 XCTRLB_XALTCH_5_AX
+ XCTRLB_XALTCH_5_Z27 VSS nch l=0.08U
+ w=0.21U
M5985 XCTRLB_XDEC3DXA_6_Z2 XCTRLB_AC_5
+ XCTRLB_XDEC3DXA_6_Z3 VSS nch l=0.06U
+ w=2U
M5986 XCTRLB_XDEC3DXA_7_Z2 XCTRLB_AT_5
+ XCTRLB_XDEC3DXA_7_Z3 VSS nch l=0.06U
+ w=2U
M5987 XCTRLB_XALTCH_5_Z26 XCTRLB_CKP
+ XCTRLB_XALTCH_5_Z1 VSS nch l=0.06U
+ w=0.21U
M5988 XCTRLB_XALTCH_5_AX BISTT
+ XCTRLB_XALTCH_5_Z21 VDD pch l=0.08U
+ w=0.42U
M5989 XCTRLB_XALTCH_5_Z1 XCTRLB_XALTCH_5_AX
+ XCTRLB_XALTCH_5_Z25 VDD pch l=0.08U
+ w=0.42U
M5990 XCTRLB_XDEC3DXA_6_Z3 XCTRLB_AT_6
+ XCTRLB_XDEC3DXA_6_Z4 VSS nch l=0.06U
+ w=2U
M5991 XCTRLB_XDEC3DXA_7_Z3 XCTRLB_AT_6
+ XCTRLB_XDEC3DXA_7_Z4 VSS nch l=0.06U
+ w=2U
M5992 XCTRLB_AT_5 XCTRLB_AC_5 VSS VSS
+ nch l=0.06U
+ w=0.55U
M5993 VDD XCTRLB_AC_5 XCTRLB_AT_5
+ VDD pch l=0.06U
+ w=1.1U
M5994 VDD XCTRLB_AT_6 XCTRLB_XDEC3DXA_6_Z1
+ VDD pch l=0.06U
+ w=0.21U
M5995 VDD XCTRLB_AT_6 XCTRLB_XDEC3DXA_7_Z1
+ VDD pch l=0.06U
+ w=0.21U
M5996 VDD XCTRLB_RSP
+ XCTRLB_XDEC3DXA_6_Z1 VDD pch l=0.06U
+ w=0.75U
M5997 VDD XCTRLB_XDEC3DXA_6_Z1 B_XA_6
+ VDD pch_hvt l=0.06U
+ w=5U
M5998 VDD AB_5 XCTRLB_XALTCH_5_Z21 VDD
+ pch l=0.08U
+	 w=0.42U
M5999 XCTRLB_AT_5 XCTRLB_AC_5 VSS
+ VSS nch l=0.06U
+	 w=0.55U
M6000 VDD XCTRLB_AC_5 XCTRLB_AT_5 VDD
+ pch l=0.06U
+ w=1.1U
M6001 VDD XCTRLB_AT_7 XCTRLB_XDEC3DXA_6_Z1
+ VDD pch l=0.06U
+ w=0.21U
M6002 VDD XCTRLB_AT_7 XCTRLB_XDEC3DXA_7_Z1
+ VDD pch l=0.06U
+ w=0.21U
M6003 VDD XCTRLB_RSP XCTRLB_XDEC3DXA_6_Z1
+ VDD pch l=0.06U
+ w=0.75U
M6004 VDD XCTRLB_XDEC3DXA_6_Z1 B_XA_6
+ VDD pch_hvt l=0.06U
+ w=5U
M6005 XCTRLB_XALTCH_5_Z25 XCTRLB_CKP VDD
+ VDD pch l=0.06U
+	 w=0.42U
M6006 XCTRLB_XDEC3DXA_6_Z4 XCTRLB_AT_7 VSS
+ VSS nch l=0.06U
+ w=2U
M6007 XCTRLB_XDEC3DXA_7_Z4 XCTRLB_AT_7 VSS
+ VSS nch l=0.06U
+ w=2U
M6008 XCTRLB_XALTCH_5_Z26 XCTRLB_AC_5 VSS
+ VSS nch l=0.06U
+	 w=0.21U
M6009 XCTRLB_XDEC3DZ_0_Z4 XCTRLB_AC_15 VSS
+ VSS nch l=0.06U
+ w=2U
M6010 XCTRLB_XDEC3DZ_1_Z4 XCTRLB_AC_15 VSS
+ VSS nch l=0.06U
+ w=2U
M6011 XCTRLB_XALTCH_13_Z26 XCTRLB_AC_13 VSS
+ VSS nch l=0.06U
+	 w=0.21U
M6012 XCTRLB_XALTCH_13_Z25 XCTRLB_CKP VDD
+ VDD pch l=0.06U
+ w=0.42U
M6013 XCTRLB_XALTCH_13_Z21 AB_13 VDD VDD
+ pch l=0.08U
+	 w=0.42U
M6014 XCTRLB_AT_13 XCTRLB_AC_13 VSS
+ VSS nch l=0.06U
+	 w=0.55U
M6015 VDD XCTRLB_AC_13 XCTRLB_AT_13
+ VDD pch l=0.06U
+ w=1.1U
M6016 VDD XCTRLB_AC_15 XCTRLB_XDEC3DZ_0_Z1
+ VDD pch l=0.06U
+ w=0.21U
M6017 VDD XCTRLB_AC_15 XCTRLB_XDEC3DZ_1_Z1
+ VDD pch l=0.06U
+ w=0.21U
M6018 VDD XCTRLB_RSP XCTRLB_XDEC3DZ_0_Z1
+ VDD pch l=0.06U
+ w=0.75U
M6019 VDD XCTRLB_XDEC3DZ_0_Z1 B_Z_0
+ VDD pch_hvt l=0.06U
+ w=5U
M6020 XCTRLB_XDEC3DZ_0_Z4 XCTRLB_AC_14
+ XCTRLB_XDEC3DZ_0_Z3 VSS nch l=0.06U
+ w=2U
M6021 XCTRLB_XDEC3DZ_1_Z4 XCTRLB_AC_14
+ XCTRLB_XDEC3DZ_1_Z3 VSS nch l=0.06U
+ w=2U
M6022 XCTRLB_XALTCH_13_Z26 XCTRLB_CKP
+ XCTRLB_XALTCH_13_Z1 VSS nch l=0.06U
+ w=0.21U
M6023 XCTRLB_XALTCH_13_AX BISTT
+ XCTRLB_XALTCH_13_Z21 VDD pch l=0.08U
+ w=0.42U
M6024 XCTRLB_AT_13 XCTRLB_AC_13 VSS
+ VSS nch l=0.06U
+ w=0.55U
M6025 VDD XCTRLB_AC_13 XCTRLB_AT_13
+ VDD pch l=0.06U
+ w=1.1U
M6026 VDD XCTRLB_AC_14 XCTRLB_XDEC3DZ_0_Z1
+ VDD pch l=0.06U
+	 w=0.21U
M6027 VDD XCTRLB_AC_14 XCTRLB_XDEC3DZ_1_Z1
+ VDD pch l=0.06U
+	 w=0.21U
M6028 VDD XCTRLB_RSP XCTRLB_XDEC3DZ_0_Z1
+ VDD pch l=0.06U
+ w=0.75U
M6029 VDD XCTRLB_XDEC3DZ_0_Z1 B_Z_0
+ VDD pch_hvt l=0.06U
+ w=5U
M6030 XCTRLB_XALTCH_13_Z25 XCTRLB_XALTCH_13_AX
+ XCTRLB_XALTCH_13_Z1 VDD pch l=0.08U
+ w=0.42U
M6031 XCTRLB_XDEC3DZ_0_Z3 XCTRLB_AC_13
+ XCTRLB_XDEC3DZ_0_Z2 VSS nch l=0.06U
+ w=2U
M6032 XCTRLB_XDEC3DZ_1_Z3 XCTRLB_AT_13
+ XCTRLB_XDEC3DZ_1_Z2 VSS nch l=0.06U
+ w=2U
M6033 XCTRLB_XALTCH_13_Z1 XCTRLB_CKC
+ XCTRLB_XALTCH_13_Z28 VDD pch l=0.06U
+ w=0.21U
M6034 XCTRLB_XALTCH_13_Z1 XCTRLB_XALTCH_13_AX
+ XCTRLB_XALTCH_13_Z27 VSS nch l=0.08U
+ w=0.21U
M6035 XCTRLB_XALTCH_13_AX BISTC
+ XCTRLB_XALTCH_13_Z22 VDD pch l=0.08U
+ w=0.42U
M6036 XCTRLB_AC_13 XCTRLB_XALTCH_13_Z1
+ VSS VSS nch l=0.06U
+ w=0.55U
M6037 VDD XCTRLB_XALTCH_13_Z1
+ XCTRLB_AC_13 VDD pch l=0.06U
+ w=1.1U
M6038 VDD XCTRLB_AC_13 XCTRLB_XDEC3DZ_0_Z1
+ VDD pch l=0.06U
+ w=0.21U
M6039 VDD XCTRLB_AT_13 XCTRLB_XDEC3DZ_1_Z1
+ VDD pch l=0.06U
+ w=0.21U
M6040 VDD XCTRLB_RSP XCTRLB_XDEC3DZ_1_Z1
+ VDD pch l=0.06U
+ w=0.75U
M6041 VDD XCTRLB_XDEC3DZ_1_Z1 B_Z_1
+ VDD pch_hvt l=0.06U
+ w=5U
M6042 XCTRLB_XDEC3DZ_0_Z2 XCTRLB_CKP
+ XCTRLB_XDEC3DZ_0_Z1 VSS nch l=0.06U
+ w=2U
M6043 XCTRLB_XDEC3DZ_1_Z2 XCTRLB_CKP
+ XCTRLB_XDEC3DZ_1_Z1 VSS nch l=0.06U
+ w=2U
M6044 VDD AMB_13 XCTRLB_XALTCH_13_Z22 VDD
+ pch l=0.08U
+	 w=0.42U
M6045 XCTRLB_AC_13 XCTRLB_XALTCH_13_Z1
+ VSS VSS nch l=0.06U
+ w=0.55U
M6046 VDD XCTRLB_XALTCH_13_Z1
+ XCTRLB_AC_13 VDD pch l=0.06U
+ w=1.1U
M6047 VDD XCTRLB_CKP XCTRLB_XDEC3DZ_0_Z1
+ VDD pch l=0.06U
+ w=0.21U
M6048 VDD XCTRLB_CKP XCTRLB_XDEC3DZ_1_Z1
+ VDD pch l=0.06U
+ w=0.21U
M6049 VDD XCTRLB_RSP XCTRLB_XDEC3DZ_1_Z1
+ VDD pch l=0.06U
+ w=0.75U
M6050 VDD XCTRLB_XDEC3DZ_1_Z1 B_Z_1
+ VDD pch_hvt l=0.06U
+ w=5U
M6051 XCTRLB_XALTCH_13_Z28 XCTRLB_AC_13 VDD
+ VDD pch l=0.06U
+ w=0.21U
M6052 VSS XCTRLB_CKC XCTRLB_XALTCH_13_Z27
+ VSS nch l=0.06U
+	 w=0.21U
M6053 XCTRLB_XDLRSD_Z7 XCTRLB_XDLRSD_Z6
+ VSS VSS nch l=0.06U
+ w=0.41U
M6054 XCTRLB_XDLRSD_Z7
+ XCTRLB_XDLRSD_Z6 VSS VSS nch
+ l=0.06U
+ w=0.41U
M6055 XCTRLB_XDLRSD_Z7
+ XCTRLB_XDLRSD_Z6 VSS VSS nch
+ l=0.06U
+ w=0.41U
M6056 XCTRLB_XDLRSD_Z7
+ XCTRLB_XDLRSD_Z6 VSS VSS nch
+ l=0.06U
+ w=0.41U
M6057 XCTRLB_XDLRSD_Z6 XCTRLB_XDLRSD_Z5
+ VSS VSS nch l=0.06U
+ w=0.41U
M6058 XCTRLB_XDLRSD_Z6
+ XCTRLB_XDLRSD_Z5 VSS VSS nch
+ l=0.06U
+ w=0.41U
M6059 XCTRLB_XDLRSD_Z6
+ XCTRLB_XDLRSD_Z5 VSS VSS nch
+ l=0.06U
+ w=0.41U
M6060 XCTRLB_XDLRSD_Z5 XCTRLB_XDLRSD_Z4
+ VSS VSS nch l=0.08U
+ w=0.41U
M6061 B_DLRS XCTRLB_XDLRSD_Z7 VSS VSS
+ nch l=0.06U
+ w=0.75U
M6062 B_DLRS XCTRLB_XDLRSD_Z7 VSS
+ VSS nch l=0.06U
+ w=0.75U
M6063 B_DLRS XCTRLB_XDLRSD_Z7 VSS
+ VSS nch l=0.06U
+ w=0.75U
M6064 B_DLRS XCTRLB_XDLRSD_Z7 VSS
+ VSS nch l=0.06U
+ w=0.75U
M6065 B_DLRS XCTRLB_XDLRSD_Z7 VSS
+ VSS nch l=0.06U
+ w=0.75U
M6066 B_DLRS XCTRLB_XDLRSD_Z7 VSS
+ VSS nch l=0.06U
+ w=0.75U
M6067 B_DLRS XCTRLB_XDLRSD_Z7 VSS
+ VSS nch l=0.06U
+ w=0.75U
M6068 B_DLRS XCTRLB_XDLRSD_Z7 VSS
+ VSS nch l=0.06U
+ w=0.75U
M6069 B_DLRS XCTRLB_XDLRSD_Z7 VSS
+ VSS nch l=0.06U
+ w=0.75U
M6070 B_DLRS XCTRLB_XDLRSD_Z7 VSS
+ VSS nch l=0.06U
+ w=0.75U
M6071 VSS XCTRLB_XDLRSD_Z37
+ XCTRLB_XDLRSD_XI74_NET9 VSS nch l=0.14U
+ w=0.41U
M6072 XCTRLB_XDLRSD_Z37 XCTRLB_XDLRSD_Z36
+ VSS VSS nch l=0.06U
+ w=0.41U
M6073 XCTRLB_XDLRSD_Z4 XCTRLB_XDLRSD_Z3
+ VSS VSS nch l=0.06U
+ w=0.41U
M6074 XCTRLB_XDLRSD_Z3 XCTRLB_XDLRSD_Z2
+ VSS VSS nch l=0.08U
+ w=0.21U
M6075 XCTRLB_XDLRSD_XND1_NET9 XCTRLB_XDLRSD_Z38
+ VSS VSS nch l=0.06U
+ w=0.41U
M6076 XCTRLB_XDLRSD_Z1 B_RD VSS VSS
+ nch l=0.06U
+ w=0.41U
M6077 XCTRLB_XDLRSD_Z33 XCTRLB_XDLRSD_Z32
+ VSS VSS nch l=0.06U
+ w=0.41U
M6078 XCTRLB_XDLRSD_Z34 XCTRLB_XDLRSD_Z33
+ VSS VSS nch l=0.14U
+ w=0.41U
M6079 XCTRLB_XDLRSD_Z2 XCTRLB_XDLRSD_Z1
+ XCTRLB_XDLRSD_XND1_NET9 VSS nch l=0.06U
+ w=0.41U
M6080 XCTRLB_XDLRSD_XI74_NET9 XCTRLB_XDLRSD_Z29
+ XCTRLB_XDLRSD_Z38 VSS nch l=0.14U
+ w=0.41U
M6081 XCTRLB_XDLRSD_Z32 XCTRLB_XDLRSD_Z31
+ VSS VSS nch l=0.14U
+ w=0.41U
M6082 XCTRLB_XDLRSD_Z35 XCTRLB_XDLRSD_Z34
+ VSS VSS nch l=0.06U
+ w=0.41U
M6083 XCTRLB_XDLRSD_Z36 XCTRLB_XDLRSD_Z35
+ VSS VSS nch l=0.14U
+ w=0.41U
M6084 XCTRLB_XDLRSD_Z23 XCTRLB_XDLRSD_Z22
+ VSS VSS nch l=0.06U
+ w=0.41U
M6085 XCTRLB_XDLRSD_Z26 XCTRLB_XDLRSD_Z25
+ VSS VSS nch l=0.14U
+ w=0.41U
M6086 XCTRLB_XDLRSD_Z25 XCTRLB_XDLRSD_Z24
+ VSS VSS nch l=0.06U
+ w=0.41U
M6087 XCTRLB_XDLRSD_Z28 XCTRLB_XDLRSD_Z27
+ VSS VSS nch l=0.14U
+ w=0.41U
M6088 XCTRLB_XDLRSD_Z27 XCTRLB_XDLRSD_Z26
+ VSS VSS nch l=0.06U
+ w=0.41U
M6089 XCTRLB_XDLRSD_Z24 XCTRLB_XDLRSD_Z23
+ VSS VSS nch l=0.14U
+ w=0.41U
M6090 XCTRLB_XDLRSD_Z22 XCTRLB_XDLRSD_Z21
+ VSS VSS nch l=0.14U
+ w=0.41U
M6091 XCTRLB_XDLRSD_Z21 XCTRLB_XDLRSD_Z20
+ VSS VSS nch l=0.06U
+ w=0.41U
M6092 VSS XCTRLB_XDLRSD_Z15
+ XCTRLB_XDLRSD_XND5_NET14 VSS nch
+ l=0.08U
+ w=0.41U
M6093 XCTRLB_XDLRSD_XND5_NET14
+	XCTRLB_XDLRSD_Z11 XCTRLB_XDLRSD_XND5_NET17 VSS
+ nch l=0.08U
+ w=0.41U
M6094 XCTRLB_XDLRSD_Z20 XCTRLB_XDLRSD_Z1
+ XCTRLB_XDLRSD_XND5_NET17 VSS nch
+ l=0.08U
+ w=0.41U
M6095 XCTRLB_XDLRSD_Z29 XCTRLB_XDLRSD_Z28
+ VSS VSS nch l=0.06U
+ w=0.41U
M6096 XCTRLB_XDLRSD_Z31 XCTRLB_XDLRSD_Z30
+ VSS VSS nch l=0.06U
+ w=0.41U
M6097 XCTRLB_XDLRSD_Z30 XCTRLB_XDLRSD_Z29
+ VSS VSS nch l=0.14U
+ w=0.41U
M6098 VSS XCTRLB_XDLRSD_Z12
+ XCTRLB_XDLRSD_XND4_NET9 VSS nch l=0.06U
+ w=0.41U
M6099 XCTRLB_XDLRSD_XND3_NET9 VS_0
+ XCTRLB_XDLRSD_Z11 VSS nch l=0.06U
+ w=0.41U
M6100 XCTRLB_XDLRSD_Z15
+ XCTRLB_XDLRSD_Z14 VSS VSS nch
+ l=0.06U
+ w=0.21U
M6101 VSS XCTRLB_XDLRSD_Z10
+ XCTRLB_XDLRSD_XND3_NET9 VSS nch l=0.06U
+ w=0.41U
M6102 XCTRLB_XDLRSD_XND2_NET9 XCTRLB_XDLRSD_Z15
+ VSS VSS nch l=0.08U
+ w=0.41U
M6103 XCTRLB_XDLRSD_Z14
+ XCTRLB_XDLRSD_Z13 VSS VSS nch
+ l=0.08U
+ w=0.21U
M6104 XCTRLB_XDLRSD_Z10 XCTRLB_XDLRSD_Z1
+ XCTRLB_XDLRSD_XND2_NET9 VSS nch l=0.08U
+ w=0.41U
M6105 XCTRLB_XDLRSD_XND4_NET9 VS_1
+ XCTRLB_XDLRSD_Z13 VSS nch l=0.06U
+ w=0.41U
M6106 XCTRLB_XDLRSD_Z12
+ XCTRLB_XDLRSD_Z1 VSS VSS nch
+ l=0.08U
+ w=0.21U
M6107 VDD XCTRLB_XDLRSD_Z6
+ XCTRLB_XDLRSD_Z7 VDD pch l=0.06U
+ w=1.4U
M6108 VDD XCTRLB_XDLRSD_Z6
+ XCTRLB_XDLRSD_Z7 VDD pch l=0.06U
+ w=1.4U
M6109 VDD XCTRLB_XDLRSD_Z6
+ XCTRLB_XDLRSD_Z7 VDD pch l=0.06U
+ w=1.4U
M6110 VDD XCTRLB_XDLRSD_Z6
+ XCTRLB_XDLRSD_Z7 VDD pch l=0.06U
+ w=1.4U
M6111 VDD XCTRLB_XDLRSD_Z5
+ XCTRLB_XDLRSD_Z6 VDD pch l=0.08U
+ w=0.6U
M6112 VDD XCTRLB_XDLRSD_Z5
+ XCTRLB_XDLRSD_Z6 VDD pch l=0.08U
+ w=0.6U
M6113 VDD XCTRLB_XDLRSD_Z5
+ XCTRLB_XDLRSD_Z6 VDD pch l=0.08U
+ w=0.6U
M6114 VDD XCTRLB_XDLRSD_Z4
+ XCTRLB_XDLRSD_Z5 VDD pch l=0.06U
+ w=0.41U
M6115 VDD XCTRLB_XDLRSD_Z4
+ XCTRLB_XDLRSD_Z5 VDD pch l=0.06U
+ w=0.41U
M6116 VDD XCTRLB_XDLRSD_Z7 B_DLRS VDD
+ pch l=0.06U
+	 w=1.5U
M6117 VDD XCTRLB_XDLRSD_Z7 B_DLRS
+ VDD pch l=0.06U
+ w=1.5U
M6118 VDD XCTRLB_XDLRSD_Z7 B_DLRS
+ VDD pch l=0.06U
+	 w=1.5U
M6119 VDD XCTRLB_XDLRSD_Z7 B_DLRS
+ VDD pch l=0.06U
+ w=1.5U
M6120 VDD XCTRLB_XDLRSD_Z7 B_DLRS
+ VDD pch l=0.06U
+ w=1.5U
M6121 VDD XCTRLB_XDLRSD_Z7 B_DLRS
+ VDD pch l=0.06U
+ w=1.5U
M6122 VDD XCTRLB_XDLRSD_Z7 B_DLRS
+ VDD pch l=0.06U
+	 w=1.5U
M6123 VDD XCTRLB_XDLRSD_Z7 B_DLRS
+ VDD pch l=0.06U
+ w=1.5U
M6124 VDD XCTRLB_XDLRSD_Z7 B_DLRS
+ VDD pch l=0.06U
+ w=1.5U
M6125 VDD XCTRLB_XDLRSD_Z7 B_DLRS
+ VDD pch l=0.06U
+	 w=1.5U
M6126 VDD XCTRLB_XDLRSD_Z37
+ XCTRLB_XDLRSD_Z38 VDD pch l=0.06U
+ w=0.41U
M6127 VDD XCTRLB_XDLRSD_Z36
+ XCTRLB_XDLRSD_Z37 VDD pch l=0.14U
+ w=0.41U
M6128 VDD XCTRLB_XDLRSD_Z3
+ XCTRLB_XDLRSD_Z4 VDD pch l=0.08U
+ w=0.41U
M6129 VDD XCTRLB_XDLRSD_Z2
+ XCTRLB_XDLRSD_Z3 VDD pch l=0.06U
+ w=0.41U
M6130 VDD XCTRLB_XDLRSD_Z38
+ XCTRLB_XDLRSD_Z2 VDD pch l=0.1U
+ w=0.41U
M6131 VDD B_RD XCTRLB_XDLRSD_Z1 VDD
+ pch l=0.06U
+ w=0.41U
M6132 VDD B_RD XCTRLB_XDLRSD_Z1
+ VDD pch l=0.06U
+	 w=0.41U
M6133 VDD XCTRLB_XDLRSD_Z32
+ XCTRLB_XDLRSD_Z33 VDD pch l=0.14U
+ w=0.41U
M6134 VDD XCTRLB_XDLRSD_Z33
+ XCTRLB_XDLRSD_Z34 VDD pch l=0.06U
+ w=0.41U
M6135 VDD XCTRLB_XDLRSD_Z1
+ XCTRLB_XDLRSD_Z2 VDD pch l=0.06U
+ w=0.41U
M6136 VDD XCTRLB_XDLRSD_Z29
+ XCTRLB_XDLRSD_Z38 VDD pch l=0.06U
+ w=0.41U
M6137 VDD XCTRLB_XDLRSD_Z31
+ XCTRLB_XDLRSD_Z32 VDD pch l=0.06U
+ w=0.41U
M6138 VDD XCTRLB_XDLRSD_Z34
+ XCTRLB_XDLRSD_Z35 VDD pch l=0.14U
+ w=0.41U
M6139 VDD XCTRLB_XDLRSD_Z35
+ XCTRLB_XDLRSD_Z36 VDD pch l=0.06U
+ w=0.41U
M6140 VDD XCTRLB_XDLRSD_Z22
+ XCTRLB_XDLRSD_Z23 VDD pch l=0.14U
+ w=0.41U
M6141 VDD XCTRLB_XDLRSD_Z25
+ XCTRLB_XDLRSD_Z26 VDD pch l=0.06U
+ w=0.41U
M6142 VDD XCTRLB_XDLRSD_Z24
+ XCTRLB_XDLRSD_Z25 VDD pch l=0.14U
+ w=0.41U
M6143 VDD XCTRLB_XDLRSD_Z27
+ XCTRLB_XDLRSD_Z28 VDD pch l=0.06U
+ w=0.41U
M6144 VDD XCTRLB_XDLRSD_Z26
+ XCTRLB_XDLRSD_Z27 VDD pch l=0.14U
+ w=0.41U
M6145 VDD XCTRLB_XDLRSD_Z23
+ XCTRLB_XDLRSD_Z24 VDD pch l=0.06U
+ w=0.41U
M6146 VDD XCTRLB_XDLRSD_Z21
+ XCTRLB_XDLRSD_Z22 VDD pch l=0.06U
+ w=0.41U
M6147 VDD XCTRLB_XDLRSD_Z20
+ XCTRLB_XDLRSD_Z21 VDD pch l=0.14U
+ w=0.41U
M6148 VDD XCTRLB_XDLRSD_Z15
+ XCTRLB_XDLRSD_Z20 VDD pch l=0.06U
+ w=0.41U
M6149 VDD XCTRLB_XDLRSD_Z11
+ XCTRLB_XDLRSD_Z20 VDD pch l=0.06U
+ w=0.41U
M6150 VDD XCTRLB_XDLRSD_Z1
+ XCTRLB_XDLRSD_Z20 VDD pch l=0.06U
+ w=0.41U
M6151 VDD XCTRLB_XDLRSD_Z28
+ XCTRLB_XDLRSD_Z29 VDD pch l=0.14U
+ w=0.41U
M6152 VDD XCTRLB_XDLRSD_Z30
+ XCTRLB_XDLRSD_Z31 VDD pch l=0.14U
+ w=0.41U
M6153 VDD XCTRLB_XDLRSD_Z29
+ XCTRLB_XDLRSD_Z30 VDD pch l=0.06U
+ w=0.41U
M6154 VDD XCTRLB_XDLRSD_Z12
+ XCTRLB_XDLRSD_Z13 VDD pch l=0.08U
+ w=0.41U
M6155 VDD VS_0 XCTRLB_XDLRSD_Z11 VDD
+ pch l=0.06U
+ w=0.41U
M6156 VDD XCTRLB_XDLRSD_Z14
+ XCTRLB_XDLRSD_Z15 VDD pch l=0.08U
+ w=0.41U
M6157 VDD XCTRLB_XDLRSD_Z10
+ XCTRLB_XDLRSD_Z11 VDD pch l=0.08U
+ w=0.41U
M6158 VDD XCTRLB_XDLRSD_Z15
+ XCTRLB_XDLRSD_Z10 VDD pch l=0.06U
+ w=0.41U
M6159 VDD XCTRLB_XDLRSD_Z13
+ XCTRLB_XDLRSD_Z14 VDD pch l=0.06U
+ w=0.41U
M6160 VDD XCTRLB_XDLRSD_Z1
+ XCTRLB_XDLRSD_Z10 VDD pch l=0.06U
+ w=0.41U
M6161 VDD VS_1 XCTRLB_XDLRSD_Z13 VDD
+ pch l=0.06U
+	 w=0.41U
M6162 VDD XCTRLB_XDLRSD_Z1
+ XCTRLB_XDLRSD_Z12 VDD pch l=0.06U
+ w=0.41U
M6163 XCTRLB_XALTCH_14_Z28 XCTRLB_AC_14 VDD
+ VDD pch l=0.06U
+ w=0.21U
M6164 XCTRLB_XALTCH_14_Z22 AMB_14 VDD VDD
+ pch l=0.08U
+	 w=0.42U
M6165 XCTRLB_XALTCH_14_Z27 XCTRLB_CKC VSS
+ VSS nch l=0.06U
+	 w=0.21U
M6166 XCTRLB_AC_14 XCTRLB_XALTCH_14_Z1
+ VSS VSS nch l=0.06U
+ w=0.55U
M6167 VDD XCTRLB_XALTCH_14_Z1
+ XCTRLB_AC_14 VDD pch l=0.06U
+ w=1.1U
M6168 VDD XCTRLB_CKP XCTRLB_XDEC3DZ_2_Z1
+ VDD pch l=0.06U
+ w=0.21U
M6169 VDD XCTRLB_CKP XCTRLB_XDEC3DZ_3_Z1
+ VDD pch l=0.06U
+ w=0.21U
M6170 VDD XCTRLB_RSP XCTRLB_XDEC3DZ_3_Z1
+ VDD pch l=0.06U
+ w=0.75U
M6171 VDD XCTRLB_XDEC3DZ_3_Z1 B_Z_3
+ VDD pch_hvt l=0.06U
+ w=5U
M6172 XCTRLB_XDEC3DZ_2_Z1 XCTRLB_CKP
+ XCTRLB_XDEC3DZ_2_Z2 VSS nch l=0.06U
+ w=2U
M6173 XCTRLB_XDEC3DZ_3_Z1 XCTRLB_CKP
+ XCTRLB_XDEC3DZ_3_Z2 VSS nch l=0.06U
+ w=2U
M6174 XCTRLB_XALTCH_14_Z22 BISTC
+ XCTRLB_XALTCH_14_AX VDD pch l=0.08U
+ w=0.42U
M6175 XCTRLB_AC_14 XCTRLB_XALTCH_14_Z1
+ VSS VSS nch l=0.06U
+ w=0.55U
M6176 VDD XCTRLB_XALTCH_14_Z1
+ XCTRLB_AC_14 VDD pch l=0.06U
+ w=1.1U
M6177 VDD XCTRLB_AC_13 XCTRLB_XDEC3DZ_2_Z1
+ VDD pch l=0.06U
+ w=0.21U
M6178 VDD XCTRLB_AT_13 XCTRLB_XDEC3DZ_3_Z1
+ VDD pch l=0.06U
+ w=0.21U
M6179 VDD XCTRLB_RSP XCTRLB_XDEC3DZ_3_Z1
+ VDD pch l=0.06U
+ w=0.75U
M6180 VDD XCTRLB_XDEC3DZ_3_Z1 B_Z_3
+ VDD pch_hvt l=0.06U
+ w=5U
M6181 XCTRLB_XALTCH_14_Z28 XCTRLB_CKC
+ XCTRLB_XALTCH_14_Z1 VDD pch l=0.06U
+ w=0.21U
M6182 XCTRLB_XALTCH_14_Z1 XCTRLB_XALTCH_14_AX
+ XCTRLB_XALTCH_14_Z27 VSS nch l=0.08U
+ w=0.21U
M6183 XCTRLB_XDEC3DZ_2_Z3 XCTRLB_AC_13
+ XCTRLB_XDEC3DZ_2_Z2 VSS nch l=0.06U
+ w=2U
M6184 XCTRLB_XDEC3DZ_3_Z3 XCTRLB_AT_13
+ XCTRLB_XDEC3DZ_3_Z2 VSS nch l=0.06U
+ w=2U
M6185 XCTRLB_XALTCH_14_Z26 XCTRLB_CKP
+ XCTRLB_XALTCH_14_Z1 VSS nch l=0.06U
+ w=0.21U
M6186 XCTRLB_XALTCH_14_AX BISTT
+ XCTRLB_XALTCH_14_Z21 VDD pch l=0.08U
+ w=0.42U
M6187 XCTRLB_XALTCH_14_Z25 XCTRLB_XALTCH_14_AX
+ XCTRLB_XALTCH_14_Z1 VDD pch l=0.08U
+ w=0.42U
M6188 XCTRLB_XDEC3DZ_2_Z3 XCTRLB_AT_14
+ XCTRLB_XDEC3DZ_2_Z4 VSS nch l=0.06U
+ w=2U
M6189 XCTRLB_XDEC3DZ_3_Z3 XCTRLB_AT_14
+ XCTRLB_XDEC3DZ_3_Z4 VSS nch l=0.06U
+ w=2U
M6190 XCTRLB_AT_14 XCTRLB_AC_14 VSS
+ VSS nch l=0.06U
+ w=0.55U
M6191 VDD XCTRLB_AC_14 XCTRLB_AT_14
+ VDD pch l=0.06U
+ w=1.1U
M6192 VDD XCTRLB_AT_14 XCTRLB_XDEC3DZ_2_Z1
+ VDD pch l=0.06U
+ w=0.21U
M6193 VDD XCTRLB_AT_14 XCTRLB_XDEC3DZ_3_Z1
+ VDD pch l=0.06U
+ w=0.21U
M6194 VDD XCTRLB_RSP XCTRLB_XDEC3DZ_2_Z1
+ VDD pch l=0.06U
+ w=0.75U
M6195 VDD XCTRLB_XDEC3DZ_2_Z1 B_Z_2
+ VDD pch_hvt l=0.06U
+ w=5U
M6196 VDD AB_14 XCTRLB_XALTCH_14_Z21 VDD
+ pch l=0.08U
+	 w=0.42U
M6197 XCTRLB_AT_14 XCTRLB_AC_14 VSS
+ VSS nch l=0.06U
+ w=0.55U
M6198 VDD XCTRLB_AC_14 XCTRLB_AT_14
+ VDD pch l=0.06U
+ w=1.1U
M6199 VDD XCTRLB_AC_15 XCTRLB_XDEC3DZ_2_Z1
+ VDD pch l=0.06U
+ w=0.21U
M6200 VDD XCTRLB_AC_15 XCTRLB_XDEC3DZ_3_Z1
+ VDD pch l=0.06U
+ w=0.21U
M6201 VDD XCTRLB_RSP XCTRLB_XDEC3DZ_2_Z1
+ VDD pch l=0.06U
+ w=0.75U
M6202 VDD XCTRLB_XDEC3DZ_2_Z1 B_Z_2
+ VDD pch_hvt l=0.06U
+ w=5U
M6203 XCTRLB_XALTCH_14_Z25 XCTRLB_CKP VDD
+ VDD pch l=0.06U
+	 w=0.42U
M6204 XCTRLB_XDEC3DZ_2_Z4 XCTRLB_AC_15 VSS
+ VSS nch l=0.06U
+ w=2U
M6205 XCTRLB_XDEC3DZ_3_Z4 XCTRLB_AC_15 VSS
+ VSS nch l=0.06U
+ w=2U
M6206 VSS XCTRLB_AC_14 XCTRLB_XALTCH_14_Z26
+ VSS nch l=0.06U
+	 w=0.21U
M6207 XCTRLB_XDEC3DZ_4_Z4 XCTRLB_AT_15 VSS
+ VSS nch l=0.06U
+ w=2U
M6208 XCTRLB_XDEC3DZ_5_Z4 XCTRLB_AT_15 VSS
+ VSS nch l=0.06U
+ w=2U
M6209 XCTRLB_XALTCH_15_Z26 XCTRLB_AC_15 VSS
+ VSS nch l=0.06U
+	 w=0.21U
M6210 XCTRLB_XALTCH_15_Z25 XCTRLB_CKP VDD
+ VDD pch l=0.06U
+ w=0.42U
M6211 XCTRLB_XALTCH_15_Z21 AB_15 VDD VDD
+ pch l=0.08U
+	 w=0.42U
M6212 XCTRLB_AT_15 XCTRLB_AC_15 VSS
+ VSS nch l=0.06U
+	 w=0.55U
M6213 VDD XCTRLB_AC_15 XCTRLB_AT_15
+ VDD pch l=0.06U
+ w=1.1U
M6214 VDD XCTRLB_AT_15 XCTRLB_XDEC3DZ_4_Z1
+ VDD pch l=0.06U
+ w=0.21U
M6215 VDD XCTRLB_AT_15 XCTRLB_XDEC3DZ_5_Z1
+ VDD pch l=0.06U
+ w=0.21U
M6216 VDD XCTRLB_RSP XCTRLB_XDEC3DZ_4_Z1
+ VDD pch l=0.06U
+ w=0.75U
M6217 VDD XCTRLB_XDEC3DZ_4_Z1 B_Z_4
+ VDD pch_hvt l=0.06U
+ w=5U
M6218 XCTRLB_XDEC3DZ_4_Z4 XCTRLB_AC_14
+ XCTRLB_XDEC3DZ_4_Z3 VSS nch l=0.06U
+ w=2U
M6219 XCTRLB_XDEC3DZ_5_Z4 XCTRLB_AC_14
+ XCTRLB_XDEC3DZ_5_Z3 VSS nch l=0.06U
+ w=2U
M6220 XCTRLB_XALTCH_15_Z26 XCTRLB_CKP
+ XCTRLB_XALTCH_15_Z1 VSS nch l=0.06U
+ w=0.21U
M6221 XCTRLB_XALTCH_15_AX BISTT
+ XCTRLB_XALTCH_15_Z21 VDD pch l=0.08U
+ w=0.42U
M6222 XCTRLB_AT_15 XCTRLB_AC_15 VSS
+ VSS nch l=0.06U
+	 w=0.55U
M6223 VDD XCTRLB_AC_15 XCTRLB_AT_15
+ VDD pch l=0.06U
+ w=1.1U
M6224 VDD XCTRLB_AC_14 XCTRLB_XDEC3DZ_4_Z1
+ VDD pch l=0.06U
+ w=0.21U
M6225 VDD XCTRLB_AC_14 XCTRLB_XDEC3DZ_5_Z1
+ VDD pch l=0.06U
+ w=0.21U
M6226 VDD XCTRLB_RSP XCTRLB_XDEC3DZ_4_Z1
+ VDD pch l=0.06U
+ w=0.75U
M6227 VDD XCTRLB_XDEC3DZ_4_Z1 B_Z_4
+ VDD pch_hvt l=0.06U
+ w=5U
M6228 XCTRLB_XALTCH_15_Z25 XCTRLB_XALTCH_15_AX
+ XCTRLB_XALTCH_15_Z1 VDD pch l=0.08U
+ w=0.42U
M6229 XCTRLB_XDEC3DZ_4_Z3 XCTRLB_AC_13
+ XCTRLB_XDEC3DZ_4_Z2 VSS nch l=0.06U
+ w=2U
M6230 XCTRLB_XDEC3DZ_5_Z3 XCTRLB_AT_13
+ XCTRLB_XDEC3DZ_5_Z2 VSS nch l=0.06U
+ w=2U
M6231 XCTRLB_XALTCH_15_Z1 XCTRLB_CKC
+ XCTRLB_XALTCH_15_Z28 VDD pch l=0.06U
+ w=0.21U
M6232 XCTRLB_XALTCH_15_Z1 XCTRLB_XALTCH_15_AX
+ XCTRLB_XALTCH_15_Z27 VSS nch l=0.08U
+ w=0.21U
M6233 XCTRLB_XALTCH_15_AX BISTC
+ XCTRLB_XALTCH_15_Z22 VDD pch l=0.08U
+ w=0.42U
M6234 XCTRLB_AC_15 XCTRLB_XALTCH_15_Z1
+ VSS VSS nch l=0.06U
+ w=0.55U
M6235 VDD XCTRLB_XALTCH_15_Z1
+ XCTRLB_AC_15 VDD pch l=0.06U
+ w=1.1U
M6236 VDD XCTRLB_AC_13 XCTRLB_XDEC3DZ_4_Z1
+ VDD pch l=0.06U
+ w=0.21U
M6237 VDD XCTRLB_AT_13 XCTRLB_XDEC3DZ_5_Z1
+ VDD pch l=0.06U
+ w=0.21U
M6238 VDD XCTRLB_RSP XCTRLB_XDEC3DZ_5_Z1
+ VDD pch l=0.06U
+ w=0.75U
M6239 VDD XCTRLB_XDEC3DZ_5_Z1 B_Z_5
+ VDD pch_hvt l=0.06U
+ w=5U
M6240 XCTRLB_XDEC3DZ_4_Z2 XCTRLB_CKP
+ XCTRLB_XDEC3DZ_4_Z1 VSS nch l=0.06U
+ w=2U
M6241 XCTRLB_XDEC3DZ_5_Z2 XCTRLB_CKP
+ XCTRLB_XDEC3DZ_5_Z1 VSS nch l=0.06U
+ w=2U
M6242 VSS XCTRLB_CKC XCTRLB_XALTCH_15_Z27
+ VSS nch l=0.06U
+	 w=0.21U
M6243 XCTRLB_AC_15 XCTRLB_XALTCH_15_Z1
+ VSS VSS nch l=0.06U
+ w=0.55U
M6244 VDD XCTRLB_CKP XCTRLB_XDEC3DZ_4_Z1
+ VDD pch l=0.06U
+ w=0.21U
M6245 VDD XCTRLB_CKP XCTRLB_XDEC3DZ_5_Z1
+ VDD pch l=0.06U
+ w=0.21U
M6246 VDD XCTRLB_RSP XCTRLB_XDEC3DZ_5_Z1
+ VDD pch l=0.06U
+ w=0.75U
M6247 VDD XCTRLB_XDEC3DZ_5_Z1 B_Z_5
+ VDD pch_hvt l=0.06U
+ w=5U
M6248 VDD XCTRLB_CKP XCTRLB_XDEC3DZ_6_Z1
+ VDD pch l=0.06U
+ w=0.21U
M6249 VDD XCTRLB_CKP XCTRLB_XDEC3DZ_7_Z1
+ VDD pch l=0.06U
+ w=0.21U
M6250 VDD XCTRLB_RSP XCTRLB_XDEC3DZ_7_Z1
+ VDD pch l=0.06U
+ w=0.75U
M6251 VDD XCTRLB_XDEC3DZ_7_Z1 B_Z_7
+ VDD pch_hvt l=0.06U
+ w=5U
M6252 XCTRLB_XDEC3DZ_6_Z1 XCTRLB_CKP
+ XCTRLB_XDEC3DZ_6_Z2 VSS nch l=0.06U
+ w=2U
M6253 XCTRLB_XDEC3DZ_7_Z1 XCTRLB_CKP
+ XCTRLB_XDEC3DZ_7_Z2 VSS nch l=0.06U
+ w=2U
M6254 VDD XCTRLB_AC_13 XCTRLB_XDEC3DZ_6_Z1
+ VDD pch l=0.06U
+ w=0.21U
M6255 VDD XCTRLB_AT_13 XCTRLB_XDEC3DZ_7_Z1
+ VDD pch l=0.06U
+ w=0.21U
M6256 VDD XCTRLB_RSP XCTRLB_XDEC3DZ_7_Z1
+ VDD pch l=0.06U
+ w=0.75U
M6257 VDD XCTRLB_XDEC3DZ_7_Z1 B_Z_7
+ VDD pch_hvt l=0.06U
+ w=5U
M6258 XCTRLB_XDEC3DZ_6_Z3 XCTRLB_AC_13
+ XCTRLB_XDEC3DZ_6_Z2 VSS nch l=0.06U
+ w=2U
M6259 XCTRLB_XDEC3DZ_7_Z3 XCTRLB_AT_13
+ XCTRLB_XDEC3DZ_7_Z2 VSS nch l=0.06U
+ w=2U
M6260 AWTI XAWTD_Z1 VSS VSS nch
+ l=0.06U
+ w=0.55U
M6261 VDD B_DWLF B_DBL VDD pch
+ l=0.06U
+ w=1.5U
M6262 VDD B_DWLF B_DBL VDD pch
+ l=0.06U
+ w=1.5U
M6263 VDD B_DWLF B_DBL VDD pch
+ l=0.06U
+ w=1.5U
M6264 VDD B_DWLF B_DBL VDD pch
+ l=0.06U
+ w=1.5U
M6265 XCTRLB_XDBLDG_NC_P1_7 VHI
+ XCTRLB_XDBLDG_XDBLD5_3_Z1 VDD pchpu_hvtdpsr
+ l=0.07U w=0.09U
M6266 XCTRLB_XDBLDG_XDBLD5_3_NC_P0
+	XCTRLB_XDBLDG_XDBLD5_3_Z1 VDD VDD pchpu_hvtdpsr
+ l=0.07U
+	 w=0.09U
M6267 XCTRLB_XDBLDG_NC_P1_6 VHI
+ XCTRLB_XDBLDG_XDBLD5_2_Z1 VDD pchpu_hvtdpsr
+ l=0.07U w=0.09U
M6268 XCTRLB_XDBLDG_XDBLD5_2_NC_P0
+	XCTRLB_XDBLDG_XDBLD5_2_Z1 VDD VDD pchpu_hvtdpsr
+ l=0.07U
+	 w=0.09U
M6269 XCTRLB_XDBLDG_NC_P1_6 VHI
+ XCTRLB_XDBLDG_XDBLD5_1_Z1 VDD pchpu_hvtdpsr
+ l=0.07U w=0.09U
M6270 XCTRLB_XDBLDG_XDBLD5_1_NC_P0
+	XCTRLB_XDBLDG_XDBLD5_1_Z1 VDD VDD pchpu_hvtdpsr
+ l=0.07U
+	 w=0.09U
M6271 XCTRLB_XDBLDG_XDBLD5_0_NC_P0
+	XCTRLB_XDBLDG_XDBLD5_0_Z1 VDD VDD pchpu_hvtdpsr
+ l=0.07U
+	 w=0.09U
M6272 XCTRLB_XDBLDG_NC_P1_5 VB_2
+ XCTRLB_XDBLDG_XDBLD4_3_Z1 VDD pchpu_hvtdpsr
+ l=0.07U w=0.09U
M6273 XCTRLB_XDBLDG_XDBLD4_3_NC_P0
+	XCTRLB_XDBLDG_XDBLD4_3_Z1 VDD VDD pchpu_hvtdpsr
+ l=0.07U
+	 w=0.09U
M6274 XCTRLB_XDBLDG_NC_P1_5 VHI
+ XCTRLB_XDBLDG_XDBLD5_0_Z1 VDD pchpu_hvtdpsr
+ l=0.07U w=0.09U
M6275 XCTRLB_XDBLDG_XDBLD4_1_NC_P0
+	XCTRLB_XDBLDG_XDBLD4_1_Z1 VDD VDD pchpu_hvtdpsr
+ l=0.07U
+	 w=0.09U
M6276 XCTRLB_XDBLDG_NC_P1_4 VB_2
+ XCTRLB_XDBLDG_XDBLD4_1_Z1 VDD pchpu_hvtdpsr
+ l=0.07U w=0.09U
M6277 XCTRLB_XDBLDG_NC_P1_4 VB_2
+ XCTRLB_XDBLDG_XDBLD4_2_Z1 VDD pchpu_hvtdpsr
+ l=0.07U w=0.09U
M6278 XCTRLB_XDBLDG_XDBLD4_2_NC_P0
+	XCTRLB_XDBLDG_XDBLD4_2_Z1 VDD VDD pchpu_hvtdpsr
+ l=0.07U
+	 w=0.09U
M6279 XCTRLB_XDBLDG_NC_P1_3 VB_2
+ XCTRLB_XDBLDG_XDBLD4_0_Z1 VDD pchpu_hvtdpsr
+ l=0.07U w=0.09U
M6280 XCTRLB_XDBLDG_XDBLD4_0_NC_P0
+	XCTRLB_XDBLDG_XDBLD4_0_Z1 VDD VDD pchpu_hvtdpsr
+ l=0.07U
+	 w=0.09U
M6281 XCTRLB_XDBLDG_XDBLD3_0_NC_P0
+	XCTRLB_XDBLDG_XDBLD3_0_Z1 VDD VDD pchpu_hvtdpsr
+ l=0.07U
+	 w=0.09U
M6282 XCTRLB_XDBLDG_NC_P1_3 VB_1
+ XCTRLB_XDBLDG_XDBLD3_1_Z1 VDD pchpu_hvtdpsr
+ l=0.07U w=0.09U
M6283 XCTRLB_XDBLDG_XDBLD3_1_NC_P0
+	XCTRLB_XDBLDG_XDBLD3_1_Z1 VDD VDD pchpu_hvtdpsr
+ l=0.07U
+	 w=0.09U
M6284 XCTRLB_XDBLDG_NC_P1_2 VB_1
+ XCTRLB_XDBLDG_XDBLD3_0_Z1 VDD pchpu_hvtdpsr
+ l=0.07U w=0.09U
M6285 XCTRLB_XDBLDG_XDBLD1_0_NC_P0
+	XCTRLB_XDBLDG_XDBLD1_0_Z1 VDD VDD pchpu_hvtdpsr
+ l=0.07U
+	 w=0.09U
M6286 XCTRLB_XDBLDG_NC_P1_2 VB_0
+ XCTRLB_XDBLDG_XDBLD2_Z1 VDD pchpu_hvtdpsr
+ l=0.07U w=0.09U
M6287 XCTRLB_XDBLDG_XDBLD2_NC_P0
+ XCTRLB_XDBLDG_XDBLD2_Z1 VDD VDD pchpu_hvtdpsr
+ l=0.07U w=0.09U
M6288 XCTRLB_XDBLDG_NC_P1_1 VD_1
+ XCTRLB_XDBLDG_XDBLD1_0_Z1 VDD pchpu_hvtdpsr
+ l=0.07U w=0.09U
M6289 XCTRLB_XDBLDG_XDBLD0_NC_P0
+ XCTRLB_XDBLDG_XDBLD0_Z1 VDD VDD pchpu_hvtdpsr
+ l=0.07U w=0.09U
M6290 XCTRLB_XDBLDG_NC_P1_1 VD_1
+ XCTRLB_XDBLDG_XDBLD1_1_Z1 VDD pchpu_hvtdpsr
+ l=0.07U w=0.09U
M6291 XCTRLB_XDBLDG_XDBLD1_1_NC_P0
+	XCTRLB_XDBLDG_XDBLD1_1_Z1 VDD VDD pchpu_hvtdpsr
+ l=0.07U
+	 w=0.09U
M6292 XCTRLB_XDBLDG_NC_P1_0 VD_0
+ XCTRLB_XDBLDG_XDBLD0_Z1 VDD pchpu_hvtdpsr
+ l=0.07U w=0.09U
M6293 XCTRLB_XDEC3DZ_6_Z3 XCTRLB_AT_14
+ XCTRLB_XDEC3DZ_6_Z4 VSS nch l=0.06U
+ w=2U
M6294 XCTRLB_XDEC3DZ_7_Z3 XCTRLB_AT_14
+ XCTRLB_XDEC3DZ_7_Z4 VSS nch l=0.06U
+ w=2U
M6295 VDD XCTRLB_AT_14 XCTRLB_XDEC3DZ_6_Z1
+ VDD pch l=0.06U
+ w=0.21U
M6296 VDD XCTRLB_AT_14 XCTRLB_XDEC3DZ_7_Z1
+ VDD pch l=0.06U
+ w=0.21U
M6297 VDD XCTRLB_RSP XCTRLB_XDEC3DZ_6_Z1
+ VDD pch l=0.06U
+ w=0.75U
M6298 VDD XCTRLB_XDEC3DZ_6_Z1 B_Z_6
+ VDD pch_hvt l=0.06U
+ w=5U
M6299 AWTI XAWTD_Z1 VSS VSS nch
+ l=0.06U
+ w=1.33U
M6300 XCTRLB_XDEC3DZ_6_Z4 XCTRLB_AT_15 VSS
+ VSS nch l=0.06U
+ w=2U
M6301 XCTRLB_XDEC3DZ_7_Z4 XCTRLB_AT_15 VSS
+ VSS nch l=0.06U
+ w=2U
M6302 VDD XCTRLB_RSP XCTRLB_XDEC3DZ_6_Z1
+ VDD pch l=0.06U
+ w=0.75U
M6303 VDD XCTRLB_XDEC3DZ_6_Z1 B_Z_6
+ VDD pch_hvt l=0.06U
+ w=5U
M6304 VDD XCTRLB_AT_15 XCTRLB_XDEC3DZ_6_Z1
+ VDD pch l=0.06U
+ w=0.21U
M6305 VDD XCTRLB_AT_15 XCTRLB_XDEC3DZ_7_Z1
+ VDD pch l=0.06U
+ w=0.21U
M6306 AWTI XAWTD_Z1 VSS VSS nch
+ l=0.06U
+ w=1.33U
M6307 VDD XAWTD_Z1 AWTI VDD pch
+ l=0.06U
+ w=1.1U
M6308 VDD XAWTD_Z1 AWTI VDD pch
+ l=0.06U
+ w=1.1U
M6309 VDD XAWTD_Z1 AWTI VDD pch
+ l=0.06U
+ w=1.1U
M6310 VDD XAWTD_Z1 AWTI VDD pch
+ l=0.06U
+	 w=1.1U
M6311 VDD XCTRLB_XALTCH_15_Z1
+ XCTRLB_AC_15 VDD pch l=0.06U
+ w=1.1U
M6312 VDD XAWTD_Z1 AWTI VDD pch
+ l=0.06U
+ w=1.8U
M6313 VDD XAWTD_Z1 AWTI VDD pch
+ l=0.06U
+ w=1.8U
M6314 VDD AWT XAWTD_Z1 VDD pch
+ l=0.06U
+ w=1.8U
M6315 XCTRLB_XALTCH_15_Z28 XCTRLB_AC_15 VDD
+ VDD pch l=0.06U
+ w=0.21U
M6316 XCTRLB_XALTCH_15_Z22 AMB_15 VDD VDD
+ pch l=0.08U
+	 w=0.42U
M6317 XCTRLB_XDBLDG_ENB_S B_DBL VSS
+ VSS nch_hvt l=0.06U
+ w=0.62U
M6318 XCTRLB_XDBLDG_ENB_S B_DBL VSS
+ VSS nch_hvt l=0.06U
+	 w=0.62U
M6319 B_DBL XCTRLB_XDBLDG_XDBLDD_Z0 VSS
+ VSS nch_hvt l=0.08U
+ w=0.62U
M6320 XCTRLB_XDBLDG_XDBLDD_Z0 VHI VSS
+ VSS nch_hvt l=0.08U
+ w=0.62U
M6321 B_DBL B_DWLF XCTRLB_XDBLDG_ENB_S
+ VSS nch_hvt l=0.08U
+ w=0.62U
M6322 B_DWL XCTRLB_XDWLDV_DWLC VSS VSS
+ nch_hvt l=0.06U
+	 w=1U
M6323 B_DWL XCTRLB_XDWLDV_DWLC VSS
+ VSS nch_hvt l=0.06U
+	 w=1U
M6324 XCTRLB_XDBLDG_XDBLD5_3_Z1 B_DWLF
+ B_DBL VSS nchpg_hvtdpsr l=0.08U
+ w=0.105U
M6325 VSS B_DWLF
+ XCTRLB_XDBLDG_XDBLD5_3_Z0 VSS nchpg_hvtdpsr
+ l=0.08U w=0.105U
M6326 VSS B_DWLF
+ XCTRLB_XDBLDG_XDBLD1_1_NC_N3 VSS nchpg_hvtdpsr
+ l=0.08U w=0.105U
M6327 XCTRLB_XDBLDG_XDBLD5_3_Z1 B_DWLF
+ B_DBL VSS nchpg_hvtdpsr l=0.08U
+ w=0.105U
M6328 VSS B_DWLF
+ XCTRLB_XDBLDG_XDBLD3_1_NC_N3 VSS nchpg_hvtdpsr
+ l=0.08U w=0.105U
M6329 XCTRLB_XDBLDG_XDBLD5_2_Z1 B_DWLF
+ B_DBL VSS nchpg_hvtdpsr l=0.08U
+ w=0.105U
M6330 XCTRLB_XDBLDG_XDBLD5_2_Z1 B_DWLF
+ B_DBL VSS nchpg_hvtdpsr l=0.08U
+ w=0.105U
M6331 VSS B_DWLF
+ XCTRLB_XDBLDG_XDBLD5_2_Z0 VSS nchpg_hvtdpsr
+ l=0.08U w=0.105U
M6332 XCTRLB_XDBLDG_XDBLD5_1_Z1 B_DWLF
+ B_DBL VSS nchpg_hvtdpsr l=0.08U
+ w=0.105U
M6333 VSS B_DWLF
+ XCTRLB_XDBLDG_XDBLD5_1_Z0 VSS nchpg_hvtdpsr
+ l=0.08U w=0.105U
M6334 VSS B_DWLF
+ XCTRLB_XDBLDG_XDBLD5_2_NC_N3 VSS nchpg_hvtdpsr
+ l=0.08U w=0.105U
M6335 XCTRLB_XDBLDG_XDBLD5_1_Z1 B_DWLF
+ B_DBL VSS nchpg_hvtdpsr l=0.08U
+ w=0.105U
M6336 VSS B_DWLF
+ XCTRLB_XDBLDG_XDBLD3_0_NC_N3 VSS nchpg_hvtdpsr
+ l=0.08U w=0.105U
M6337 XCTRLB_XDBLDG_XDBLD5_0_Z1 B_DWLF
+ B_DBL VSS nchpg_hvtdpsr l=0.08U
+ w=0.105U
M6338 XCTRLB_XDBLDG_XDBLD5_0_Z1 B_DWLF
+ B_DBL VSS nchpg_hvtdpsr l=0.08U
+ w=0.105U
M6339 VSS B_DWLF
+ XCTRLB_XDBLDG_XDBLD5_0_Z0 VSS nchpg_hvtdpsr
+ l=0.08U w=0.105U
M6340 VSS B_DWLF
+ XCTRLB_XDBLDG_XDBLD2_NC_N3 VSS nchpg_hvtdpsr
+ l=0.08U w=0.105U
M6341 XCTRLB_XDBLDG_XDBLD4_3_Z1 B_DWLF
+ B_DBL VSS nchpg_hvtdpsr l=0.08U
+ w=0.105U
M6342 XCTRLB_XDBLDG_XDBLD4_3_Z1 B_DWLF
+ B_DBL VSS nchpg_hvtdpsr l=0.08U
+ w=0.105U
M6343 VSS B_DWLF
+ XCTRLB_XDBLDG_XDBLD4_3_Z0 VSS nchpg_hvtdpsr
+ l=0.08U w=0.105U
M6344 VSS B_DWLF
+ XCTRLB_XDBLDG_XDBLD4_3_NC_N3 VSS nchpg_hvtdpsr
+ l=0.08U w=0.105U
M6345 XCTRLB_XDBLDG_XDBLD4_1_Z1 B_DWLF
+ B_DBL VSS nchpg_hvtdpsr l=0.08U
+ w=0.105U
M6346 XCTRLB_XDBLDG_XDBLD4_1_Z1 B_DWLF
+ B_DBL VSS nchpg_hvtdpsr l=0.08U
+ w=0.105U
M6347 VSS B_DWLF
+ XCTRLB_XDBLDG_XDBLD4_1_Z0 VSS nchpg_hvtdpsr
+ l=0.08U w=0.105U
M6348 XCTRLB_XDBLDG_XDBLD4_2_Z1 B_DWLF
+ B_DBL VSS nchpg_hvtdpsr l=0.08U
+ w=0.105U
M6349 VSS B_DWLF
+ XCTRLB_XDBLDG_XDBLD4_2_Z0 VSS nchpg_hvtdpsr
+ l=0.08U w=0.105U
M6350 VSS B_DWLF
+ XCTRLB_XDBLDG_XDBLD4_2_NC_N3 VSS nchpg_hvtdpsr
+ l=0.08U w=0.105U
M6351 XCTRLB_XDBLDG_XDBLD4_2_Z1 B_DWLF
+ B_DBL VSS nchpg_hvtdpsr l=0.08U
+ w=0.105U
M6352 VSS B_DWLF
+ XCTRLB_XDBLDG_XDBLD5_0_NC_N3 VSS nchpg_hvtdpsr
+ l=0.08U w=0.105U
M6353 XCTRLB_XDBLDG_XDBLD4_0_Z1 B_DWLF
+ B_DBL VSS nchpg_hvtdpsr l=0.08U
+ w=0.105U
M6354 VSS B_DWLF
+ XCTRLB_XDBLDG_XDBLD4_1_NC_N3 VSS nchpg_hvtdpsr
+ l=0.08U w=0.105U
M6355 XCTRLB_XDBLDG_XDBLD3_1_Z1 B_DWLF
+ B_DBL VSS nchpg_hvtdpsr l=0.08U
+ w=0.105U
M6356 XCTRLB_XDBLDG_XDBLD3_1_Z1 B_DWLF
+ B_DBL VSS nchpg_hvtdpsr l=0.08U
+ w=0.105U
M6357 VSS B_DWLF
+ XCTRLB_XDBLDG_XDBLD3_1_Z0 VSS nchpg_hvtdpsr
+ l=0.08U w=0.105U
M6358 XCTRLB_XDBLDG_XDBLD4_0_Z1 B_DWLF
+ B_DBL VSS nchpg_hvtdpsr l=0.08U
+ w=0.105U
M6359 VSS B_DWLF
+ XCTRLB_XDBLDG_XDBLD4_0_Z0 VSS nchpg_hvtdpsr
+ l=0.08U w=0.105U
M6360 VSS B_DWLF
+ XCTRLB_XDBLDG_XDBLD4_0_NC_N3 VSS nchpg_hvtdpsr
+ l=0.08U w=0.105U
M6361 XCTRLB_XDBLDG_XDBLD3_0_Z1 B_DWLF
+ B_DBL VSS nchpg_hvtdpsr l=0.08U
+ w=0.105U
M6362 XCTRLB_XDBLDG_XDBLD3_0_Z1 B_DWLF
+ B_DBL VSS nchpg_hvtdpsr l=0.08U
+ w=0.105U
M6363 VSS B_DWLF
+ XCTRLB_XDBLDG_XDBLD3_0_Z0 VSS nchpg_hvtdpsr
+ l=0.08U w=0.105U
M6364 VSS B_DWLF
+ XCTRLB_XDBLDG_XDBLD1_0_NC_N3 VSS nchpg_hvtdpsr
+ l=0.08U w=0.105U
M6365 XCTRLB_XDBLDG_XDBLD1_0_Z1 B_DWLF
+ B_DBL VSS nchpg_hvtdpsr l=0.08U
+ w=0.105U
M6366 VSS B_DWLF
+ XCTRLB_XDBLDG_XDBLD5_1_NC_N3 VSS nchpg_hvtdpsr
+ l=0.08U w=0.105U
M6367 XCTRLB_XDBLDG_XDBLD2_Z1 B_DWLF B_DBL
+ VSS nchpg_hvtdpsr l=0.08U
+ w=0.105U
M6368 XCTRLB_XDBLDG_XDBLD2_Z1 B_DWLF B_DBL
+ VSS nchpg_hvtdpsr l=0.08U
+ w=0.105U
M6369 VSS B_DWLF
+ XCTRLB_XDBLDG_XDBLD2_Z0 VSS nchpg_hvtdpsr
+ l=0.08U w=0.105U
M6370 XCTRLB_XDBLDG_XDBLD1_0_Z1 B_DWLF
+ B_DBL VSS nchpg_hvtdpsr l=0.08U
+ w=0.105U
M6371 VSS B_DWLF
+ XCTRLB_XDBLDG_XDBLD1_0_Z0 VSS nchpg_hvtdpsr
+ l=0.08U w=0.105U
M6372 XCTRLB_XDBLDG_XDBLD1_1_Z1 B_DWLF
+ B_DBL VSS nchpg_hvtdpsr l=0.08U
+ w=0.105U
M6373 VSS B_DWLF
+ XCTRLB_XDBLDG_XDBLD1_1_Z0 VSS nchpg_hvtdpsr
+ l=0.08U w=0.105U
M6374 XCTRLB_XDBLDG_XDBLD0_Z1 B_DWLF B_DBL
+ VSS nchpg_hvtdpsr l=0.08U
+ w=0.105U
M6375 VSS B_DWLF
+ XCTRLB_XDBLDG_XDBLD0_Z0 VSS nchpg_hvtdpsr
+ l=0.08U w=0.105U
M6376 VSS B_DWLF
+ XCTRLB_XDBLDG_XDBLD5_3_NC_N3 VSS nchpg_hvtdpsr
+ l=0.08U w=0.105U
M6377 XCTRLB_XDBLDG_XDBLD0_Z1 B_DWLF B_DBL
+ VSS nchpg_hvtdpsr l=0.08U
+ w=0.105U
M6378 VSS B_DWLF
+ XCTRLB_XDBLDG_XDBLD0_NC_N3 VSS nchpg_hvtdpsr
+ l=0.08U w=0.105U
M6379 XCTRLB_XDBLDG_XDBLD1_1_Z1 B_DWLF
+ B_DBL VSS nchpg_hvtdpsr l=0.08U
+ w=0.105U
M6380 VSS XCTRLB_XDBLDG_XDBLD5_3_Z1
+ XCTRLB_XDBLDG_XDBLD5_3_Z0 VSS nchpd_hvtdpsr
+ l=0.065U w=0.315U
M6381 VSS XCTRLB_XDBLDG_XDBLD5_2_Z1
+ XCTRLB_XDBLDG_XDBLD5_2_Z0 VSS nchpd_hvtdpsr
+ l=0.065U w=0.315U
M6382 XCTRLB_XDBLDG_XDBLD5_3_Z1 VHI
+ VSS VSS nchpd_hvtdpsr l=0.065U
+ w=0.315U
M6383 XCTRLB_XDBLDG_XDBLD5_2_Z1 VHI
+ VSS VSS nchpd_hvtdpsr l=0.065U
+ w=0.315U
M6384 XCTRLB_XDBLDG_XDBLD5_1_Z1 VHI
+ VSS VSS nchpd_hvtdpsr l=0.065U
+ w=0.315U
M6385 VSS XCTRLB_XDBLDG_XDBLD5_1_Z1
+ XCTRLB_XDBLDG_XDBLD5_1_Z0 VSS nchpd_hvtdpsr
+ l=0.065U w=0.315U
M6386 VSS XCTRLB_XDBLDG_XDBLD5_0_Z1
+ XCTRLB_XDBLDG_XDBLD5_0_Z0 VSS nchpd_hvtdpsr
+ l=0.065U w=0.315U
M6387 VSS XCTRLB_XDBLDG_XDBLD4_3_Z1
+ XCTRLB_XDBLDG_XDBLD4_3_Z0 VSS nchpd_hvtdpsr
+ l=0.065U w=0.315U
M6388 XCTRLB_XDBLDG_XDBLD4_3_Z1 VB_2
+ VSS VSS nchpd_hvtdpsr l=0.065U
+ w=0.315U
M6389 XCTRLB_XDBLDG_XDBLD5_0_Z1 VHI
+ VSS VSS nchpd_hvtdpsr l=0.065U
+ w=0.315U
M6390 VSS XCTRLB_XDBLDG_XDBLD4_1_Z1
+ XCTRLB_XDBLDG_XDBLD4_1_Z0 VSS nchpd_hvtdpsr
+ l=0.065U w=0.315U
M6391 VSS XCTRLB_XDBLDG_XDBLD4_2_Z1
+ XCTRLB_XDBLDG_XDBLD4_2_Z0 VSS nchpd_hvtdpsr
+ l=0.065U w=0.315U
M6392 XCTRLB_XDBLDG_XDBLD4_1_Z1 VB_2
+ VSS VSS nchpd_hvtdpsr l=0.065U
+ w=0.315U
M6393 XCTRLB_XDBLDG_XDBLD4_2_Z1 VB_2
+ VSS VSS nchpd_hvtdpsr l=0.065U
+ w=0.315U
M6394 VSS XCTRLB_XDBLDG_XDBLD4_0_Z1
+ XCTRLB_XDBLDG_XDBLD4_0_Z0 VSS nchpd_hvtdpsr
+ l=0.065U w=0.315U
M6395 VSS XCTRLB_XDBLDG_XDBLD3_0_Z1
+ XCTRLB_XDBLDG_XDBLD3_0_Z0 VSS nchpd_hvtdpsr
+ l=0.065U w=0.315U
M6396 VSS XCTRLB_XDBLDG_XDBLD3_1_Z1
+ XCTRLB_XDBLDG_XDBLD3_1_Z0 VSS nchpd_hvtdpsr
+ l=0.065U w=0.315U
M6397 XCTRLB_XDBLDG_XDBLD4_0_Z1 VB_2
+ VSS VSS nchpd_hvtdpsr l=0.065U
+ w=0.315U
M6398 XCTRLB_XDBLDG_XDBLD3_1_Z1 VB_1
+ VSS VSS nchpd_hvtdpsr l=0.065U
+ w=0.315U
M6399 VSS XCTRLB_XDBLDG_XDBLD1_0_Z1
+ XCTRLB_XDBLDG_XDBLD1_0_Z0 VSS nchpd_hvtdpsr
+ l=0.065U w=0.315U
M6400 VSS XCTRLB_XDBLDG_XDBLD2_Z1
+ XCTRLB_XDBLDG_XDBLD2_Z0 VSS nchpd_hvtdpsr
+ l=0.065U w=0.315U
M6401 XCTRLB_XDBLDG_XDBLD3_0_Z1 VB_1
+ VSS VSS nchpd_hvtdpsr l=0.065U
+ w=0.315U
M6402 XCTRLB_XDBLDG_XDBLD2_Z1 VB_0 VSS
+ VSS nchpd_hvtdpsr l=0.065U
+ w=0.315U
M6403 XCTRLB_XDBLDG_XDBLD1_0_Z1 VD_1
+ XCTRLB_XDBLDG_ENB_S VSS nchpd_hvtdpsr
+ l=0.065U w=0.315U
M6404 VSS XCTRLB_XDBLDG_XDBLD0_Z1
+ XCTRLB_XDBLDG_XDBLD0_Z0 VSS nchpd_hvtdpsr
+ l=0.065U w=0.315U
M6405 VSS XCTRLB_XDBLDG_XDBLD1_1_Z1
+ XCTRLB_XDBLDG_XDBLD1_1_Z0 VSS nchpd_hvtdpsr
+ l=0.065U w=0.315U
M6406 XCTRLB_XDBLDG_XDBLD1_1_Z1 VD_1
+ XCTRLB_XDBLDG_ENB_S VSS nchpd_hvtdpsr
+ l=0.065U w=0.315U
M6407 XCTRLB_XDBLDG_XDBLD0_Z1 VD_0
+ XCTRLB_XDBLDG_ENB_S VSS nchpd_hvtdpsr
+ l=0.065U w=0.315U
M6408 XAWTD_Z1 AWT VSS VSS nch
+ l=0.06U
+ w=0.9U
M6409 XCTRLB_XALTCH_15_Z23 AB_15 VSS VSS
+ nch l=0.08U
+	 w=0.21U
M6410 XCTRLB_XALTCH_15_Z23 BISTC
+ XCTRLB_XALTCH_15_AX VSS nch l=0.08U
+ w=0.21U
M6411 VSS AB_14 XCTRLB_XALTCH_14_Z23 VSS
+ nch l=0.08U
+ w=0.21U
M6412 VSS AMB_15 XCTRLB_XALTCH_15_Z24 VSS
+ nch l=0.08U
+	 w=0.21U
M6413 XCTRLB_XALTCH_15_AX BISTT
+ XCTRLB_XALTCH_15_Z24 VSS nch l=0.08U
+ w=0.21U
M6414 XCTRLB_XALTCH_13_Z23 AB_13 VSS VSS
+ nch l=0.08U
+	 w=0.21U
M6415 XCTRLB_XALTCH_13_Z23 BISTC
+ XCTRLB_XALTCH_13_AX VSS nch l=0.08U
+ w=0.21U
M6416 VSS AB_5 XCTRLB_XALTCH_5_Z23 VSS
+ nch l=0.08U
+ w=0.21U
M6417 XCTRLB_XALTCH_14_Z24 AMB_14 VSS VSS
+ nch l=0.08U
+	 w=0.21U
M6418 XCTRLB_XALTCH_14_Z24 BISTT
+ XCTRLB_XALTCH_14_AX VSS nch l=0.08U
+ w=0.21U
M6419 XCTRLB_XALTCH_14_AX BISTC
+ XCTRLB_XALTCH_14_Z23 VSS nch l=0.08U
+ w=0.21U
M6420 VSS AMB_13 XCTRLB_XALTCH_13_Z24 VSS
+ nch l=0.08U
+ w=0.21U
M6421 XCTRLB_XALTCH_13_AX BISTT
+ XCTRLB_XALTCH_13_Z24 VSS nch l=0.08U
+ w=0.21U
M6422 XCTRLB_XALTCH_7_Z23 BISTC
+ XCTRLB_XALTCH_7_AX VSS nch l=0.08U
+ w=0.21U
M6423 VSS AB_6 XCTRLB_XALTCH_6_Z23 VSS
+ nch l=0.08U
+ w=0.21U
M6424 XCTRLB_XALTCH_7_Z23 AB_7 VSS VSS
+ nch l=0.08U
+	 w=0.21U
M6425 XCTRLB_XALTCH_5_Z24 AMB_5 VSS VSS
+ nch l=0.08U
+	 w=0.21U
M6426 XCTRLB_XALTCH_5_Z24 BISTT
+ XCTRLB_XALTCH_5_AX VSS nch l=0.08U
+ w=0.21U
M6427 XCTRLB_XALTCH_5_AX BISTC
+ XCTRLB_XALTCH_5_Z23 VSS nch l=0.08U
+ w=0.21U
M6428 VSS AMB_6 XCTRLB_XALTCH_6_Z24 VSS
+ nch l=0.08U
+ w=0.21U
M6429 XCTRLB_XALTCH_6_Z24 BISTT
+ XCTRLB_XALTCH_6_AX VSS nch l=0.08U
+ w=0.21U
M6430 XCTRLB_XALTCH_6_AX BISTC
+ XCTRLB_XALTCH_6_Z23 VSS nch l=0.08U
+ w=0.21U
M6431 XCTRLB_XALTCH_11_AX BISTT
+ XCTRLB_XALTCH_11_Z24 VSS nch l=0.08U
+ w=0.21U
M6432 VSS AB_12 XCTRLB_XALTCH_12_Z23 VSS
+ nch l=0.08U
+	 w=0.21U
M6433 VSS AB_11 XCTRLB_XALTCH_11_Z23 VSS
+ nch l=0.08U
+ w=0.21U
M6434 XCTRLB_XALTCH_11_AX BISTC
+ XCTRLB_XALTCH_11_Z23 VSS nch l=0.08U
+ w=0.21U
M6435 XCTRLB_XALTCH_7_Z24 AMB_7 VSS VSS
+ nch l=0.08U
+	 w=0.21U
M6436 XCTRLB_XALTCH_7_Z24 BISTT
+ XCTRLB_XALTCH_7_AX VSS nch l=0.08U
+ w=0.21U
M6437 VSS AMB_12 XCTRLB_XALTCH_12_Z24 VSS
+ nch l=0.08U
+ w=0.21U
M6438 XCTRLB_XALTCH_12_Z24 BISTT
+ XCTRLB_XALTCH_12_AX VSS nch l=0.08U
+ w=0.21U
M6439 XCTRLB_XALTCH_12_AX BISTC
+ XCTRLB_XALTCH_12_Z23 VSS nch l=0.08U
+ w=0.21U
M6440 XCTRLB_XALTCH_8_Z24 AMB_8 VSS VSS
+ nch l=0.08U
+	 w=0.21U
M6441 XCTRLB_XALTCH_8_Z24 BISTT
+ XCTRLB_XALTCH_8_AX VSS nch l=0.08U
+ w=0.21U
M6442 XCTRLB_XALTCH_8_Z23 AB_8 VSS VSS
+ nch l=0.08U
+	 w=0.21U
M6443 XCTRLB_XALTCH_8_AX BISTC
+ XCTRLB_XALTCH_8_Z23 VSS nch l=0.08U
+ w=0.21U
M6444 XCTRLB_XALTCH_11_Z24 AMB_11 VSS VSS
+ nch l=0.08U
+	 w=0.21U
M6445 VSS AB_10 XCTRLB_XALTCH_10_Z23 VSS
+ nch l=0.08U
+	 w=0.21U
M6446 VSS AMB_10 XCTRLB_XALTCH_10_Z24 VSS
+ nch l=0.08U
+	 w=0.21U
M6447 XCTRLB_XALTCH_10_Z24 BISTT
+ XCTRLB_XALTCH_10_AX VSS nch l=0.08U
+ w=0.21U
M6448 XCTRLB_XALTCH_10_AX BISTC
+ XCTRLB_XALTCH_10_Z23 VSS nch l=0.08U
+ w=0.21U
M6449 XCTRLB_XALTCH_0_Z24 AMB_0 VSS VSS
+ nch l=0.08U
+	 w=0.21U
M6450 XCTRLB_XALTCH_0_Z24 BISTT
+ XCTRLB_XALTCH_0_AX VSS nch l=0.08U
+ w=0.21U
M6451 XCTRLB_XALTCH_0_Z23 AB_0 VSS VSS
+ nch l=0.08U
+	 w=0.21U
M6452 XCTRLB_XALTCH_0_AX BISTC
+ XCTRLB_XALTCH_0_Z23 VSS nch l=0.08U
+ w=0.21U
M6453 VSS AB_9 XCTRLB_XALTCH_9_Z23 VSS
+ nch l=0.08U
+	 w=0.21U
M6454 VSS AMB_9 XCTRLB_XALTCH_9_Z24 VSS
+ nch l=0.08U
+	 w=0.21U
M6455 XCTRLB_XALTCH_9_Z24 BISTT
+ XCTRLB_XALTCH_9_AX VSS nch l=0.08U
+ w=0.21U
M6456 XCTRLB_XALTCH_9_AX BISTC
+ XCTRLB_XALTCH_9_Z23 VSS nch l=0.08U
+ w=0.21U
M6457 VSS AMB_3 XCTRLB_XALTCH_3_Z24 VSS
+ nch l=0.08U
+ w=0.21U
M6458 VSS AMB_2 XCTRLB_XALTCH_2_Z24 VSS
+ nch l=0.08U
+ w=0.21U
M6459 XCTRLB_XALTCH_2_Z24 BISTT
+ XCTRLB_XALTCH_2_AX VSS nch l=0.08U
+ w=0.21U
M6460 XCTRLB_XALTCH_2_AX BISTC
+ XCTRLB_XALTCH_2_Z23 VSS nch l=0.08U
+ w=0.21U
M6461 XCTRLB_XALTCH_1_Z23 AB_1 VSS VSS
+ nch l=0.08U
+	 w=0.21U
M6462 VSS AMB_1 XCTRLB_XALTCH_1_Z24 VSS
+ nch l=0.08U
+ w=0.21U
M6463 XCTRLB_XALTCH_1_Z24 BISTT
+ XCTRLB_XALTCH_1_AX VSS nch l=0.08U
+ w=0.21U
M6464 XCTRLB_XALTCH_1_AX BISTC
+ XCTRLB_XALTCH_1_Z23 VSS nch l=0.08U
+ w=0.21U
M6465 XCTRLB_XALTCH_2_Z23 AB_2 VSS VSS
+ nch l=0.08U
+	 w=0.21U
M6466 XCTRLB_XALTCH0_Z24 WEBMB VSS VSS
+ nch l=0.08U
+	 w=0.21U
M6467 XCTRLB_XALTCH0_Z24 BISTT
+ XCTRLB_XALTCH0_AX VSS nch l=0.08U
+ w=0.21U
M6468 VSS AMB_4 XCTRLB_XALTCH_4_Z24 VSS
+ nch l=0.08U
+ w=0.21U
M6469 XCTRLB_XALTCH_4_Z24 BISTT
+ XCTRLB_XALTCH_4_AX VSS nch l=0.08U
+ w=0.21U
M6470 XCTRLB_XALTCH_4_AX BISTC
+ XCTRLB_XALTCH_4_Z23 VSS nch l=0.08U
+ w=0.21U
M6471 XCTRLB_XALTCH_4_Z23 AB_4 VSS VSS
+ nch l=0.08U
+	 w=0.21U
M6472 VSS AB_3 XCTRLB_XALTCH_3_Z23 VSS
+ nch l=0.08U
+ w=0.21U
M6473 XCTRLB_XALTCH_3_Z24 BISTT
+ XCTRLB_XALTCH_3_AX VSS nch l=0.08U
+ w=0.21U
M6474 XCTRLB_XALTCH_3_AX BISTC
+ XCTRLB_XALTCH_3_Z23 VSS nch l=0.08U
+ w=0.21U
M6475 VSS WEBB XCTRLB_XALTCH0_Z23 VSS
+ nch l=0.08U
+	 w=0.21U
M6476 XCTRLB_XALTCH0_AX BISTC
+ XCTRLB_XALTCH0_Z23 VSS nch l=0.08U
+ w=0.21U
M6477 XCTRLA_XALTCH0_AX BISTC
+ XCTRLA_XALTCH0_Z23 VSS nch l=0.08U
+ w=0.21U
M6478 XCTRLA_XALTCH0_AX BISTT
+ XCTRLA_XALTCH0_Z24 VSS nch l=0.08U
+ w=0.21U
M6479 XCTRLA_XALTCH0_Z24 WEBMA VSS VSS
+ nch l=0.08U
+	 w=0.21U
M6480 VSS WEBA XCTRLA_XALTCH0_Z23 VSS
+ nch l=0.08U
+	 w=0.21U
M6481 XCTRLA_XALTCH_3_Z23 BISTC
+ XCTRLA_XALTCH_3_AX VSS nch l=0.08U
+ w=0.21U
M6482 XCTRLA_XALTCH_3_Z23 AA_3 VSS VSS
+ nch l=0.08U
+	 w=0.21U
M6483 VSS AA_4 XCTRLA_XALTCH_4_Z23 VSS
+ nch l=0.08U
+ w=0.21U
M6484 XCTRLA_XALTCH_4_Z23 BISTC
+ XCTRLA_XALTCH_4_AX VSS nch l=0.08U
+ w=0.21U
M6485 XCTRLA_XALTCH_4_AX BISTT
+ XCTRLA_XALTCH_4_Z24 VSS nch l=0.08U
+ w=0.21U
M6486 XCTRLA_XALTCH_4_Z24 AMA_4 VSS VSS
+ nch l=0.08U
+	 w=0.21U
M6487 VSS AMA_2 XCTRLA_XALTCH_2_Z24 VSS
+ nch l=0.08U
+ w=0.21U
M6488 XCTRLA_XALTCH_3_AX BISTT
+ XCTRLA_XALTCH_3_Z24 VSS nch l=0.08U
+ w=0.21U
M6489 VSS AMA_3 XCTRLA_XALTCH_3_Z24 VSS
+ nch l=0.08U
+ w=0.21U
M6490 VSS AA_2 XCTRLA_XALTCH_2_Z23 VSS
+ nch l=0.08U
+ w=0.21U
M6491 XCTRLA_XALTCH_1_AX BISTC
+ XCTRLA_XALTCH_1_Z23 VSS nch l=0.08U
+ w=0.21U
M6492 XCTRLA_XALTCH_1_AX BISTT
+ XCTRLA_XALTCH_1_Z24 VSS nch l=0.08U
+ w=0.21U
M6493 XCTRLA_XALTCH_1_Z24 AMA_1 VSS VSS
+ nch l=0.08U
+	 w=0.21U
M6494 XCTRLA_XALTCH_1_Z23 AA_1 VSS VSS
+ nch l=0.08U
+	 w=0.21U
M6495 XCTRLA_XALTCH_2_Z23 BISTC
+ XCTRLA_XALTCH_2_AX VSS nch l=0.08U
+ w=0.21U
M6496 XCTRLA_XALTCH_2_Z24 BISTT
+ XCTRLA_XALTCH_2_AX VSS nch l=0.08U
+ w=0.21U
M6497 XCTRLA_XALTCH_0_Z24 BISTT
+ XCTRLA_XALTCH_0_AX VSS nch l=0.08U
+ w=0.21U
M6498 VSS AMA_0 XCTRLA_XALTCH_0_Z24 VSS
+ nch l=0.08U
+	 w=0.21U
M6499 XCTRLA_XALTCH_9_AX BISTC
+ XCTRLA_XALTCH_9_Z23 VSS nch l=0.08U
+ w=0.21U
M6500 XCTRLA_XALTCH_9_AX BISTT
+ XCTRLA_XALTCH_9_Z24 VSS nch l=0.08U
+ w=0.21U
M6501 XCTRLA_XALTCH_9_Z24 AMA_9 VSS VSS
+ nch l=0.08U
+	 w=0.21U
M6502 XCTRLA_XALTCH_9_Z23 AA_9 VSS VSS
+ nch l=0.08U
+	 w=0.21U
M6503 XCTRLA_XALTCH_8_Z24 BISTT
+ XCTRLA_XALTCH_8_AX VSS nch l=0.08U
+ w=0.21U
M6504 VSS AMA_8 XCTRLA_XALTCH_8_Z24 VSS
+ nch l=0.08U
+ w=0.21U
M6505 XCTRLA_XALTCH_0_AX BISTC
+ XCTRLA_XALTCH_0_Z23 VSS nch l=0.08U
+ w=0.21U
M6506 VSS AA_0 XCTRLA_XALTCH_0_Z23 VSS
+ nch l=0.08U
+	 w=0.21U
M6507 XCTRLA_XALTCH_8_AX BISTC
+ XCTRLA_XALTCH_8_Z23 VSS nch l=0.08U
+ w=0.21U
M6508 XCTRLA_XALTCH_11_Z23 BISTC
+ XCTRLA_XALTCH_11_AX VSS nch l=0.08U
+ w=0.21U
M6509 XCTRLA_XALTCH_11_Z23 AA_11 VSS VSS
+ nch l=0.08U
+	 w=0.21U
M6510 XCTRLA_XALTCH_10_AX BISTC
+ XCTRLA_XALTCH_10_Z23 VSS nch l=0.08U
+ w=0.21U
M6511 XCTRLA_XALTCH_10_AX BISTT
+ XCTRLA_XALTCH_10_Z24 VSS nch l=0.08U
+ w=0.21U
M6512 XCTRLA_XALTCH_10_Z24 AMA_10 VSS VSS
+ nch l=0.08U
+	 w=0.21U
M6513 XCTRLA_XALTCH_10_Z23 AA_10 VSS VSS
+ nch l=0.08U
+	 w=0.21U
M6514 XCTRLA_XALTCH_11_AX BISTT
+ XCTRLA_XALTCH_11_Z24 VSS nch l=0.08U
+ w=0.21U
M6515 XCTRLA_XALTCH_11_Z24 AMA_11 VSS VSS
+ nch l=0.08U
+	 w=0.21U
M6516 VSS AA_8 XCTRLA_XALTCH_8_Z23 VSS
+ nch l=0.08U
+ w=0.21U
M6517 XCTRLA_XALTCH_7_Z23 AA_7 VSS VSS
+ nch l=0.08U
+	 w=0.21U
M6518 XCTRLA_XALTCH_12_AX BISTC
+ XCTRLA_XALTCH_12_Z23 VSS nch l=0.08U
+ w=0.21U
M6519 XCTRLA_XALTCH_12_AX BISTT
+ XCTRLA_XALTCH_12_Z24 VSS nch l=0.08U
+ w=0.21U
M6520 XCTRLA_XALTCH_12_Z24 AMA_12 VSS VSS
+ nch l=0.08U
+	 w=0.21U
M6521 XCTRLA_XALTCH_7_Z23 BISTC
+ XCTRLA_XALTCH_7_AX VSS nch l=0.08U
+ w=0.21U
M6522 XCTRLA_XALTCH_7_AX BISTT
+ XCTRLA_XALTCH_7_Z24 VSS nch l=0.08U
+ w=0.21U
M6523 VSS AMA_7 XCTRLA_XALTCH_7_Z24 VSS
+ nch l=0.08U
+ w=0.21U
M6524 VSS AA_12 XCTRLA_XALTCH_12_Z23 VSS
+ nch l=0.08U
+	 w=0.21U
M6525 VSS AA_6 XCTRLA_XALTCH_6_Z23 VSS
+ nch l=0.08U
+ w=0.21U
M6526 VSS AA_5 XCTRLA_XALTCH_5_Z23 VSS
+ nch l=0.08U
+ w=0.21U
M6527 VSS AA_13 XCTRLA_XALTCH_13_Z23 VSS
+ nch l=0.08U
+	 w=0.21U
M6528 XCTRLA_XALTCH_6_Z23 BISTC
+ XCTRLA_XALTCH_6_AX VSS nch l=0.08U
+ w=0.21U
M6529 XCTRLA_XALTCH_6_AX BISTT
+ XCTRLA_XALTCH_6_Z24 VSS nch l=0.08U
+ w=0.21U
M6530 XCTRLA_XALTCH_6_Z24 AMA_6 VSS VSS
+ nch l=0.08U
+	 w=0.21U
M6531 XCTRLA_XALTCH_5_Z23 BISTC
+ XCTRLA_XALTCH_5_AX VSS nch l=0.08U
+ w=0.21U
M6532 XCTRLA_XALTCH_5_Z24 BISTT
+ XCTRLA_XALTCH_5_AX VSS nch l=0.08U
+ w=0.21U
M6533 VSS AMA_5 XCTRLA_XALTCH_5_Z24 VSS
+ nch l=0.08U
+ w=0.21U
M6534 XCTRLA_XALTCH_13_AX BISTT
+ XCTRLA_XALTCH_13_Z24 VSS nch l=0.08U
+ w=0.21U
M6535 XCTRLA_XALTCH_13_AX BISTC
+ XCTRLA_XALTCH_13_Z23 VSS nch l=0.08U
+ w=0.21U
M6536 VSS AA_14 XCTRLA_XALTCH_14_Z23 VSS
+ nch l=0.08U
+ w=0.21U
M6537 XCTRLA_XALTCH_15_Z23 BISTC
+ XCTRLA_XALTCH_15_AX VSS nch l=0.08U
+ w=0.21U
M6538 VSS AA_15 XCTRLA_XALTCH_15_Z23 VSS
+ nch l=0.08U
+ w=0.21U
M6539 XCTRLA_XALTCH_13_Z24 AMA_13 VSS VSS
+ nch l=0.08U
+	 w=0.21U
M6540 XCTRLA_XALTCH_14_Z23 BISTC
+ XCTRLA_XALTCH_14_AX VSS nch l=0.08U
+ w=0.21U
M6541 XCTRLA_XALTCH_14_AX BISTT
+ XCTRLA_XALTCH_14_Z24 VSS nch l=0.08U
+ w=0.21U
M6542 XCTRLA_XALTCH_14_Z24 AMA_14 VSS VSS
+ nch l=0.08U
+	 w=0.21U
M6543 XCTRLA_XALTCH_15_AX BISTT
+ XCTRLA_XALTCH_15_Z24 VSS nch l=0.08U
+ w=0.21U
M6544 XCTRLA_XALTCH_15_Z24 AMA_15 VSS VSS
+ nch l=0.08U
+ w=0.21U
M6545 BISTT BISTC VSS VSS nch
+ l=0.06U
+ w=1U
M6546 BISTT BISTC VSS VSS nch
+ l=0.06U
+ w=1U
M6547 BISTC BIST VSS VSS nch
+ l=0.06U
+ w=1U
M6548 BISTC BIST VSS VSS nch
+ l=0.06U
+ w=1U
M6549 B_WENB_1 XCTRLB_XWENB0_1_Z1
+ VSS VSS nch_hvt l=0.06U
+ w=0.8U
M6550 B_WENB_1 XCTRLB_XWENB0_1_Z1
+ VSS VSS nch_hvt l=0.06U
+ w=0.8U
M6551 B_WENB_0 XCTRLB_XWENB0_0_Z1
+ VSS VSS nch_hvt l=0.06U
+ w=0.8U
M6552 B_WENB_0 XCTRLB_XWENB0_0_Z1
+ VSS VSS nch_hvt l=0.06U
+ w=0.8U
M6553 B_WENB_3 XCTRLB_XWENB0_3_Z1
+ VSS VSS nch_hvt l=0.06U
+ w=0.8U
M6554 B_WENB_3 XCTRLB_XWENB0_3_Z1
+ VSS VSS nch_hvt l=0.06U
+ w=0.8U
M6555 B_WENB_2 XCTRLB_XWENB0_2_Z1
+ VSS VSS nch_hvt l=0.06U
+ w=0.8U
M6556 B_WENB_2 XCTRLB_XWENB0_2_Z1
+ VSS VSS nch_hvt l=0.06U
+ w=0.8U
M6557 B_GCDEC_1 XCTRLB_XGCDEC0_1_Z1
+ VSS VSS nch_hvt l=0.06U
+ w=0.8U
M6558 B_GCDEC_0 XCTRLB_XGCDEC0_0_Z1
+ VSS VSS nch_hvt l=0.06U
+ w=0.8U
M6559 B_GCDEC_0 XCTRLB_XGCDEC0_0_Z1
+ VSS VSS nch_hvt l=0.06U
+ w=0.8U
M6560 B_WRT XCTRLB_XDEC1DWR_0_Z1 VSS
+ VSS nch_hvt l=0.06U
+	 w=0.8U
M6561 B_WRT XCTRLB_XDEC1DWR_0_Z1 VSS
+ VSS nch_hvt l=0.06U
+ w=0.8U
M6562 B_RD XCTRLB_XDEC1DWR_1_Z1 VSS
+ VSS nch_hvt l=0.06U
+ w=0.8U
M6563 B_RD XCTRLB_XDEC1DWR_1_Z1 VSS
+ VSS nch_hvt l=0.06U
+ w=0.8U
M6564 B_Y_4 XCTRLB_XDEC3DY_4_Z1 VSS
+ VSS nch_hvt l=0.06U
+ w=0.8U
M6565 B_Y_4 XCTRLB_XDEC3DY_4_Z1 VSS
+ VSS nch_hvt l=0.06U
+ w=0.8U
M6566 B_GCDEC_1 XCTRLB_XGCDEC0_1_Z1
+ VSS VSS nch_hvt l=0.06U
+ w=0.8U
M6567 B_GCDEC_3 XCTRLB_XGCDEC0_3_Z1
+ VSS VSS nch_hvt l=0.06U
+ w=0.8U
M6568 B_GCDEC_3 XCTRLB_XGCDEC0_3_Z1
+ VSS VSS nch_hvt l=0.06U
+ w=0.8U
M6569 B_GCDEC_2 XCTRLB_XGCDEC0_2_Z1
+ VSS VSS nch_hvt l=0.06U
+ w=0.8U
M6570 B_GCDEC_2 XCTRLB_XGCDEC0_2_Z1
+ VSS VSS nch_hvt l=0.06U
+ w=0.8U
M6571 B_Y_1 XCTRLB_XDEC3DY_1_Z1 VSS
+ VSS nch_hvt l=0.06U
+ w=0.8U
M6572 B_Y_1 XCTRLB_XDEC3DY_1_Z1 VSS
+ VSS nch_hvt l=0.06U
+ w=0.8U
M6573 B_Y_0 XCTRLB_XDEC3DY_0_Z1 VSS
+ VSS nch_hvt l=0.06U
+ w=0.8U
M6574 B_Y_0 XCTRLB_XDEC3DY_0_Z1 VSS
+ VSS nch_hvt l=0.06U
+ w=0.8U
M6575 B_Y_3 XCTRLB_XDEC3DY_3_Z1 VSS
+ VSS nch_hvt l=0.06U
+ w=0.8U
M6576 B_Y_3 XCTRLB_XDEC3DY_3_Z1 VSS
+ VSS nch_hvt l=0.06U
+ w=0.8U
M6577 B_Y_2 XCTRLB_XDEC3DY_2_Z1 VSS
+ VSS nch_hvt l=0.06U
+ w=0.8U
M6578 B_Y_2 XCTRLB_XDEC3DY_2_Z1 VSS
+ VSS nch_hvt l=0.06U
+ w=0.8U
M6579 B_XC_0 XCTRLB_XDEC3DXC_0_Z1 VSS
+ VSS nch_hvt l=0.06U
+	 w=0.8U
M6580 B_Y_7 XCTRLB_XDEC3DY_7_Z1 VSS
+ VSS nch_hvt l=0.06U
+ w=0.8U
M6581 B_Y_7 XCTRLB_XDEC3DY_7_Z1 VSS
+ VSS nch_hvt l=0.06U
+ w=0.8U
M6582 B_Y_6 XCTRLB_XDEC3DY_6_Z1 VSS
+ VSS nch_hvt l=0.06U
+ w=0.8U
M6583 B_Y_6 XCTRLB_XDEC3DY_6_Z1 VSS
+ VSS nch_hvt l=0.06U
+ w=0.8U
M6584 B_Y_5 XCTRLB_XDEC3DY_5_Z1 VSS
+ VSS nch_hvt l=0.06U
+ w=0.8U
M6585 B_Y_5 XCTRLB_XDEC3DY_5_Z1 VSS
+ VSS nch_hvt l=0.06U
+ w=0.8U
M6586 B_XB_3 XCTRLB_XDEC3DXB_3_Z1 VSS
+ VSS nch_hvt l=0.06U
+	 w=0.8U
M6587 B_XB_3 XCTRLB_XDEC3DXB_3_Z1 VSS
+ VSS nch_hvt l=0.06U
+	 w=0.8U
M6588 B_XB_2 XCTRLB_XDEC3DXB_2_Z1 VSS
+ VSS nch_hvt l=0.06U
+	 w=0.8U
M6589 B_XB_2 XCTRLB_XDEC3DXB_2_Z1 VSS
+ VSS nch_hvt l=0.06U
+	 w=0.8U
M6590 B_XB_1 XCTRLB_XDEC3DXB_1_Z1 VSS
+ VSS nch_hvt l=0.06U
+	 w=0.8U
M6591 B_XB_1 XCTRLB_XDEC3DXB_1_Z1 VSS
+ VSS nch_hvt l=0.06U
+	 w=0.8U
M6592 B_XB_0 XCTRLB_XDEC3DXB_0_Z1 VSS
+ VSS nch_hvt l=0.06U
+ w=0.8U
M6593 B_XB_0 XCTRLB_XDEC3DXB_0_Z1 VSS
+ VSS nch_hvt l=0.06U
+ w=0.8U
M6594 B_XC_7 XCTRLB_XDEC3DXC_7_Z1 VSS
+ VSS nch_hvt l=0.06U
+ w=0.8U
M6595 B_XC_7 XCTRLB_XDEC3DXC_7_Z1 VSS
+ VSS nch_hvt l=0.06U
+ w=0.8U
M6596 B_XC_6 XCTRLB_XDEC3DXC_6_Z1 VSS
+ VSS nch_hvt l=0.06U
+ w=0.8U
M6597 B_XC_6 XCTRLB_XDEC3DXC_6_Z1 VSS
+ VSS nch_hvt l=0.06U
+ w=0.8U
M6598 B_XC_5 XCTRLB_XDEC3DXC_5_Z1 VSS
+ VSS nch_hvt l=0.06U
+ w=0.8U
M6599 B_XC_5 XCTRLB_XDEC3DXC_5_Z1 VSS
+ VSS nch_hvt l=0.06U
+ w=0.8U
M6600 B_XC_4 XCTRLB_XDEC3DXC_4_Z1 VSS
+ VSS nch_hvt l=0.06U
+	 w=0.8U
M6601 B_XC_4 XCTRLB_XDEC3DXC_4_Z1 VSS
+ VSS nch_hvt l=0.06U
+	 w=0.8U
M6602 B_XC_3 XCTRLB_XDEC3DXC_3_Z1 VSS
+ VSS nch_hvt l=0.06U
+	 w=0.8U
M6603 B_XC_3 XCTRLB_XDEC3DXC_3_Z1 VSS
+ VSS nch_hvt l=0.06U
+	 w=0.8U
M6604 B_XC_2 XCTRLB_XDEC3DXC_2_Z1 VSS
+ VSS nch_hvt l=0.06U
+	 w=0.8U
M6605 B_XC_2 XCTRLB_XDEC3DXC_2_Z1 VSS
+ VSS nch_hvt l=0.06U
+	 w=0.8U
M6606 B_XC_1 XCTRLB_XDEC3DXC_1_Z1 VSS
+ VSS nch_hvt l=0.06U
+	 w=0.8U
M6607 B_XC_1 XCTRLB_XDEC3DXC_1_Z1 VSS
+ VSS nch_hvt l=0.06U
+	 w=0.8U
M6608 B_XC_0 XCTRLB_XDEC3DXC_0_Z1 VSS
+ VSS nch_hvt l=0.06U
+	 w=0.8U
M6609 B_XA_7 XCTRLB_XDEC3DXA_7_Z1 VSS
+ VSS nch_hvt l=0.06U
+ w=0.8U
M6610 B_XA_7 XCTRLB_XDEC3DXA_7_Z1 VSS
+ VSS nch_hvt l=0.06U
+ w=0.8U
M6611 B_XA_6 XCTRLB_XDEC3DXA_6_Z1 VSS
+ VSS nch_hvt l=0.06U
+ w=0.8U
M6612 B_XA_5 XCTRLB_XDEC3DXA_5_Z1 VSS
+ VSS nch_hvt l=0.06U
+ w=0.8U
M6613 B_XA_5 XCTRLB_XDEC3DXA_5_Z1 VSS
+ VSS nch_hvt l=0.06U
+ w=0.8U
M6614 B_XA_4 XCTRLB_XDEC3DXA_4_Z1 VSS
+ VSS nch_hvt l=0.06U
+ w=0.8U
M6615 B_XA_4 XCTRLB_XDEC3DXA_4_Z1 VSS
+ VSS nch_hvt l=0.06U
+ w=0.8U
M6616 B_XA_3 XCTRLB_XDEC3DXA_3_Z1 VSS
+ VSS nch_hvt l=0.06U
+ w=0.8U
M6617 B_XA_3 XCTRLB_XDEC3DXA_3_Z1 VSS
+ VSS nch_hvt l=0.06U
+ w=0.8U
M6618 B_XA_2 XCTRLB_XDEC3DXA_2_Z1 VSS
+ VSS nch_hvt l=0.06U
+ w=0.8U
M6619 B_XA_2 XCTRLB_XDEC3DXA_2_Z1 VSS
+ VSS nch_hvt l=0.06U
+ w=0.8U
M6620 B_XA_1 XCTRLB_XDEC3DXA_1_Z1 VSS
+ VSS nch_hvt l=0.06U
+ w=0.8U
M6621 B_XA_1 XCTRLB_XDEC3DXA_1_Z1 VSS
+ VSS nch_hvt l=0.06U
+ w=0.8U
M6622 B_XA_0 XCTRLB_XDEC3DXA_0_Z1 VSS
+ VSS nch_hvt l=0.06U
+ w=0.8U
M6623 B_XA_0 XCTRLB_XDEC3DXA_0_Z1 VSS
+ VSS nch_hvt l=0.06U
+ w=0.8U
M6624 B_Z_7 XCTRLB_XDEC3DZ_7_Z1 VSS
+ VSS nch_hvt l=0.06U
+ w=0.8U
M6625 B_Z_7 XCTRLB_XDEC3DZ_7_Z1 VSS
+ VSS nch_hvt l=0.06U
+ w=0.8U
M6626 B_Z_5 XCTRLB_XDEC3DZ_5_Z1 VSS
+ VSS nch_hvt l=0.06U
+ w=0.8U
M6627 B_Z_5 XCTRLB_XDEC3DZ_5_Z1 VSS
+ VSS nch_hvt l=0.06U
+ w=0.8U
M6628 B_Z_4 XCTRLB_XDEC3DZ_4_Z1 VSS
+ VSS nch_hvt l=0.06U
+ w=0.8U
M6629 B_Z_4 XCTRLB_XDEC3DZ_4_Z1 VSS
+ VSS nch_hvt l=0.06U
+ w=0.8U
M6630 B_Z_3 XCTRLB_XDEC3DZ_3_Z1 VSS
+ VSS nch_hvt l=0.06U
+ w=0.8U
M6631 B_Z_3 XCTRLB_XDEC3DZ_3_Z1 VSS
+ VSS nch_hvt l=0.06U
+ w=0.8U
M6632 B_Z_2 XCTRLB_XDEC3DZ_2_Z1 VSS
+ VSS nch_hvt l=0.06U
+ w=0.8U
M6633 B_Z_2 XCTRLB_XDEC3DZ_2_Z1 VSS
+ VSS nch_hvt l=0.06U
+ w=0.8U
M6634 B_Z_1 XCTRLB_XDEC3DZ_1_Z1 VSS
+ VSS nch_hvt l=0.06U
+ w=0.8U
M6635 B_Z_1 XCTRLB_XDEC3DZ_1_Z1 VSS
+ VSS nch_hvt l=0.06U
+ w=0.8U
M6636 B_Z_0 XCTRLB_XDEC3DZ_0_Z1 VSS
+ VSS nch_hvt l=0.06U
+ w=0.8U
M6637 B_Z_0 XCTRLB_XDEC3DZ_0_Z1 VSS
+ VSS nch_hvt l=0.06U
+ w=0.8U
M6638 B_XA_6 XCTRLB_XDEC3DXA_6_Z1 VSS
+ VSS nch_hvt l=0.06U
+ w=0.8U
M6639 B_Z_6 XCTRLB_XDEC3DZ_6_Z1 VSS
+ VSS nch_hvt l=0.06U
+ w=0.8U
M6640 B_Z_6 XCTRLB_XDEC3DZ_6_Z1 VSS
+ VSS nch_hvt l=0.06U
+ w=0.8U
M6641 XCTRLB_XCKENB0_CE CEBB VSS VSS
+ nch l=0.06U
+ w=0.21U
M6642 XCTRLB_XCKENB1_CE CEBMB VSS VSS
+ nch l=0.06U
+ w=0.21U
M6643 B_WRT XCTRLB_RSN VSS VSS nch
+ l=0.06U
+	 w=1U
M6644 B_WRT XCTRLB_RSN VSS VSS
+ nch l=0.06U
+	 w=1U
M6645 B_WENB_0 XCTRLB_RSN VSS VSS
+ nch l=0.06U
+	 w=1U
M6646 B_WENB_0 XCTRLB_RSN VSS VSS
+ nch l=0.06U
+	 w=1U
M6647 B_WENB_1 XCTRLB_RSN VSS VSS
+ nch l=0.06U
+	 w=1U
M6648 B_WENB_1 XCTRLB_RSN VSS VSS
+ nch l=0.06U
+	 w=1U
M6649 B_WENB_3 XCTRLB_RSN VSS VSS
+ nch l=0.06U
+	 w=1U
M6650 B_RD XCTRLB_RSN VSS VSS nch
+ l=0.06U
+	 w=1U
M6651 B_RD XCTRLB_RSN VSS VSS
+ nch l=0.06U
+	 w=1U
M6652 B_WENB_3 XCTRLB_RSN VSS VSS
+ nch l=0.06U
+	 w=1U
M6653 B_WENB_2 XCTRLB_RSN VSS VSS
+ nch l=0.06U
+	 w=1U
M6654 B_WENB_2 XCTRLB_RSN VSS VSS
+ nch l=0.06U
+	 w=1U
M6655 B_GCDEC_0 XCTRLB_RSN VSS VSS
+ nch l=0.06U
+	 w=1U
M6656 B_GCDEC_0 XCTRLB_RSN VSS VSS
+ nch l=0.06U
+	 w=1U
M6657 B_GCDEC_1 XCTRLB_RSN VSS VSS
+ nch l=0.06U
+	 w=1U
M6658 B_GCDEC_1 XCTRLB_RSN VSS VSS
+ nch l=0.06U
+	 w=1U
M6659 B_GCDEC_3 XCTRLB_RSN VSS VSS
+ nch l=0.06U
+	 w=1U
M6660 B_GCDEC_3 XCTRLB_RSN VSS VSS
+ nch l=0.06U
+	 w=1U
M6661 B_GCDEC_2 XCTRLB_RSN VSS VSS
+ nch l=0.06U
+	 w=1U
M6662 B_GCDEC_2 XCTRLB_RSN VSS VSS
+ nch l=0.06U
+	 w=1U
M6663 B_Y_0 XCTRLB_RSN VSS VSS nch
+ l=0.06U
+	 w=1U
M6664 B_Y_0 XCTRLB_RSN VSS VSS nch
+ l=0.06U
+	 w=1U
M6665 B_Y_1 XCTRLB_RSN VSS VSS nch
+ l=0.06U
+	 w=1U
M6666 B_Y_1 XCTRLB_RSN VSS VSS nch
+ l=0.06U
+	 w=1U
M6667 B_Y_3 XCTRLB_RSN VSS VSS nch
+ l=0.06U
+	 w=1U
M6668 B_Y_3 XCTRLB_RSN VSS VSS nch
+ l=0.06U
+	 w=1U
M6669 B_Y_2 XCTRLB_RSN VSS VSS nch
+ l=0.06U
+	 w=1U
M6670 B_Y_7 XCTRLB_RSN VSS VSS nch
+ l=0.06U
+	 w=1U
M6671 B_Y_7 XCTRLB_RSN VSS VSS nch
+ l=0.06U
+	 w=1U
M6672 B_Y_4 XCTRLB_RSN VSS VSS nch
+ l=0.06U
+	 w=1U
M6673 B_Y_4 XCTRLB_RSN VSS VSS nch
+ l=0.06U
+	 w=1U
M6674 B_Y_5 XCTRLB_RSN VSS VSS nch
+ l=0.06U
+	 w=1U
M6675 B_Y_5 XCTRLB_RSN VSS VSS nch
+ l=0.06U
+	 w=1U
M6676 B_Y_2 XCTRLB_RSN VSS VSS nch
+ l=0.06U
+	 w=1U
M6677 B_Y_6 XCTRLB_RSN VSS VSS nch
+ l=0.06U
+	 w=1U
M6678 B_Y_6 XCTRLB_RSN VSS VSS nch
+ l=0.06U
+	 w=1U
M6679 B_XB_3 XCTRLB_RSN VSS VSS nch
+ l=0.06U
+	 w=1U
M6680 B_XB_0 XCTRLB_RSN VSS VSS nch
+ l=0.06U
+	 w=1U
M6681 B_XB_0 XCTRLB_RSN VSS VSS
+ nch l=0.06U
+	 w=1U
M6682 B_XB_1 XCTRLB_RSN VSS VSS nch
+ l=0.06U
+	 w=1U
M6683 B_XB_1 XCTRLB_RSN VSS VSS
+ nch l=0.06U
+	 w=1U
M6684 B_XB_3 XCTRLB_RSN VSS VSS
+ nch l=0.06U
+	 w=1U
M6685 B_XB_2 XCTRLB_RSN VSS VSS nch
+ l=0.06U
+	 w=1U
M6686 B_XB_2 XCTRLB_RSN VSS VSS
+ nch l=0.06U
+	 w=1U
M6687 B_XC_3 XCTRLB_RSN VSS VSS nch
+ l=0.06U
+	 w=1U
M6688 B_XC_0 XCTRLB_RSN VSS VSS nch
+ l=0.06U
+	 w=1U
M6689 B_XC_0 XCTRLB_RSN VSS VSS
+ nch l=0.06U
+	 w=1U
M6690 B_XC_1 XCTRLB_RSN VSS VSS nch
+ l=0.06U
+	 w=1U
M6691 B_XC_1 XCTRLB_RSN VSS VSS
+ nch l=0.06U
+	 w=1U
M6692 B_XC_3 XCTRLB_RSN VSS VSS
+ nch l=0.06U
+	 w=1U
M6693 B_XC_2 XCTRLB_RSN VSS VSS nch
+ l=0.06U
+	 w=1U
M6694 B_XC_2 XCTRLB_RSN VSS VSS
+ nch l=0.06U
+	 w=1U
M6695 XCTRLB_XDWLDV_DWLC XCTRLB_CKP VSS
+ VSS nch l=0.06U
+	 w=0.61U
M6696 B_XC_7 XCTRLB_RSN VSS VSS nch
+ l=0.06U
+ w=1U
M6697 B_XC_4 XCTRLB_RSN VSS VSS nch
+ l=0.06U
+	 w=1U
M6698 B_XC_4 XCTRLB_RSN VSS VSS
+ nch l=0.06U
+	 w=1U
M6699 B_XC_5 XCTRLB_RSN VSS VSS nch
+ l=0.06U
+ w=1U
M6700 B_XC_5 XCTRLB_RSN VSS VSS
+ nch l=0.06U
+	 w=1U
M6701 B_XC_7 XCTRLB_RSN VSS VSS
+ nch l=0.06U
+ w=1U
M6702 B_XA_0 XCTRLB_RSN VSS VSS
+ nch l=0.06U
+ w=1U
M6703 B_XC_6 XCTRLB_RSN VSS VSS
+ nch l=0.06U
+ w=1U
M6704 B_XC_6 XCTRLB_RSN VSS VSS nch
+ l=0.06U
+ w=1U
M6705 B_XA_3 XCTRLB_RSN VSS VSS nch
+ l=0.06U
+ w=1U
M6706 B_XA_0 XCTRLB_RSN VSS VSS nch
+ l=0.06U
+ w=1U
M6707 B_XA_1 XCTRLB_RSN VSS VSS nch
+ l=0.06U
+ w=1U
M6708 B_XA_1 XCTRLB_RSN VSS VSS
+ nch l=0.06U
+ w=1U
M6709 B_XA_2 XCTRLB_RSN VSS VSS nch
+ l=0.06U
+ w=1U
M6710 B_XA_3 XCTRLB_RSN VSS VSS
+ nch l=0.06U
+ w=1U
M6711 B_XA_4 XCTRLB_RSN VSS VSS nch
+ l=0.06U
+ w=1U
M6712 B_XA_2 XCTRLB_RSN VSS VSS
+ nch l=0.06U
+ w=1U
M6713 B_XA_7 XCTRLB_RSN VSS VSS nch
+ l=0.06U
+ w=1U
M6714 B_XA_4 XCTRLB_RSN VSS VSS
+ nch l=0.06U
+ w=1U
M6715 B_XA_5 XCTRLB_RSN VSS VSS nch
+ l=0.06U
+ w=1U
M6716 B_XA_5 XCTRLB_RSN VSS VSS
+ nch l=0.06U
+ w=1U
M6717 B_XA_6 XCTRLB_RSN VSS VSS nch
+ l=0.06U
+ w=1U
M6718 B_XA_7 XCTRLB_RSN VSS VSS
+ nch l=0.06U
+	 w=1U
M6719 B_Z_0 XCTRLB_RSN VSS VSS nch
+ l=0.06U
+ w=1U
M6720 B_Z_0 XCTRLB_RSN VSS VSS nch
+ l=0.06U
+ w=1U
M6721 B_XA_6 XCTRLB_RSN VSS VSS
+ nch l=0.06U
+	 w=1U
M6722 B_Z_3 XCTRLB_RSN VSS VSS nch
+ l=0.06U
+ w=1U
M6723 B_Z_1 XCTRLB_RSN VSS VSS nch
+ l=0.06U
+ w=1U
M6724 B_Z_1 XCTRLB_RSN VSS VSS nch
+ l=0.06U
+ w=1U
M6725 B_Z_2 XCTRLB_RSN VSS VSS nch
+ l=0.06U
+ w=1U
M6726 B_Z_3 XCTRLB_RSN VSS VSS nch
+ l=0.06U
+ w=1U
M6727 B_Z_4 XCTRLB_RSN VSS VSS nch
+ l=0.06U
+ w=1U
M6728 B_Z_4 XCTRLB_RSN VSS VSS nch
+ l=0.06U
+ w=1U
M6729 B_Z_2 XCTRLB_RSN VSS VSS nch
+ l=0.06U
+ w=1U
M6730 B_Z_7 XCTRLB_RSN VSS VSS nch
+ l=0.06U
+ w=1U
M6731 B_Z_5 XCTRLB_RSN VSS VSS nch
+ l=0.06U
+ w=1U
M6732 B_Z_5 XCTRLB_RSN VSS VSS nch
+ l=0.06U
+ w=1U
M6733 B_Z_6 XCTRLB_RSN VSS VSS nch
+ l=0.06U
+ w=1U
M6734 B_Z_7 XCTRLB_RSN VSS VSS nch
+ l=0.06U
+ w=1U
M6735 B_Z_6 XCTRLB_RSN VSS VSS nch
+ l=0.06U
+	 w=1U
.ENDS
* DMCBLX4G
.SUBCKT SDL400W20S_NDMCBLX4G A_WL_3 A_WL_2 A_WL_1 A_WL_0 B_WL_3 B_WL_2
+	 B_WL_1 B_WL_0 NWELL SUB VHI DBL0 DBL1 GFA GFB
M6736 VHI A_WL_1 VHI SUB nchpg_hvtdpsr
+ l=0.08U w=0.105U
M6737 VHI A_WL_1 VHI SUB nchpg_hvtdpsr
+ l=0.08U w=0.105U
M6738 VHI A_WL_0 VHI SUB nchpg_hvtdpsr
+ l=0.08U w=0.105U
M6739 VHI A_WL_0 VHI SUB nchpg_hvtdpsr
+ l=0.08U w=0.105U
M6740 VHI A_WL_2 VHI SUB nchpg_hvtdpsr
+ l=0.08U w=0.105U
M6741 VHI A_WL_2 VHI SUB nchpg_hvtdpsr
+ l=0.08U w=0.105U
M6742 VHI A_WL_3 VHI SUB nchpg_hvtdpsr
+ l=0.08U w=0.105U
M6743 VHI A_WL_3 VHI SUB nchpg_hvtdpsr
+ l=0.08U w=0.105U
M6744 VDD VHI VHI NWELL pchpu_hvtdpsr
+ l=0.07U w=0.09U
M6745 VDD VHI VHI NWELL pchpu_hvtdpsr
+ l=0.07U w=0.09U
M6746 VDD VHI VHI NWELL pchpu_hvtdpsr
+ l=0.07U w=0.09U
M6747 VDD VHI VHI NWELL pchpu_hvtdpsr
+ l=0.07U w=0.09U
M6748 VDD VHI VHI NWELL pchpu_hvtdpsr
+ l=0.07U w=0.09U
M6749 VDD VHI VHI NWELL pchpu_hvtdpsr
+ l=0.07U w=0.09U
M6750 VDD VHI VHI NWELL pchpu_hvtdpsr
+ l=0.07U w=0.09U
M6751 VDD VHI VHI NWELL pchpu_hvtdpsr
+ l=0.07U w=0.09U
M6752 DBL0 VSS VHI SUB nchpg_hvtdpsr
+ l=0.08U w=0.105U
M6753 VHI VSS DBL1 SUB nchpg_hvtdpsr
+ l=0.08U w=0.105U
M6754 DBL0 VSS VHI SUB nchpg_hvtdpsr
+ l=0.08U w=0.105U
M6755 VHI VSS DBL1 SUB nchpg_hvtdpsr
+ l=0.08U w=0.105U
M6756 DBL0 VSS VHI SUB nchpg_hvtdpsr
+ l=0.08U w=0.105U
M6757 VHI VSS DBL1 SUB nchpg_hvtdpsr
+ l=0.08U w=0.105U
M6758 DBL0 VSS VHI SUB nchpg_hvtdpsr
+ l=0.08U w=0.105U
M6759 VHI VSS DBL1 SUB nchpg_hvtdpsr
+ l=0.08U w=0.105U
.ENDS
* DMCBLX4GF
.SUBCKT SDL400W20S_NDMCBLX4GF A_WL_3 A_WL_2 A_WL_1 A_WL_0 B_WL_3 B_WL_2
+	 B_WL_1 B_WL_0 NWELL SUB VHI DBL0 DBL1 GFA GFB
M6760 VHI A_WL_0 VHI SUB nchpg_hvtdpsr
+ l=0.08U w=0.105U
M6761 VHI A_WL_0 VHI SUB nchpg_hvtdpsr
+ l=0.08U w=0.105U
M6762 VHI A_WL_3 VHI SUB nchpg_hvtdpsr
+ l=0.08U w=0.105U
M6763 VHI A_WL_3 VHI SUB nchpg_hvtdpsr
+ l=0.08U w=0.105U
M6764 VHI A_WL_1 VHI SUB nchpg_hvtdpsr
+ l=0.08U w=0.105U
M6765 VHI A_WL_1 VHI SUB nchpg_hvtdpsr
+ l=0.08U w=0.105U
M6766 VHI A_WL_2 VHI SUB nchpg_hvtdpsr
+ l=0.08U w=0.105U
M6767 VHI A_WL_2 VHI SUB nchpg_hvtdpsr
+ l=0.08U w=0.105U
M6768 VDD VHI VHI NWELL pchpu_hvtdpsr
+ l=0.07U w=0.09U
M6769 VDD VHI VHI NWELL pchpu_hvtdpsr
+ l=0.07U w=0.09U
M6770 VDD VHI VHI NWELL pchpu_hvtdpsr
+ l=0.07U w=0.09U
M6771 VDD VHI VHI NWELL pchpu_hvtdpsr
+ l=0.07U w=0.09U
M6772 VDD VHI VHI NWELL pchpu_hvtdpsr
+ l=0.07U w=0.09U
M6773 VDD VHI VHI NWELL pchpu_hvtdpsr
+ l=0.07U w=0.09U
M6774 VDD VHI VHI NWELL pchpu_hvtdpsr
+ l=0.07U w=0.09U
M6775 VDD VHI VHI NWELL pchpu_hvtdpsr
+ l=0.07U w=0.09U
M6776 DBL0 VSS VHI SUB nchpg_hvtdpsr
+ l=0.08U w=0.105U
M6777 VHI VSS DBL1 SUB nchpg_hvtdpsr
+ l=0.08U w=0.105U
M6778 VHI VSS DBL1 SUB nchpg_hvtdpsr
+ l=0.08U w=0.105U
M6779 DBL0 VSS VHI SUB nchpg_hvtdpsr
+ l=0.08U w=0.105U
M6780 VHI VSS DBL1 SUB nchpg_hvtdpsr
+ l=0.08U w=0.105U
M6781 DBL0 VSS VHI SUB nchpg_hvtdpsr
+ l=0.08U w=0.105U
M6782 DBL0 VSS VHI SUB nchpg_hvtdpsr
+ l=0.08U w=0.105U
M6783 VHI VSS DBL1 SUB nchpg_hvtdpsr
+ l=0.08U w=0.105U
.ENDS
* DMCBLX4V
.SUBCKT SDL400W20S_NDMCBLX4V A_WL_3 A_WL_2 A_WL_1 A_WL_0 B_WL_3 B_WL_2
+	 B_WL_1 B_WL_0 NWELL SUB VHI DBL0 DBL1 GFA GFB
M6784 VHI A_WL_1 VHI SUB nchpg_hvtdpsr
+ l=0.08U w=0.105U
M6785 VHI A_WL_1 VHI SUB nchpg_hvtdpsr
+ l=0.08U w=0.105U
M6786 VHI A_WL_0 VHI SUB nchpg_hvtdpsr
+ l=0.08U w=0.105U
M6787 VHI A_WL_0 VHI SUB nchpg_hvtdpsr
+ l=0.08U w=0.105U
M6788 VHI A_WL_2 VHI SUB nchpg_hvtdpsr
+ l=0.08U w=0.105U
M6789 VHI A_WL_2 VHI SUB nchpg_hvtdpsr
+ l=0.08U w=0.105U
M6790 VHI A_WL_3 VHI SUB nchpg_hvtdpsr
+ l=0.08U w=0.105U
M6791 VHI A_WL_3 VHI SUB nchpg_hvtdpsr
+ l=0.08U w=0.105U
M6792 VDD VHI VHI NWELL pchpu_hvtdpsr
+ l=0.07U w=0.09U
M6793 VDD VHI VHI NWELL pchpu_hvtdpsr
+ l=0.07U w=0.09U
M6794 VDD VHI VHI NWELL pchpu_hvtdpsr
+ l=0.07U w=0.09U
M6795 VDD VHI VHI NWELL pchpu_hvtdpsr
+ l=0.07U w=0.09U
M6796 VDD VHI VHI NWELL pchpu_hvtdpsr
+ l=0.07U w=0.09U
M6797 VDD VHI VHI NWELL pchpu_hvtdpsr
+ l=0.07U w=0.09U
M6798 VDD VHI VHI NWELL pchpu_hvtdpsr
+ l=0.07U w=0.09U
M6799 VDD VHI VHI NWELL pchpu_hvtdpsr
+ l=0.07U w=0.09U
M6800 DBL0 VSS VHI SUB nchpg_hvtdpsr
+ l=0.08U w=0.105U
M6801 VHI VSS DBL1 SUB nchpg_hvtdpsr
+ l=0.08U w=0.105U
M6802 DBL0 VSS VHI SUB nchpg_hvtdpsr
+ l=0.08U w=0.105U
M6803 VHI VSS DBL1 SUB nchpg_hvtdpsr
+ l=0.08U w=0.105U
M6804 DBL0 VSS VHI SUB nchpg_hvtdpsr
+ l=0.08U w=0.105U
M6805 VHI VSS DBL1 SUB nchpg_hvtdpsr
+ l=0.08U w=0.105U
M6806 DBL0 VSS VHI SUB nchpg_hvtdpsr
+ l=0.08U w=0.105U
M6807 VHI VSS DBL1 SUB nchpg_hvtdpsr
+ l=0.08U w=0.105U
.ENDS
* DMCBLX4VF
.SUBCKT SDL400W20S_NDMCBLX4VF A_WL_3 A_WL_2 A_WL_1 A_WL_0 B_WL_3 B_WL_2
+	 B_WL_1 B_WL_0 NWELL SUB VHI DBL0 DBL1 GFA GFB
M6808 VHI A_WL_0 VHI SUB nchpg_hvtdpsr
+ l=0.08U w=0.105U
M6809 VHI A_WL_0 VHI SUB nchpg_hvtdpsr
+ l=0.08U w=0.105U
M6810 VHI A_WL_3 VHI SUB nchpg_hvtdpsr
+ l=0.08U w=0.105U
M6811 VHI A_WL_3 VHI SUB nchpg_hvtdpsr
+ l=0.08U w=0.105U
M6812 VHI A_WL_1 VHI SUB nchpg_hvtdpsr
+ l=0.08U w=0.105U
M6813 VHI A_WL_1 VHI SUB nchpg_hvtdpsr
+ l=0.08U w=0.105U
M6814 VHI A_WL_2 VHI SUB nchpg_hvtdpsr
+ l=0.08U w=0.105U
M6815 VHI A_WL_2 VHI SUB nchpg_hvtdpsr
+ l=0.08U w=0.105U
M6816 VDD VHI VHI NWELL pchpu_hvtdpsr
+ l=0.07U w=0.09U
M6817 VDD VHI VHI NWELL pchpu_hvtdpsr
+ l=0.07U w=0.09U
M6818 VDD VHI VHI NWELL pchpu_hvtdpsr
+ l=0.07U w=0.09U
M6819 VDD VHI VHI NWELL pchpu_hvtdpsr
+ l=0.07U w=0.09U
M6820 VDD VHI VHI NWELL pchpu_hvtdpsr
+ l=0.07U w=0.09U
M6821 VDD VHI VHI NWELL pchpu_hvtdpsr
+ l=0.07U w=0.09U
M6822 VDD VHI VHI NWELL pchpu_hvtdpsr
+ l=0.07U w=0.09U
M6823 VDD VHI VHI NWELL pchpu_hvtdpsr
+ l=0.07U w=0.09U
M6824 DBL0 VSS VHI SUB nchpg_hvtdpsr
+ l=0.08U w=0.105U
M6825 VHI VSS DBL1 SUB nchpg_hvtdpsr
+ l=0.08U w=0.105U
M6826 VHI VSS DBL1 SUB nchpg_hvtdpsr
+ l=0.08U w=0.105U
M6827 DBL0 VSS VHI SUB nchpg_hvtdpsr
+ l=0.08U w=0.105U
M6828 VHI VSS DBL1 SUB nchpg_hvtdpsr
+ l=0.08U w=0.105U
M6829 DBL0 VSS VHI SUB nchpg_hvtdpsr
+ l=0.08U w=0.105U
M6830 DBL0 VSS VHI SUB nchpg_hvtdpsr
+ l=0.08U w=0.105U
M6831 VHI VSS DBL1 SUB nchpg_hvtdpsr
+ l=0.08U w=0.105U
.ENDS
* DMCWL
.SUBCKT SDL400W20S_DMCWL DWL DWLF VHI GFA_3 GFA_2 GFA_1 GFA_0 GFB_3 GFB_2
+	 GFB_1 GFB_0
M6832 VDD VHI VHI VDD pchpu_hvtdpsr
+ l=0.07U w=0.09U
M6833 VDD VHI VHI VDD pchpu_hvtdpsr
+ l=0.07U w=0.09U
M6834 VDD VHI VHI VDD pchpu_hvtdpsr
+ l=0.07U w=0.09U
M6835 VDD VHI VHI VDD pchpu_hvtdpsr
+ l=0.07U w=0.09U
M6836 VDD VHI VHI VDD pchpu_hvtdpsr
+ l=0.07U w=0.09U
M6837 VDD VHI VHI VDD pchpu_hvtdpsr
+ l=0.07U w=0.09U
M6838 VDD VHI VHI VDD pchpu_hvtdpsr
+ l=0.07U w=0.09U
M6839 VDD VHI VHI VDD pchpu_hvtdpsr
+ l=0.07U w=0.09U
M6840 VDD VHI VHI VDD pchpu_hvtdpsr
+ l=0.07U w=0.09U
M6841 VDD VHI VHI VDD pchpu_hvtdpsr
+ l=0.07U w=0.09U
M6842 VDD VHI VHI VDD pchpu_hvtdpsr
+ l=0.07U w=0.09U
M6843 VDD VHI VHI VDD pchpu_hvtdpsr
+ l=0.07U w=0.09U
M6844 VDD VHI VHI VDD pchpu_hvtdpsr
+ l=0.07U w=0.09U
M6845 VDD VHI VHI VDD pchpu_hvtdpsr
+ l=0.07U w=0.09U
M6846 VDD VHI VHI VDD pchpu_hvtdpsr
+ l=0.07U w=0.09U
M6847 VDD VHI VHI VDD pchpu_hvtdpsr
+ l=0.07U w=0.09U
M6848 VHI VSS VHI VSS nchpg_hvtdpsr
+ l=0.08U w=0.105U
M6849 VHI VSS VHI VSS nchpg_hvtdpsr
+ l=0.08U w=0.105U
M6850 VHI VSS VHI VSS nchpg_hvtdpsr
+ l=0.08U w=0.105U
M6851 VHI VSS VHI VSS nchpg_hvtdpsr
+ l=0.08U w=0.105U
M6852 VHI VSS VHI VSS nchpg_hvtdpsr
+ l=0.08U w=0.105U
M6853 VHI VSS VHI VSS nchpg_hvtdpsr
+ l=0.08U w=0.105U
M6854 VHI VSS VHI VSS nchpg_hvtdpsr
+ l=0.08U w=0.105U
M6855 VHI VSS VHI VSS nchpg_hvtdpsr
+ l=0.08U w=0.105U
M6856 VHI VSS VHI VSS nchpg_hvtdpsr
+ l=0.08U w=0.105U
M6857 VHI VSS VHI VSS nchpg_hvtdpsr
+ l=0.08U w=0.105U
M6858 VHI DWL VHI VSS nchpg_hvtdpsr
+ l=0.08U w=0.105U
M6859 VHI DWL VHI VSS nchpg_hvtdpsr
+ l=0.08U w=0.105U
M6860 VHI DWL VHI VSS nchpg_hvtdpsr
+ l=0.08U w=0.105U
M6861 VHI DWL VHI VSS nchpg_hvtdpsr
+ l=0.08U w=0.105U
M6862 VHI DWL VHI VSS nchpg_hvtdpsr
+ l=0.08U w=0.105U
M6863 VHI DWL VHI VSS nchpg_hvtdpsr
+ l=0.08U w=0.105U
M6864 VHI DWL VHI VSS nchpg_hvtdpsr
+ l=0.08U w=0.105U
M6865 VHI DWL VHI VSS nchpg_hvtdpsr
+ l=0.08U w=0.105U
M6866 VHI VSS VHI VSS nchpg_hvtdpsr
+ l=0.08U w=0.105U
M6867 VHI VSS VHI VSS nchpg_hvtdpsr
+ l=0.08U w=0.105U
M6868 VHI VSS VHI VSS nchpg_hvtdpsr
+ l=0.08U w=0.105U
M6869 VHI VSS VHI VSS nchpg_hvtdpsr
+ l=0.08U w=0.105U
M6870 VHI VSS VHI VSS nchpg_hvtdpsr
+ l=0.08U w=0.105U
M6871 VHI VSS VHI VSS nchpg_hvtdpsr
+ l=0.08U w=0.105U
M6872 VHI DWLF VHI VSS nchpg_hvtdpsr
+ l=0.08U w=0.105U
M6873 VHI DWLF VHI VSS nchpg_hvtdpsr
+ l=0.08U w=0.105U
M6874 VHI DWLF VHI VSS nchpg_hvtdpsr
+ l=0.08U w=0.105U
M6875 VHI DWLF VHI VSS nchpg_hvtdpsr
+ l=0.08U w=0.105U
M6876 VHI DWLF VHI VSS nchpg_hvtdpsr
+ l=0.08U w=0.105U
M6877 VHI DWLF VHI VSS nchpg_hvtdpsr
+ l=0.08U w=0.105U
M6878 VHI DWLF VHI VSS nchpg_hvtdpsr
+ l=0.08U w=0.105U
M6879 VHI DWLF VHI VSS nchpg_hvtdpsr
+ l=0.08U w=0.105U
.ENDS
* DMCWLN
.SUBCKT SDL400W20S_DMCWLN DWL DWLF VHI GFA_3 GFA_2 GFA_1 GFA_0 GFB_3
+	 GFB_2 GFB_1 GFB_0
M6880 VDD VHI VHI VDD pchpu_hvtdpsr
+ l=0.07U w=0.09U
M6881 VDD VHI VHI VDD pchpu_hvtdpsr
+ l=0.07U w=0.09U
M6882 VDD VHI VHI VDD pchpu_hvtdpsr
+ l=0.07U w=0.09U
M6883 VDD VHI VHI VDD pchpu_hvtdpsr
+ l=0.07U w=0.09U
M6884 VDD VHI VHI VDD pchpu_hvtdpsr
+ l=0.07U w=0.09U
M6885 VDD VHI VHI VDD pchpu_hvtdpsr
+ l=0.07U w=0.09U
M6886 VDD VHI VHI VDD pchpu_hvtdpsr
+ l=0.07U w=0.09U
M6887 VDD VHI VHI VDD pchpu_hvtdpsr
+ l=0.07U w=0.09U
M6888 VDD VHI VHI VDD pchpu_hvtdpsr
+ l=0.07U w=0.09U
M6889 VDD VHI VHI VDD pchpu_hvtdpsr
+ l=0.07U w=0.09U
M6890 VDD VHI VHI VDD pchpu_hvtdpsr
+ l=0.07U w=0.09U
M6891 VDD VHI VHI VDD pchpu_hvtdpsr
+ l=0.07U w=0.09U
M6892 VHI VSS VHI VSS nchpg_hvtdpsr
+ l=0.08U w=0.105U
M6893 VHI VSS VHI VSS nchpg_hvtdpsr
+ l=0.08U w=0.105U
M6894 VHI VSS VHI VSS nchpg_hvtdpsr
+ l=0.08U w=0.105U
M6895 VHI VSS VHI VSS nchpg_hvtdpsr
+ l=0.08U w=0.105U
M6896 VHI VSS VHI VSS nchpg_hvtdpsr
+ l=0.08U w=0.105U
M6897 VHI VSS VHI VSS nchpg_hvtdpsr
+ l=0.08U w=0.105U
M6898 VHI VSS VHI VSS nchpg_hvtdpsr
+ l=0.08U w=0.105U
M6899 VHI VSS VHI VSS nchpg_hvtdpsr
+ l=0.08U w=0.105U
M6900 VHI DWL VHI VSS nchpg_hvtdpsr
+ l=0.08U w=0.105U
M6901 VHI DWL VHI VSS nchpg_hvtdpsr
+ l=0.08U w=0.105U
M6902 VHI DWL VHI VSS nchpg_hvtdpsr
+ l=0.08U w=0.105U
M6903 VHI DWL VHI VSS nchpg_hvtdpsr
+ l=0.08U w=0.105U
M6904 VHI DWL VHI VSS nchpg_hvtdpsr
+ l=0.08U w=0.105U
M6905 VHI DWL VHI VSS nchpg_hvtdpsr
+ l=0.08U w=0.105U
M6906 VHI VSS VHI VSS nchpg_hvtdpsr
+ l=0.08U w=0.105U
M6907 VHI VSS VHI VSS nchpg_hvtdpsr
+ l=0.08U w=0.105U
M6908 VHI VSS VHI VSS nchpg_hvtdpsr
+ l=0.08U w=0.105U
M6909 VHI VSS VHI VSS nchpg_hvtdpsr
+ l=0.08U w=0.105U
M6910 VHI DWLF VHI VSS nchpg_hvtdpsr
+ l=0.08U w=0.105U
M6911 VHI DWLF VHI VSS nchpg_hvtdpsr
+ l=0.08U w=0.105U
M6912 VHI DWLF VHI VSS nchpg_hvtdpsr
+ l=0.08U w=0.105U
M6913 VHI DWLF VHI VSS nchpg_hvtdpsr
+ l=0.08U w=0.105U
M6914 VHI DWLF VHI VSS nchpg_hvtdpsr
+ l=0.08U w=0.105U
M6915 VHI DWLF VHI VSS nchpg_hvtdpsr
+ l=0.08U w=0.105U
.ENDS
* DMCWLN0
.SUBCKT SDL400W20S_DMCWLN0 DWL VHI GFA_3 GFA_2 GFA_1 GFA_0 GFB_3 GFB_2
+	 GFB_1 GFB_0
M6916 VHI VHI VDD VDD pchpu_hvtdpsr
+ l=0.07U w=0.09U
M6917 VHI VHI VDD VDD pchpu_hvtdpsr
+ l=0.07U w=0.09U
M6918 VHI VHI VDD VDD pchpu_hvtdpsr
+ l=0.07U w=0.09U
M6919 VHI VHI VDD VDD pchpu_hvtdpsr
+ l=0.07U w=0.09U
M6920 VHI VHI VDD VDD pchpu_hvtdpsr
+ l=0.07U w=0.09U
M6921 VHI VHI VDD VDD pchpu_hvtdpsr
+ l=0.07U w=0.09U
M6922 VHI VHI VDD VDD pchpu_hvtdpsr
+ l=0.07U w=0.09U
M6923 VHI VHI VDD VDD pchpu_hvtdpsr
+ l=0.07U w=0.09U
M6924 VHI VSS VHI VSS nchpg_hvtdpsr
+ l=0.08U w=0.105U
M6925 VHI VSS VHI VSS nchpg_hvtdpsr
+ l=0.08U w=0.105U
M6926 VHI VSS VHI VSS nchpg_hvtdpsr
+ l=0.08U w=0.105U
M6927 VHI VSS VHI VSS nchpg_hvtdpsr
+ l=0.08U w=0.105U
M6928 VHI DWL VHI VSS nchpg_hvtdpsr
+ l=0.08U w=0.105U
M6929 VHI DWL VHI VSS nchpg_hvtdpsr
+ l=0.08U w=0.105U
M6930 VHI DWL VHI VSS nchpg_hvtdpsr
+ l=0.08U w=0.105U
M6931 VHI DWL VHI VSS nchpg_hvtdpsr
+ l=0.08U w=0.105U
M6932 VHI VSS VHI VSS nchpg_hvtdpsr
+ l=0.08U w=0.105U
M6933 VHI VSS VHI VSS nchpg_hvtdpsr
+ l=0.08U w=0.105U
M6934 VHI VSS VHI VSS nchpg_hvtdpsr
+ l=0.08U w=0.105U
M6935 VHI VSS VHI VSS nchpg_hvtdpsr
+ l=0.08U w=0.105U
M6936 VHI DWL VHI VSS nchpg_hvtdpsr
+ l=0.08U w=0.105U
M6937 VHI DWL VHI VSS nchpg_hvtdpsr
+ l=0.08U w=0.105U
M6938 VHI DWL VHI VSS nchpg_hvtdpsr
+ l=0.08U w=0.105U
M6939 VHI DWL VHI VSS nchpg_hvtdpsr
+ l=0.08U w=0.105U
.ENDS
* LCTRLA
.SUBCKT SDL400W20S_NLCTRLA A_GCDEC_3 A_GCDEC_2 A_GCDEC_1 A_GCDEC_0 A_RD
+	 A_VS_1 A_VS_0 A_WRT A_XA_7 A_XA_6 A_XA_5 A_XA_4 A_XA_3 A_XA_2
+	 A_XA_1 A_XA_0 A_XB_3 A_XB_2 A_XB_1 A_XB_0 A_XC_7 A_XC_6
+	 A_XC_5 A_XC_4 A_XC_3 A_XC_2 A_XC_1 A_XC_0 A_Y_7 A_Y_6 A_Y_5
+	 A_Y_4 A_Y_3 A_Y_2 A_Y_1 A_Y_0 B_GCDEC_3 B_GCDEC_2 B_GCDEC_1
+	 B_GCDEC_0 B_RD B_VS_1 B_VS_0 B_WRT B_XA_7 B_XA_6 B_XA_5
+	 B_XA_4 B_XA_3 B_XA_2 B_XA_1 B_XA_0 B_XB_3 B_XB_2 B_XB_1
+	 B_XB_0 B_XC_7 B_XC_6 B_XC_5 B_XC_4 B_XC_3 B_XC_2 B_XC_1
+	 B_XC_0 B_Y_7 B_Y_6 B_Y_5 B_Y_4 B_Y_3 B_Y_2 B_Y_1 B_Y_0 ZZ RDL
+	 SMPRS_3 SMPRS_2 SMPRS_1 SMPRS_0 SOE WRTL XLA_7 XLA_6 XLA_5
+	 XLA_4 XLA_3 XLA_2 XLA_1 XLA_0 XLB_3 XLB_2 XLB_1 XLB_0 XLC_7
+	 XLC_6 XLC_5 XLC_4 XLC_3 XLC_2 XLC_1 XLC_0 YSEL_7 YSEL_6
+	 YSEL_5 YSEL_4 YSEL_3 YSEL_2 YSEL_1 YSEL_0 A_Z_7 A_Z_6 A_Z_5
+	 A_Z_4 A_Z_3 A_Z_2 A_Z_1 A_Z_0 B_Z_7 B_Z_6 B_Z_5 B_Z_4 B_Z_3
+	 B_Z_2 B_Z_1 B_Z_0
M6940 VDD ZZ XLCTRL_XXLDECC0_N2_2 VDD
+ pch l=0.06U
+ w=0.41U
M6941 VDD ZZ XLCTRL_XXLDECC0_N2_1 VDD
+ pch l=0.06U
+ w=0.41U
M6942 VDD ZZ XLCTRL_XXLDECC0_N2_0 VDD
+ pch l=0.06U
+ w=0.41U
M6943 VDD ZZ XLCTRL_XXLDECA0_N2_0 VDD
+ pch l=0.06U
+ w=0.41U
M6944 VDD ZZ XLCTRL_XXLDECA0_N2_1 VDD
+ pch l=0.06U
+ w=0.41U
M6945 VDD ZZ XLCTRL_XXLDECA0_N2_2 VDD
+ pch l=0.06U
+ w=0.41U
M6946 VDD ZZ XLCTRL_XXLDECA0_N2_3 VDD
+ pch l=0.06U
+ w=0.41U
M6947 VDD A_XC_3 XLCTRL_XXLDECC0_N2_3
+ VDD pch l=0.06U
+	 w=0.615U
M6948 VDD A_XC_2 XLCTRL_XXLDECC0_N2_2
+ VDD pch l=0.06U
+	 w=0.615U
M6949 VDD A_XC_2 XLCTRL_XXLDECC0_N2_2 VDD
+ pch l=0.06U
+ w=0.615U
M6950 VDD A_XC_1 XLCTRL_XXLDECC0_N2_1 VDD
+ pch l=0.06U
+ w=0.615U
M6951 VDD A_XC_1 XLCTRL_XXLDECC0_N2_1
+ VDD pch l=0.06U
+	 w=0.615U
M6952 VDD A_XC_0 XLCTRL_XXLDECC0_N2_0 VDD
+ pch l=0.06U
+	 w=0.615U
M6953 VDD A_XC_0 XLCTRL_XXLDECC0_N2_0
+ VDD pch l=0.06U
+ w=0.615U
M6954 VDD A_XA_6 XLCTRL_XXLDECA0_N2_0
+ VDD pch l=0.06U
+ w=0.615U
M6955 VDD A_XA_6 XLCTRL_XXLDECA0_N2_0 VDD
+ pch l=0.06U
+	 w=0.615U
M6956 VDD A_XA_4 XLCTRL_XXLDECA0_N2_1
+ VDD pch l=0.06U
+	 w=0.615U
M6957 VDD A_XA_4 XLCTRL_XXLDECA0_N2_1 VDD
+ pch l=0.06U
+ w=0.615U
M6958 VDD A_XA_2 XLCTRL_XXLDECA0_N2_2 VDD
+ pch l=0.06U
+ w=0.615U
M6959 VDD A_XA_2 XLCTRL_XXLDECA0_N2_2
+ VDD pch l=0.06U
+	 w=0.615U
M6960 VDD A_XA_0 XLCTRL_XXLDECA0_N2_3
+ VDD pch l=0.06U
+	 w=0.615U
M6961 VDD A_XA_0 XLCTRL_XXLDECA0_N2_3 VDD
+ pch l=0.06U
+	 w=0.615U
M6962 VDD XLCTRL_XXLDECC0_N2_3 XLC_3
+ VDD pch_hvt l=0.06U
+ w=3.335U
M6963 VDD XLCTRL_XXLDECC0_N2_3 XLC_3
+ VDD pch_hvt l=0.06U
+ w=3.335U
M6964 VDD XLCTRL_XXLDECC0_N2_2 XLC_2
+ VDD pch_hvt l=0.06U
+ w=3.335U
M6965 VDD XLCTRL_XXLDECC0_N2_2 XLC_2
+ VDD pch_hvt l=0.06U
+ w=3.335U
M6966 VDD XLCTRL_XXLDECC0_N2_2 XLC_2
+ VDD pch_hvt l=0.06U
+ w=3.335U
M6967 VDD XLCTRL_XXLDECC0_N2_1 XLC_1
+ VDD pch_hvt l=0.06U
+ w=3.335U
M6968 VDD XLCTRL_XXLDECC0_N2_1 XLC_1
+ VDD pch_hvt l=0.06U
+ w=3.335U
M6969 VDD XLCTRL_XXLDECC0_N2_1 XLC_1
+ VDD pch_hvt l=0.06U
+ w=3.335U
M6970 VDD XLCTRL_XXLDECC0_N2_0 XLC_0
+ VDD pch_hvt l=0.06U
+ w=3.335U
M6971 VDD XLCTRL_XXLDECC0_N2_0 XLC_0
+ VDD pch_hvt l=0.06U
+ w=3.335U
M6972 VDD XLCTRL_XXLDECC0_N2_0 XLC_0
+ VDD pch_hvt l=0.06U
+ w=3.335U
M6973 VDD XLCTRL_XXLDECA0_N2_0 XLA_6
+ VDD pch_hvt l=0.06U
+ w=3.335U
M6974 VDD XLCTRL_XXLDECA0_N2_0 XLA_6
+ VDD pch_hvt l=0.06U
+ w=3.335U
M6975 VDD XLCTRL_XXLDECA0_N2_0 XLA_6
+ VDD pch_hvt l=0.06U
+ w=3.335U
M6976 VDD XLCTRL_XXLDECA0_N2_1 XLA_4
+ VDD pch_hvt l=0.06U
+ w=3.335U
M6977 VDD XLCTRL_XXLDECA0_N2_1 XLA_4
+ VDD pch_hvt l=0.06U
+ w=3.335U
M6978 VDD XLCTRL_XXLDECA0_N2_1 XLA_4
+ VDD pch_hvt l=0.06U
+ w=3.335U
M6979 VDD XLCTRL_XXLDECA0_N2_2 XLA_2
+ VDD pch_hvt l=0.06U
+ w=3.335U
M6980 VDD XLCTRL_XXLDECA0_N2_2 XLA_2
+ VDD pch_hvt l=0.06U
+ w=3.335U
M6981 VDD XLCTRL_XXLDECA0_N2_2 XLA_2
+ VDD pch_hvt l=0.06U
+ w=3.335U
M6982 VDD XLCTRL_XXLDECA0_N2_3 XLA_0
+ VDD pch_hvt l=0.06U
+ w=3.335U
M6983 VDD XLCTRL_XXLDECA0_N2_3 XLA_0
+ VDD pch_hvt l=0.06U
+ w=3.335U
M6984 VDD XLCTRL_XXLDECA0_N2_3 XLA_0
+ VDD pch_hvt l=0.06U
+ w=3.335U
M6985 VDD ZZ XLCTRL_XRWDEC_WRTLC VDD
+ pch l=0.06U
+ w=0.41U
M6986 VDD A_WRT XLCTRL_XRWDEC_WRTLC VDD
+ pch l=0.06U
+ w=0.615U
M6987 VDD A_WRT XLCTRL_XRWDEC_WRTLC VDD
+ pch l=0.06U
+ w=0.615U
M6988 VDD XLCTRL_XRWDEC_WRTLC WRTL VDD
+ pch_hvt l=0.06U
+ w=3.335U
M6989 VDD XLCTRL_XRWDEC_WRTLC WRTL
+ VDD pch_hvt l=0.06U
+ w=3.335U
M6990 VDD XLCTRL_XRWDEC_WRTLC WRTL
+ VDD pch_hvt l=0.06U
+ w=3.335U
M6991 VDD XLCTRL_XXLDECC0_N2_3 XLC_3
+ VDD pch_hvt l=0.06U
+ w=3.335U
M6992 VDD ZZ XLCTRL_XXLDECC0_N2_3 VDD
+ pch l=0.06U
+	 w=0.41U
M6993 VDD A_XC_3 XLCTRL_XXLDECC0_N2_3 VDD
+ pch l=0.06U
+ w=0.615U
M6994 XLC_1 XLCTRL_XXLDECC0_N2_1 VSS
+ VSS nch_hvt l=0.06U
+ w=1.11U
M6995 XLC_1 XLCTRL_XXLDECC0_N2_1 VSS
+ VSS nch_hvt l=0.06U
+	 w=1.11U
M6996 XLC_1 XLCTRL_XXLDECC0_N2_1 VSS
+ VSS nch_hvt l=0.06U
+ w=1.11U
M6997 XLC_2 XLCTRL_XXLDECC0_N2_2 VSS
+ VSS nch_hvt l=0.06U
+ w=1.11U
M6998 XLC_2 XLCTRL_XXLDECC0_N2_2 VSS
+ VSS nch_hvt l=0.06U
+	 w=1.11U
M6999 XLC_2 XLCTRL_XXLDECC0_N2_2 VSS
+ VSS nch_hvt l=0.06U
+ w=1.11U
M7000 XLA_2 XLCTRL_XXLDECA0_N2_2 VSS
+ VSS nch_hvt l=0.06U
+ w=1.11U
M7001 XLA_2 XLCTRL_XXLDECA0_N2_2 VSS
+ VSS nch_hvt l=0.06U
+	 w=1.11U
M7002 XLA_2 XLCTRL_XXLDECA0_N2_2 VSS
+ VSS nch_hvt l=0.06U
+ w=1.11U
M7003 XLA_4 XLCTRL_XXLDECA0_N2_1 VSS
+ VSS nch_hvt l=0.06U
+ w=1.11U
M7004 XLA_4 XLCTRL_XXLDECA0_N2_1 VSS
+ VSS nch_hvt l=0.06U
+	 w=1.11U
M7005 XLA_4 XLCTRL_XXLDECA0_N2_1 VSS
+ VSS nch_hvt l=0.06U
+ w=1.11U
M7006 XLC_6 XLCTRL_XXLDECC1_N2_2 VSS
+ VSS nch_hvt l=0.06U
+ w=1.11U
M7007 XLC_6 XLCTRL_XXLDECC1_N2_2 VSS
+ VSS nch_hvt l=0.06U
+	 w=1.11U
M7008 XLC_6 XLCTRL_XXLDECC1_N2_2 VSS
+ VSS nch_hvt l=0.06U
+ w=1.11U
M7009 XLC_5 XLCTRL_XXLDECC1_N2_1 VSS
+ VSS nch_hvt l=0.06U
+ w=1.11U
M7010 XLC_5 XLCTRL_XXLDECC1_N2_1 VSS
+ VSS nch_hvt l=0.06U
+	 w=1.11U
M7011 XLC_5 XLCTRL_XXLDECC1_N2_1 VSS
+ VSS nch_hvt l=0.06U
+ w=1.11U
M7012 XLA_5 XLCTRL_XXLDECA1_N2_1 VSS
+ VSS nch_hvt l=0.06U
+ w=1.11U
M7013 XLA_5 XLCTRL_XXLDECA1_N2_1 VSS
+ VSS nch_hvt l=0.06U
+	 w=1.11U
M7014 XLA_5 XLCTRL_XXLDECA1_N2_1 VSS
+ VSS nch_hvt l=0.06U
+ w=1.11U
M7015 XLA_3 XLCTRL_XXLDECA1_N2_2 VSS
+ VSS nch_hvt l=0.06U
+ w=1.11U
M7016 XLA_3 XLCTRL_XXLDECA1_N2_2 VSS
+ VSS nch_hvt l=0.06U
+	 w=1.11U
M7017 XLA_3 XLCTRL_XXLDECA1_N2_2 VSS
+ VSS nch_hvt l=0.06U
+ w=1.11U
M7018 VDD XLCTRL_XXLDECC1_N2_0 XLC_4
+ VDD pch_hvt l=0.06U
+ w=3.335U
M7019 VDD XLCTRL_XXLDECC1_N2_0 XLC_4
+ VDD pch_hvt l=0.06U
+	 w=3.335U
M7020 VDD XLCTRL_XXLDECC1_N2_1 XLC_5
+ VDD pch_hvt l=0.06U
+ w=3.335U
M7021 VDD XLCTRL_XXLDECC1_N2_1 XLC_5
+ VDD pch_hvt l=0.06U
+ w=3.335U
M7022 VDD XLCTRL_XXLDECC1_N2_1 XLC_5
+ VDD pch_hvt l=0.06U
+ w=3.335U
M7023 VDD XLCTRL_XXLDECC1_N2_2 XLC_6
+ VDD pch_hvt l=0.06U
+ w=3.335U
M7024 VDD XLCTRL_XXLDECC1_N2_2 XLC_6
+ VDD pch_hvt l=0.06U
+ w=3.335U
M7025 VDD XLCTRL_XXLDECC1_N2_2 XLC_6
+ VDD pch_hvt l=0.06U
+ w=3.335U
M7026 VDD XLCTRL_XXLDECC1_N2_3 XLC_7
+ VDD pch_hvt l=0.06U
+ w=3.335U
M7027 VDD XLCTRL_XXLDECC1_N2_3 XLC_7
+ VDD pch_hvt l=0.06U
+ w=3.335U
M7028 VDD XLCTRL_XXLDECC1_N2_3 XLC_7
+ VDD pch_hvt l=0.06U
+ w=3.335U
M7029 VDD XLCTRL_XXLDECA1_N2_3 XLA_1
+ VDD pch_hvt l=0.06U
+ w=3.335U
M7030 VDD XLCTRL_XXLDECA1_N2_3 XLA_1
+ VDD pch_hvt l=0.06U
+ w=3.335U
M7031 VDD XLCTRL_XXLDECA1_N2_3 XLA_1
+ VDD pch_hvt l=0.06U
+ w=3.335U
M7032 VDD XLCTRL_XXLDECA1_N2_2 XLA_3
+ VDD pch_hvt l=0.06U
+ w=3.335U
M7033 VDD XLCTRL_XXLDECA1_N2_2 XLA_3
+ VDD pch_hvt l=0.06U
+ w=3.335U
M7034 VDD XLCTRL_XXLDECA1_N2_2 XLA_3
+ VDD pch_hvt l=0.06U
+ w=3.335U
M7035 VDD XLCTRL_XXLDECA1_N2_1 XLA_5
+ VDD pch_hvt l=0.06U
+ w=3.335U
M7036 VDD XLCTRL_XXLDECA1_N2_1 XLA_5
+ VDD pch_hvt l=0.06U
+ w=3.335U
M7037 VDD XLCTRL_XXLDECA1_N2_1 XLA_5
+ VDD pch_hvt l=0.06U
+ w=3.335U
M7038 VDD XLCTRL_XXLDECA1_N2_0 XLA_7
+ VDD pch_hvt l=0.06U
+ w=3.335U
M7039 VDD XLCTRL_XXLDECA1_N2_0 XLA_7
+ VDD pch_hvt l=0.06U
+ w=3.335U
M7040 VDD XLCTRL_XXLDECA1_N2_0 XLA_7
+ VDD pch_hvt l=0.06U
+ w=3.335U
M7041 VDD A_XC_4 XLCTRL_XXLDECC1_N2_0
+ VDD pch l=0.06U
+ w=0.615U
M7042 VDD A_XC_5 XLCTRL_XXLDECC1_N2_1
+ VDD pch l=0.06U
+	 w=0.615U
M7043 VDD A_XC_5 XLCTRL_XXLDECC1_N2_1 VDD
+ pch l=0.06U
+ w=0.615U
M7044 VDD A_XC_6 XLCTRL_XXLDECC1_N2_2 VDD
+ pch l=0.06U
+ w=0.615U
M7045 VDD A_XC_6 XLCTRL_XXLDECC1_N2_2
+ VDD pch l=0.06U
+	 w=0.615U
M7046 VDD A_XC_7 XLCTRL_XXLDECC1_N2_3 VDD
+ pch l=0.06U
+	 w=0.615U
M7047 VDD A_XC_7 XLCTRL_XXLDECC1_N2_3
+ VDD pch l=0.06U
+ w=0.615U
M7048 VDD A_XA_1 XLCTRL_XXLDECA1_N2_3
+ VDD pch l=0.06U
+ w=0.615U
M7049 VDD A_XA_1 XLCTRL_XXLDECA1_N2_3 VDD
+ pch l=0.06U
+	 w=0.615U
M7050 VDD A_XA_3 XLCTRL_XXLDECA1_N2_2
+ VDD pch l=0.06U
+	 w=0.615U
M7051 VDD A_XA_3 XLCTRL_XXLDECA1_N2_2 VDD
+ pch l=0.06U
+ w=0.615U
M7052 VDD A_XA_5 XLCTRL_XXLDECA1_N2_1 VDD
+ pch l=0.06U
+ w=0.615U
M7053 VDD A_XA_5 XLCTRL_XXLDECA1_N2_1
+ VDD pch l=0.06U
+	 w=0.615U
M7054 VDD A_XA_7 XLCTRL_XXLDECA1_N2_0
+ VDD pch l=0.06U
+	 w=0.615U
M7055 VDD A_XA_7 XLCTRL_XXLDECA1_N2_0 VDD
+ pch l=0.06U
+	 w=0.615U
M7056 VDD ZZ XLCTRL_XXLDECC1_N2_1 VDD
+ pch l=0.06U
+ w=0.41U
M7057 VDD ZZ XLCTRL_XXLDECC1_N2_2 VDD
+ pch l=0.06U
+ w=0.41U
M7058 VDD ZZ XLCTRL_XXLDECC1_N2_3 VDD
+ pch l=0.06U
+ w=0.41U
M7059 VDD ZZ XLCTRL_XXLDECA1_N2_3 VDD
+ pch l=0.06U
+ w=0.41U
M7060 VDD ZZ XLCTRL_XXLDECA1_N2_2 VDD
+ pch l=0.06U
+ w=0.41U
M7061 VDD ZZ XLCTRL_XXLDECA1_N2_1 VDD
+ pch l=0.06U
+ w=0.41U
M7062 VDD ZZ XLCTRL_XXLDECA1_N2_0 VDD
+ pch l=0.06U
+ w=0.41U
M7063 VDD XLCTRL_XRWDEC_RDLC
+ XLCTRL_XRWDEC_Z2 VDD pch l=0.06U
+ w=1.4U
M7064 VDD XLCTRL_XRWDEC_RDLC
+ XLCTRL_XRWDEC_Z2 VDD pch l=0.06U
+ w=1.4U
M7065 VDD ZZ XLCTRL_XRWDEC_RDLC VDD
+ pch l=0.06U
+	 w=0.41U
M7066 VDD A_RD XLCTRL_XRWDEC_RDLC VDD
+ pch l=0.06U
+ w=0.82U
M7067 VDD XLCTRL_XRWDEC_Z2 RDL VDD
+ pch_hvt l=0.06U
+ w=3.335U
M7068 VDD XLCTRL_XRWDEC_Z2 RDL
+ VDD pch_hvt l=0.06U
+ w=3.335U
M7069 VDD XLCTRL_XRWDEC_Z2 RDL
+ VDD pch_hvt l=0.06U
+ w=3.335U
M7070 VDD XLCTRL_XXLDECC1_N2_0 XLC_4
+ VDD pch_hvt l=0.06U
+ w=3.335U
M7071 VDD A_XC_4 XLCTRL_XXLDECC1_N2_0 VDD
+ pch l=0.06U
+ w=0.615U
M7072 VDD ZZ XLCTRL_XXLDECC1_N2_0 VDD
+ pch l=0.06U
+	 w=0.41U
M7073 VDD ZZ XLCTRL_XYLDEC0_N2_2 VDD
+ pch l=0.06U
+ w=0.41U
M7074 VDD ZZ XLCTRL_XYLDEC0_N2_1 VDD
+ pch l=0.06U
+ w=0.41U
M7075 VDD ZZ XLCTRL_XYLDEC0_N2_0 VDD
+ pch l=0.06U
+ w=0.41U
M7076 VDD ZZ XLCTRL_XXLDECB_N2_3 VDD
+ pch l=0.06U
+ w=0.41U
M7077 VDD ZZ XLCTRL_XXLDECB_N2_2 VDD
+ pch l=0.06U
+ w=0.41U
M7078 VDD ZZ XLCTRL_XXLDECB_N2_1 VDD
+ pch l=0.06U
+ w=0.41U
M7079 VDD ZZ XLCTRL_XXLDECB_N2_0 VDD
+ pch l=0.06U
+ w=0.41U
M7080 VDD A_Y_3 XLCTRL_XYLDEC0_N2_3 VDD
+ pch l=0.06U
+	 w=0.615U
M7081 VDD A_Y_2 XLCTRL_XYLDEC0_N2_2 VDD
+ pch l=0.06U
+	 w=0.615U
M7082 VDD A_Y_2 XLCTRL_XYLDEC0_N2_2 VDD
+ pch l=0.06U
+ w=0.615U
M7083 VDD A_Y_1 XLCTRL_XYLDEC0_N2_1 VDD
+ pch l=0.06U
+ w=0.615U
M7084 VDD A_Y_1 XLCTRL_XYLDEC0_N2_1 VDD
+ pch l=0.06U
+	 w=0.615U
M7085 VDD A_Y_0 XLCTRL_XYLDEC0_N2_0 VDD
+ pch l=0.06U
+	 w=0.615U
M7086 VDD A_Y_0 XLCTRL_XYLDEC0_N2_0 VDD
+ pch l=0.06U
+ w=0.615U
M7087 VDD A_XB_3 XLCTRL_XXLDECB_N2_3 VDD
+ pch l=0.06U
+ w=0.615U
M7088 VDD A_XB_3 XLCTRL_XXLDECB_N2_3 VDD
+ pch l=0.06U
+	 w=0.615U
M7089 VDD A_XB_2 XLCTRL_XXLDECB_N2_2 VDD
+ pch l=0.06U
+	 w=0.615U
M7090 VDD A_XB_2 XLCTRL_XXLDECB_N2_2 VDD
+ pch l=0.06U
+ w=0.615U
M7091 VDD A_XB_1 XLCTRL_XXLDECB_N2_1 VDD
+ pch l=0.06U
+ w=0.615U
M7092 VDD A_XB_1 XLCTRL_XXLDECB_N2_1 VDD
+ pch l=0.06U
+	 w=0.615U
M7093 VDD A_XB_0 XLCTRL_XXLDECB_N2_0 VDD
+ pch l=0.06U
+	 w=0.615U
M7094 VDD A_XB_0 XLCTRL_XXLDECB_N2_0 VDD
+ pch l=0.06U
+	 w=0.615U
M7095 VDD XLCTRL_XSMPD_Z3 SOE VDD pch
+ l=0.06U
+	 w=3.33U
M7096 VDD XLCTRL_XSMPD_Z3 SOE VDD
+ pch l=0.06U
+ w=3.335U
M7097 VDD XLCTRL_XSMPD_Z3 SOE VDD
+ pch l=0.06U
+ w=3.335U
M7098 VDD XLCTRL_XSMPD_Z2 XLCTRL_XSMPD_Z3 VDD
+ pch l=0.06U
+ w=0.74U
M7099 VDD XLCTRL_XSMPD_Z2
+ XLCTRL_XSMPD_Z3 VDD pch l=0.06U
+ w=0.74U
M7100 VDD XLCTRL_XSMPD_Z2
+ XLCTRL_XSMPD_Z3 VDD pch l=0.06U
+ w=0.74U
M7101 VDD XLCTRL_XSMPD_Z2
+ XLCTRL_XSMPD_Z3 VDD pch l=0.06U
+ w=0.74U
M7102 VDD ZZ XLCTRL_XYLDEC0_N2_3 VDD
+ pch l=0.06U
+ w=0.41U
M7103 VDD A_Y_3 XLCTRL_XYLDEC0_N2_3 VDD
+ pch l=0.06U
+ w=0.615U
M7104 VDD XLCTRL_XYLDEC0_N2_3 YSEL_3
+ VDD pch_hvt l=0.06U
+ w=3.335U
M7105 VDD XLCTRL_XYLDEC0_N2_3 YSEL_3
+ VDD pch_hvt l=0.06U
+ w=3.335U
M7106 VDD XLCTRL_XYLDEC0_N2_3 YSEL_3
+ VDD pch_hvt l=0.06U
+ w=3.335U
M7107 VDD XLCTRL_XYLDEC0_N2_2 YSEL_2
+ VDD pch_hvt l=0.06U
+ w=3.335U
M7108 VDD XLCTRL_XYLDEC0_N2_2 YSEL_2
+ VDD pch_hvt l=0.06U
+ w=3.335U
M7109 VDD XLCTRL_XYLDEC0_N2_2 YSEL_2
+ VDD pch_hvt l=0.06U
+ w=3.335U
M7110 VDD XLCTRL_XYLDEC0_N2_1 YSEL_1
+ VDD pch_hvt l=0.06U
+ w=3.335U
M7111 VDD XLCTRL_XYLDEC0_N2_1 YSEL_1
+ VDD pch_hvt l=0.06U
+ w=3.335U
M7112 VDD XLCTRL_XYLDEC0_N2_1 YSEL_1
+ VDD pch_hvt l=0.06U
+ w=3.335U
M7113 VDD XLCTRL_XYLDEC0_N2_0 YSEL_0
+ VDD pch_hvt l=0.06U
+ w=3.335U
M7114 VDD XLCTRL_XYLDEC0_N2_0 YSEL_0
+ VDD pch_hvt l=0.06U
+ w=3.335U
M7115 VDD XLCTRL_XYLDEC0_N2_0 YSEL_0
+ VDD pch_hvt l=0.06U
+ w=3.335U
M7116 VDD XLCTRL_XXLDECB_N2_3 XLB_3
+ VDD pch_hvt l=0.06U
+ w=3.335U
M7117 VDD XLCTRL_XXLDECB_N2_3 XLB_3
+ VDD pch_hvt l=0.06U
+ w=3.335U
M7118 VDD XLCTRL_XXLDECB_N2_3 XLB_3
+ VDD pch_hvt l=0.06U
+ w=3.335U
M7119 VDD XLCTRL_XXLDECB_N2_2 XLB_2
+ VDD pch_hvt l=0.06U
+ w=3.335U
M7120 VDD XLCTRL_XXLDECB_N2_2 XLB_2
+ VDD pch_hvt l=0.06U
+ w=3.335U
M7121 VDD XLCTRL_XXLDECB_N2_2 XLB_2
+ VDD pch_hvt l=0.06U
+ w=3.335U
M7122 VDD XLCTRL_XXLDECB_N2_1 XLB_1
+ VDD pch_hvt l=0.06U
+ w=3.335U
M7123 VDD XLCTRL_XXLDECB_N2_1 XLB_1
+ VDD pch_hvt l=0.06U
+ w=3.335U
M7124 VDD XLCTRL_XXLDECB_N2_1 XLB_1
+ VDD pch_hvt l=0.06U
+ w=3.335U
M7125 VDD XLCTRL_XXLDECB_N2_0 XLB_0
+ VDD pch_hvt l=0.06U
+ w=3.335U
M7126 VDD XLCTRL_XXLDECB_N2_0 XLB_0
+ VDD pch_hvt l=0.06U
+ w=3.335U
M7127 VDD XLCTRL_XXLDECB_N2_0 XLB_0
+ VDD pch_hvt l=0.06U
+ w=3.335U
M7128 YSEL_1 XLCTRL_XYLDEC0_N2_1 VSS
+ VSS nch_hvt l=0.06U
+ w=1.11U
M7129 YSEL_1 XLCTRL_XYLDEC0_N2_1 VSS
+ VSS nch_hvt l=0.06U
+	 w=1.11U
M7130 YSEL_1 XLCTRL_XYLDEC0_N2_1 VSS
+ VSS nch_hvt l=0.06U
+ w=1.11U
M7131 YSEL_2 XLCTRL_XYLDEC0_N2_2 VSS
+ VSS nch_hvt l=0.06U
+ w=1.11U
M7132 YSEL_2 XLCTRL_XYLDEC0_N2_2 VSS
+ VSS nch_hvt l=0.06U
+	 w=1.11U
M7133 YSEL_2 XLCTRL_XYLDEC0_N2_2 VSS
+ VSS nch_hvt l=0.06U
+ w=1.11U
M7134 XLB_1 XLCTRL_XXLDECB_N2_1 VSS
+ VSS nch_hvt l=0.06U
+ w=1.11U
M7135 XLB_1 XLCTRL_XXLDECB_N2_1 VSS
+ VSS nch_hvt l=0.06U
+	 w=1.11U
M7136 XLB_1 XLCTRL_XXLDECB_N2_1 VSS
+ VSS nch_hvt l=0.06U
+ w=1.11U
M7137 XLB_2 XLCTRL_XXLDECB_N2_2 VSS
+ VSS nch_hvt l=0.06U
+ w=1.11U
M7138 XLB_2 XLCTRL_XXLDECB_N2_2 VSS
+ VSS nch_hvt l=0.06U
+	 w=1.11U
M7139 XLB_2 XLCTRL_XXLDECB_N2_2 VSS
+ VSS nch_hvt l=0.06U
+ w=1.11U
M7140 YSEL_6 XLCTRL_XYLDEC1_N2_2 VSS
+ VSS nch_hvt l=0.06U
+ w=1.11U
M7141 YSEL_6 XLCTRL_XYLDEC1_N2_2 VSS
+ VSS nch_hvt l=0.06U
+	 w=1.11U
M7142 YSEL_6 XLCTRL_XYLDEC1_N2_2 VSS
+ VSS nch_hvt l=0.06U
+ w=1.11U
M7143 YSEL_5 XLCTRL_XYLDEC1_N2_1 VSS
+ VSS nch_hvt l=0.06U
+ w=1.11U
M7144 YSEL_5 XLCTRL_XYLDEC1_N2_1 VSS
+ VSS nch_hvt l=0.06U
+	 w=1.11U
M7145 YSEL_5 XLCTRL_XYLDEC1_N2_1 VSS
+ VSS nch_hvt l=0.06U
+ w=1.11U
M7146 VDD XLCTRL_XSMPD_Z21_3 SMPRS_3 VDD
+ pch_hvt l=0.06U
+	 w=2.5U
M7147 VDD XLCTRL_XSMPD_Z21_3
+ SMPRS_3 VDD pch_hvt l=0.06U
+ w=2.5U
M7148 VDD XLCTRL_XSMPD_Z21_3
+ SMPRS_3 VDD pch_hvt l=0.06U
+ w=2.5U
M7149 VDD XLCTRL_XSMPD_Z21_3
+ SMPRS_3 VDD pch_hvt l=0.06U
+ w=2.5U
M7150 VDD XLCTRL_XSMPD_Z21_2
+ SMPRS_2 VDD pch_hvt l=0.06U
+ w=2.5U
M7151 VDD XLCTRL_XSMPD_Z21_2
+ SMPRS_2 VDD pch_hvt l=0.06U
+ w=2.5U
M7152 VDD XLCTRL_XSMPD_Z21_2
+ SMPRS_2 VDD pch_hvt l=0.06U
+ w=2.5U
M7153 VDD XLCTRL_XSMPD_Z21_2 SMPRS_2 VDD
+ pch_hvt l=0.06U
+ w=2.5U
M7154 VDD XLCTRL_XSMPD_Z21_1 SMPRS_1 VDD
+ pch_hvt l=0.06U
+ w=2.5U
M7155 VDD XLCTRL_XSMPD_Z21_1
+ SMPRS_1 VDD pch_hvt l=0.06U
+ w=2.5U
M7156 VDD XLCTRL_XSMPD_Z21_1
+ SMPRS_1 VDD pch_hvt l=0.06U
+ w=2.5U
M7157 VDD XLCTRL_XSMPD_Z21_1
+ SMPRS_1 VDD pch_hvt l=0.06U
+ w=2.5U
M7158 VDD XLCTRL_XSMPD_Z21_0
+ SMPRS_0 VDD pch_hvt l=0.06U
+ w=2.5U
M7159 VDD XLCTRL_XSMPD_Z21_0
+ SMPRS_0 VDD pch_hvt l=0.06U
+ w=2.5U
M7160 VDD XLCTRL_XSMPD_Z21_0
+ SMPRS_0 VDD pch_hvt l=0.06U
+ w=2.5U
M7161 VDD XLCTRL_XSMPD_Z21_0 SMPRS_0 VDD
+ pch_hvt l=0.06U
+	 w=2.5U
M7162 VDD XLCTRL_XYLDEC1_N2_0 YSEL_4
+ VDD pch_hvt l=0.06U
+ w=3.335U
M7163 VDD XLCTRL_XYLDEC1_N2_0 YSEL_4
+ VDD pch_hvt l=0.06U
+ w=3.335U
M7164 VDD XLCTRL_XYLDEC1_N2_0 YSEL_4
+ VDD pch_hvt l=0.06U
+ w=3.335U
M7165 VDD XLCTRL_XYLDEC1_N2_1 YSEL_5
+ VDD pch_hvt l=0.06U
+ w=3.335U
M7166 VDD XLCTRL_XYLDEC1_N2_1 YSEL_5
+ VDD pch_hvt l=0.06U
+ w=3.335U
M7167 VDD XLCTRL_XYLDEC1_N2_1 YSEL_5
+ VDD pch_hvt l=0.06U
+ w=3.335U
M7168 VDD XLCTRL_XYLDEC1_N2_2 YSEL_6
+ VDD pch_hvt l=0.06U
+ w=3.335U
M7169 VDD XLCTRL_XYLDEC1_N2_2 YSEL_6
+ VDD pch_hvt l=0.06U
+ w=3.335U
M7170 VDD XLCTRL_XYLDEC1_N2_2 YSEL_6
+ VDD pch_hvt l=0.06U
+ w=3.335U
M7171 VDD XLCTRL_XYLDEC1_N2_3 YSEL_7
+ VDD pch_hvt l=0.06U
+ w=3.335U
M7172 VDD XLCTRL_XYLDEC1_N2_3 YSEL_7
+ VDD pch_hvt l=0.06U
+ w=3.335U
M7173 VDD XLCTRL_XYLDEC1_N2_3 YSEL_7
+ VDD pch_hvt l=0.06U
+ w=3.335U
M7174 VDD XLCTRL_XSMPD_Z20_3
+ XLCTRL_XSMPD_Z21_3 VDD pch l=0.06U
+ w=0.935U
M7175 VDD XLCTRL_XSMPD_Z20_3
+ XLCTRL_XSMPD_Z21_3 VDD pch l=0.06U
+ w=0.935U
M7176 VDD XLCTRL_XSMPD_Z20_3
+ XLCTRL_XSMPD_Z21_3 VDD pch l=0.06U
+ w=0.935U
M7177 VDD XLCTRL_XSMPD_Z22_3
+ XLCTRL_XSMPD_Z21_3 VDD pch l=0.06U
+ w=0.82U
M7178 VDD XLCTRL_XSMPD_Z22_2
+ XLCTRL_XSMPD_Z21_2 VDD pch l=0.06U
+ w=0.82U
M7179 VDD XLCTRL_XSMPD_Z20_2
+ XLCTRL_XSMPD_Z21_2 VDD pch l=0.06U
+ w=0.935U
M7180 VDD XLCTRL_XSMPD_Z20_2
+ XLCTRL_XSMPD_Z21_2 VDD pch l=0.06U
+ w=0.935U
M7181 VDD XLCTRL_XSMPD_Z20_2
+ XLCTRL_XSMPD_Z21_2 VDD pch l=0.06U
+ w=0.935U
M7182 VDD XLCTRL_XSMPD_Z20_1
+ XLCTRL_XSMPD_Z21_1 VDD pch l=0.06U
+ w=0.935U
M7183 VDD XLCTRL_XSMPD_Z20_1
+ XLCTRL_XSMPD_Z21_1 VDD pch l=0.06U
+ w=0.935U
M7184 VDD XLCTRL_XSMPD_Z20_1
+ XLCTRL_XSMPD_Z21_1 VDD pch l=0.06U
+ w=0.935U
M7185 VDD XLCTRL_XSMPD_Z22_1
+ XLCTRL_XSMPD_Z21_1 VDD pch l=0.06U
+ w=0.82U
M7186 VDD XLCTRL_XSMPD_Z22_0
+ XLCTRL_XSMPD_Z21_0 VDD pch l=0.06U
+ w=0.82U
M7187 VDD XLCTRL_XSMPD_Z20_0
+ XLCTRL_XSMPD_Z21_0 VDD pch l=0.06U
+ w=0.935U
M7188 VDD XLCTRL_XSMPD_Z20_0
+ XLCTRL_XSMPD_Z21_0 VDD pch l=0.06U
+ w=0.935U
M7189 VDD XLCTRL_XSMPD_Z20_0
+ XLCTRL_XSMPD_Z21_0 VDD pch l=0.06U
+ w=0.935U
M7190 VDD A_Y_4 XLCTRL_XYLDEC1_N2_0 VDD
+ pch l=0.06U
+	 w=0.615U
M7191 VDD A_Y_4 XLCTRL_XYLDEC1_N2_0 VDD
+ pch l=0.06U
+	 w=0.615U
M7192 VDD A_Y_5 XLCTRL_XYLDEC1_N2_1 VDD
+ pch l=0.06U
+	 w=0.615U
M7193 VDD A_Y_5 XLCTRL_XYLDEC1_N2_1 VDD
+ pch l=0.06U
+ w=0.615U
M7194 VDD A_Y_6 XLCTRL_XYLDEC1_N2_2 VDD
+ pch l=0.06U
+ w=0.615U
M7195 VDD A_Y_6 XLCTRL_XYLDEC1_N2_2 VDD
+ pch l=0.06U
+	 w=0.615U
M7196 VDD A_Y_7 XLCTRL_XYLDEC1_N2_3 VDD
+ pch l=0.06U
+	 w=0.615U
M7197 VDD A_Y_7 XLCTRL_XYLDEC1_N2_3 VDD
+ pch l=0.06U
+	 w=0.615U
M7198 XLCTRL_XSMPD_XND20_3_NET9
+ XLCTRL_XSMPD_Z22_3 VSS VSS nch
+ l=0.06U
+ w=1U
M7199 XLCTRL_XSMPD_Z21_3
+	XLCTRL_XSMPD_Z20_3 XLCTRL_XSMPD_XND20_3_NET9 VSS
+ nch l=0.06U
+ w=1U
M7200 XLCTRL_XSMPD_Z21_3
+	XLCTRL_XSMPD_Z20_3 XLCTRL_XSMPD_XND20_3_NET9 VSS
+ nch l=0.06U
+ w=1U
M7201 VSS XLCTRL_XSMPD_Z22_3
+ XLCTRL_XSMPD_XND20_3_NET9 VSS nch
+ l=0.06U
+ w=1U
M7202 XLCTRL_XSMPD_XND20_2_NET9
+ XLCTRL_XSMPD_Z22_2 VSS VSS nch
+ l=0.06U
+ w=1U
M7203 XLCTRL_XSMPD_Z21_2
+	XLCTRL_XSMPD_Z20_2 XLCTRL_XSMPD_XND20_2_NET9 VSS
+ nch l=0.06U
+ w=1U
M7204 XLCTRL_XSMPD_XND20_2_NET9
+ XLCTRL_XSMPD_Z22_2 VSS VSS nch
+ l=0.06U
+ w=1U
M7205 VSS XLCTRL_XSMPD_Z22_1
+ XLCTRL_XSMPD_XND20_1_NET9 VSS nch
+ l=0.06U
+ w=1U
M7206 XLCTRL_XSMPD_Z21_1
+	XLCTRL_XSMPD_Z20_1 XLCTRL_XSMPD_XND20_1_NET9 VSS
+ nch l=0.06U
+ w=1U
M7207 XLCTRL_XSMPD_XND20_1_NET9
+ XLCTRL_XSMPD_Z22_1 VSS VSS nch
+ l=0.06U
+ w=1U
M7208 XLCTRL_XSMPD_XND20_0_NET9
+ XLCTRL_XSMPD_Z22_0 VSS VSS nch
+ l=0.06U
+ w=1U
M7209 XLCTRL_XSMPD_Z21_0
+	XLCTRL_XSMPD_Z20_0 XLCTRL_XSMPD_XND20_0_NET9 VSS
+ nch l=0.06U
+ w=1U
M7210 XLCTRL_XSMPD_Z21_0
+	XLCTRL_XSMPD_Z20_0 XLCTRL_XSMPD_XND20_0_NET9 VSS
+ nch l=0.06U
+ w=1U
M7211 XLCTRL_XSMPD_XND20_0_NET9
+ XLCTRL_XSMPD_Z22_0 VSS VSS nch
+ l=0.06U
+ w=1U
M7212 VDD ZZ XLCTRL_XYLDEC1_N2_0 VDD
+ pch l=0.06U
+ w=0.41U
M7213 VDD ZZ XLCTRL_XYLDEC1_N2_1 VDD
+ pch l=0.06U
+ w=0.41U
M7214 VDD ZZ XLCTRL_XYLDEC1_N2_2 VDD
+ pch l=0.06U
+ w=0.41U
M7215 VDD ZZ XLCTRL_XYLDEC1_N2_3 VDD
+ pch l=0.06U
+ w=0.41U
M7216 XLCTRL_XSMPD_XND20_2_NET9
+	XLCTRL_XSMPD_Z20_2 XLCTRL_XSMPD_Z21_2 VSS nch
+ l=0.06U
+ w=1U
M7217 XLCTRL_XSMPD_Z21_1
+	XLCTRL_XSMPD_Z20_1 XLCTRL_XSMPD_XND20_1_NET9 VSS
+ nch l=0.06U
+ w=1U
M7218 XLCTRL_XSMPD_XND21_3_NET9
+ XLCTRL_XSMPD_Z21_3 VSS VSS nch
+ l=0.06U
+ w=0.62U
M7219 XLCTRL_XSMPD_Z22_3
+	XLCTRL_XSMPD_Z16 XLCTRL_XSMPD_XND21_3_NET9 VSS
+ nch l=0.06U
+ w=0.62U
M7220 XLCTRL_XSMPD_XND21_2_NET9
+	XLCTRL_XSMPD_Z16 XLCTRL_XSMPD_Z22_2 VSS nch
+ l=0.06U
+ w=0.62U
M7221 XLCTRL_XSMPD_XND21_2_NET9
+ XLCTRL_XSMPD_Z21_2 VSS VSS nch
+ l=0.06U
+ w=0.62U
M7222 VSS XLCTRL_XSMPD_Z21_1
+ XLCTRL_XSMPD_XND21_1_NET9 VSS nch
+ l=0.06U
+ w=0.62U
M7223 XLCTRL_XSMPD_Z22_1
+	XLCTRL_XSMPD_Z16 XLCTRL_XSMPD_XND21_1_NET9 VSS
+ nch l=0.06U
+ w=0.62U
M7224 XLCTRL_XSMPD_Z22_0
+	XLCTRL_XSMPD_Z16 XLCTRL_XSMPD_XND21_0_NET9 VSS
+ nch l=0.06U
+ w=0.62U
M7225 XLCTRL_XSMPD_XND21_0_NET9
+ XLCTRL_XSMPD_Z21_0 VSS VSS nch
+ l=0.06U
+ w=0.62U
M7226 VDD XLCTRL_XSMPD_Z21_3
+ XLCTRL_XSMPD_Z22_3 VDD pch l=0.06U
+ w=0.62U
M7227 VDD XLCTRL_XSMPD_Z16
+ XLCTRL_XSMPD_Z22_3 VDD pch l=0.06U
+ w=0.62U
M7228 VDD XLCTRL_XSMPD_Z16
+ XLCTRL_XSMPD_Z22_2 VDD pch l=0.06U
+ w=0.62U
M7229 VDD XLCTRL_XSMPD_Z21_2
+ XLCTRL_XSMPD_Z22_2 VDD pch l=0.06U
+ w=0.62U
M7230 VDD XLCTRL_XSMPD_Z21_1
+ XLCTRL_XSMPD_Z22_1 VDD pch l=0.06U
+ w=0.62U
M7231 VDD XLCTRL_XSMPD_Z16
+ XLCTRL_XSMPD_Z22_1 VDD pch l=0.06U
+ w=0.62U
M7232 VDD XLCTRL_XSMPD_Z16
+ XLCTRL_XSMPD_Z22_0 VDD pch l=0.06U
+ w=0.62U
M7233 VDD XLCTRL_XSMPD_Z21_0
+ XLCTRL_XSMPD_Z22_0 VDD pch l=0.06U
+ w=0.62U
M7234 VDD ZZ XLCTRL_XSMPD_Z20_3 VDD
+ pch l=0.06U
+	 w=0.41U
M7235 VDD A_RD XLCTRL_XSMPD_Z20_3 VDD
+ pch l=0.06U
+ w=0.41U
M7236 VDD A_GCDEC_3 XLCTRL_XSMPD_Z20_3
+ VDD pch l=0.06U
+	 w=0.41U
M7237 VDD A_GCDEC_2 XLCTRL_XSMPD_Z20_2
+ VDD pch l=0.06U
+	 w=0.41U
M7238 VDD A_RD XLCTRL_XSMPD_Z20_2 VDD
+ pch l=0.06U
+ w=0.41U
M7239 VDD ZZ XLCTRL_XSMPD_Z20_2 VDD
+ pch l=0.06U
+ w=0.41U
M7240 VDD ZZ XLCTRL_XSMPD_Z20_1 VDD
+ pch l=0.06U
+ w=0.41U
M7241 VDD A_RD XLCTRL_XSMPD_Z20_1 VDD
+ pch l=0.06U
+ w=0.41U
M7242 VDD A_GCDEC_1 XLCTRL_XSMPD_Z20_1
+ VDD pch l=0.06U
+	 w=0.41U
M7243 VDD A_GCDEC_0 XLCTRL_XSMPD_Z20_0
+ VDD pch l=0.06U
+	 w=0.41U
M7244 VDD A_RD XLCTRL_XSMPD_Z20_0 VDD
+ pch l=0.06U
+ w=0.41U
M7245 VDD XLCTRL_XSMPD_Z15
+ XLCTRL_XSMPD_Z14B VDD pch l=0.06U
+ w=0.41U
M7246 VDD XLCTRL_XSMPD_Z14B
+ XLCTRL_XSMPD_Z15B VDD pch l=0.1U
+ w=0.41U
M7247 VDD XLCTRL_XSMPD_Z13
+ XLCTRL_XSMPD_Z14 VDD pch l=0.06U
+ w=0.41U
M7248 VDD XLCTRL_XSMPD_Z14
+ XLCTRL_XSMPD_Z15 VDD pch l=0.1U
+ w=0.41U
M7249 VDD A_VS_1 XLCTRL_XSMPD_Z5 VDD pch
+ l=0.06U
+ w=0.41U
M7250 VDD XLCTRL_XSMPD_Z4 XLCTRL_XSMPD_Z5 VDD
+ pch l=0.08U
+ w=0.41U
M7251 VDD XLCTRL_XSMPD_Z1 XLCTRL_XSMPD_Z4 VDD
+ pch l=0.06U
+ w=0.41U
M7252 VDD XLCTRL_XSMPD_Z5 XLCTRL_XSMPD_Z6 VDD
+ pch l=0.06U
+ w=0.41U
M7253 VDD XLCTRL_XSMPD_Z15B
+ XLCTRL_XSMPD_Z16 VDD pch l=0.06U
+ w=0.62U
M7254 VDD XLCTRL_XSMPD_Z6 XLCTRL_XSMPD_Z7 VDD
+ pch l=0.08U
+ w=0.41U
M7255 VDD XLCTRL_XSMPD_Z1 XLCTRL_XSMPD_Z10
+ VDD pch l=0.06U
+ w=0.41U
M7256 VDD A_VS_0 XLCTRL_XSMPD_Z9 VDD pch
+ l=0.06U
+ w=0.41U
M7257 VDD XLCTRL_XSMPD_Z7 XLCTRL_XSMPD_Z8 VDD
+ pch l=0.06U
+ w=0.41U
M7258 VDD XLCTRL_XSMPD_Z1 XLCTRL_XSMPD_Z8 VDD
+ pch l=0.06U
+ w=0.41U
M7259 VDD XLCTRL_XSMPD_Z8 XLCTRL_XSMPD_Z9 VDD
+ pch l=0.08U
+ w=0.41U
M7260 VDD XLCTRL_XSMPD_Z12
+ XLCTRL_XSMPD_Z13 VDD pch l=0.1U
+ w=0.41U
M7261 VDD XLCTRL_XSMPD_Z11
+ XLCTRL_XSMPD_Z12 VDD pch l=0.06U
+ w=0.41U
M7262 VDD XLCTRL_XSMPD_Z9 XLCTRL_XSMPD_Z10
+ VDD pch l=0.06U
+ w=0.41U
M7263 VDD XLCTRL_XSMPD_Z10
+ XLCTRL_XSMPD_Z11 VDD pch l=0.12U
+ w=0.41U
M7264 VDD XLCTRL_XSMPD_Z7 XLCTRL_XSMPD_Z10
+ VDD pch l=0.06U
+ w=0.41U
M7265 VDD ZZ XLCTRL_XSMPD_Z1 VDD pch
+ l=0.06U
+ w=0.82U
M7266 VDD A_RD XLCTRL_XSMPD_Z1 VDD pch
+ l=0.06U
+ w=0.82U
M7267 VDD ZZ XLCTRL_XSMPD_Z20_0 VDD
+ pch l=0.06U
+ w=0.41U
M7268 VDD XLCTRL_XSMPD_Z16
+ XLCTRL_XSMPD_Z2 VDD pch l=0.06U
+ w=0.62U
M7269 VDD XLCTRL_XSMPD_Z1 XLCTRL_XSMPD_Z2 VDD
+ pch l=0.06U
+ w=0.62U
M7270 XLA_0 XLCTRL_XXLDECA0_N2_3 VSS
+ VSS nch_hvt l=0.06U
+ w=1.11U
M7271 XLA_0 XLCTRL_XXLDECA0_N2_3 VSS
+ VSS nch_hvt l=0.06U
+ w=1.11U
M7272 XLA_0 XLCTRL_XXLDECA0_N2_3 VSS
+ VSS nch_hvt l=0.06U
+ w=1.11U
M7273 XLA_7 XLCTRL_XXLDECA1_N2_0 VSS
+ VSS nch_hvt l=0.06U
+ w=1.11U
M7274 XLA_7 XLCTRL_XXLDECA1_N2_0 VSS
+ VSS nch_hvt l=0.06U
+ w=1.11U
M7275 XLA_7 XLCTRL_XXLDECA1_N2_0 VSS
+ VSS nch_hvt l=0.06U
+ w=1.11U
M7276 XLB_0 XLCTRL_XXLDECB_N2_0 VSS
+ VSS nch_hvt l=0.06U
+ w=1.11U
M7277 XLB_0 XLCTRL_XXLDECB_N2_0 VSS
+ VSS nch_hvt l=0.06U
+ w=1.11U
M7278 XLB_0 XLCTRL_XXLDECB_N2_0 VSS
+ VSS nch_hvt l=0.06U
+ w=1.11U
M7279 YSEL_7 XLCTRL_XYLDEC1_N2_3 VSS
+ VSS nch_hvt l=0.06U
+ w=1.11U
M7280 YSEL_7 XLCTRL_XYLDEC1_N2_3 VSS
+ VSS nch_hvt l=0.06U
+ w=1.11U
M7281 YSEL_7 XLCTRL_XYLDEC1_N2_3 VSS
+ VSS nch_hvt l=0.06U
+ w=1.11U
M7282 XLC_0 XLCTRL_XXLDECC0_N2_0 VSS
+ VSS nch_hvt l=0.06U
+ w=1.11U
M7283 XLC_7 XLCTRL_XXLDECC1_N2_3 VSS
+ VSS nch_hvt l=0.06U
+ w=1.11U
M7284 YSEL_0 XLCTRL_XYLDEC0_N2_0 VSS
+ VSS nch_hvt l=0.06U
+ w=1.11U
M7285 YSEL_4 XLCTRL_XYLDEC1_N2_0 VSS
+ VSS nch_hvt l=0.06U
+	 w=1.11U
M7286 YSEL_4 XLCTRL_XYLDEC1_N2_0 VSS
+ VSS nch_hvt l=0.06U
+ w=1.11U
M7287 YSEL_4 XLCTRL_XYLDEC1_N2_0 VSS
+ VSS nch_hvt l=0.06U
+ w=1.11U
M7288 XLA_6 XLCTRL_XXLDECA0_N2_0 VSS
+ VSS nch_hvt l=0.06U
+	 w=1.11U
M7289 XLA_6 XLCTRL_XXLDECA0_N2_0 VSS
+ VSS nch_hvt l=0.06U
+ w=1.11U
M7290 XLA_6 XLCTRL_XXLDECA0_N2_0 VSS
+ VSS nch_hvt l=0.06U
+ w=1.11U
M7291 XLA_1 XLCTRL_XXLDECA1_N2_3 VSS
+ VSS nch_hvt l=0.06U
+	 w=1.11U
M7292 XLA_1 XLCTRL_XXLDECA1_N2_3 VSS
+ VSS nch_hvt l=0.06U
+ w=1.11U
M7293 XLA_1 XLCTRL_XXLDECA1_N2_3 VSS
+ VSS nch_hvt l=0.06U
+ w=1.11U
M7294 XLB_3 XLCTRL_XXLDECB_N2_3 VSS
+ VSS nch_hvt l=0.06U
+	 w=1.11U
M7295 XLB_3 XLCTRL_XXLDECB_N2_3 VSS
+ VSS nch_hvt l=0.06U
+ w=1.11U
M7296 XLB_3 XLCTRL_XXLDECB_N2_3 VSS
+ VSS nch_hvt l=0.06U
+ w=1.11U
M7297 SMPRS_1 XLCTRL_XSMPD_Z21_1 VSS VSS
+ nch_hvt l=0.06U
+ w=1.25U
M7298 SMPRS_1 XLCTRL_XSMPD_Z21_1 VSS
+ VSS nch_hvt l=0.06U
+ w=1.25U
M7299 SMPRS_0 XLCTRL_XSMPD_Z21_0 VSS VSS
+ nch_hvt l=0.06U
+ w=1.25U
M7300 SMPRS_0 XLCTRL_XSMPD_Z21_0 VSS
+ VSS nch_hvt l=0.06U
+ w=1.25U
M7301 SMPRS_0 XLCTRL_XSMPD_Z21_0 VSS
+ VSS nch_hvt l=0.06U
+ w=1.25U
M7302 SMPRS_0 XLCTRL_XSMPD_Z21_0 VSS
+ VSS nch_hvt l=0.06U
+ w=1.25U
M7303 XLC_0 XLCTRL_XXLDECC0_N2_0 VSS
+ VSS nch_hvt l=0.06U
+ w=1.11U
M7304 XLC_0 XLCTRL_XXLDECC0_N2_0 VSS
+ VSS nch_hvt l=0.06U
+ w=1.11U
M7305 XLC_7 XLCTRL_XXLDECC1_N2_3 VSS
+ VSS nch_hvt l=0.06U
+ w=1.11U
M7306 XLC_7 XLCTRL_XXLDECC1_N2_3 VSS
+ VSS nch_hvt l=0.06U
+ w=1.11U
M7307 YSEL_0 XLCTRL_XYLDEC0_N2_0 VSS
+ VSS nch_hvt l=0.06U
+	 w=1.11U
M7308 YSEL_0 XLCTRL_XYLDEC0_N2_0 VSS
+ VSS nch_hvt l=0.06U
+ w=1.11U
M7309 YSEL_3 XLCTRL_XYLDEC0_N2_3 VSS
+ VSS nch_hvt l=0.06U
+	 w=1.11U
M7310 YSEL_3 XLCTRL_XYLDEC0_N2_3 VSS
+ VSS nch_hvt l=0.06U
+ w=1.11U
M7311 YSEL_3 XLCTRL_XYLDEC0_N2_3 VSS
+ VSS nch_hvt l=0.06U
+ w=1.11U
M7312 RDL XLCTRL_XRWDEC_Z2 VSS VSS
+ nch_hvt l=0.06U
+ w=1.11U
M7313 RDL XLCTRL_XRWDEC_Z2 VSS
+ VSS nch_hvt l=0.06U
+ w=1.11U
M7314 XLC_4 XLCTRL_XXLDECC1_N2_0 VSS
+ VSS nch_hvt l=0.06U
+ w=1.11U
M7315 XLC_4 XLCTRL_XXLDECC1_N2_0 VSS
+ VSS nch_hvt l=0.06U
+ w=1.11U
M7316 XLC_4 XLCTRL_XXLDECC1_N2_0 VSS
+ VSS nch_hvt l=0.06U
+ w=1.11U
M7317 WRTL XLCTRL_XRWDEC_WRTLC VSS VSS
+ nch_hvt l=0.06U
+ w=1.11U
M7318 WRTL XLCTRL_XRWDEC_WRTLC VSS
+ VSS nch_hvt l=0.06U
+ w=1.11U
M7319 XLC_3 XLCTRL_XXLDECC0_N2_3 VSS
+ VSS nch_hvt l=0.06U
+ w=1.11U
M7320 XLC_3 XLCTRL_XXLDECC0_N2_3 VSS
+ VSS nch_hvt l=0.06U
+ w=1.11U
M7321 XLC_3 XLCTRL_XXLDECC0_N2_3 VSS
+ VSS nch_hvt l=0.06U
+ w=1.11U
M7322 SMPRS_2 XLCTRL_XSMPD_Z21_2 VSS VSS
+ nch_hvt l=0.06U
+ w=1.25U
M7323 SMPRS_2 XLCTRL_XSMPD_Z21_2 VSS
+ VSS nch_hvt l=0.06U
+ w=1.25U
M7324 SMPRS_2 XLCTRL_XSMPD_Z21_2 VSS
+ VSS nch_hvt l=0.06U
+ w=1.25U
M7325 SMPRS_2 XLCTRL_XSMPD_Z21_2 VSS
+ VSS nch_hvt l=0.06U
+ w=1.25U
M7326 SMPRS_3 XLCTRL_XSMPD_Z21_3 VSS VSS
+ nch_hvt l=0.06U
+ w=1.25U
M7327 SMPRS_1 XLCTRL_XSMPD_Z21_1 VSS
+ VSS nch_hvt l=0.06U
+ w=1.25U
M7328 SMPRS_1 XLCTRL_XSMPD_Z21_1 VSS
+ VSS nch_hvt l=0.06U
+	 w=1.25U
M7329 RDL XLCTRL_XRWDEC_Z2 VSS
+ VSS nch_hvt l=0.06U
+ w=1.11U
M7330 WRTL XLCTRL_XRWDEC_WRTLC VSS
+ VSS nch_hvt l=0.06U
+ w=1.11U
M7331 SMPRS_3 XLCTRL_XSMPD_Z21_3 VSS
+ VSS nch_hvt l=0.06U
+ w=1.25U
M7332 SMPRS_3 XLCTRL_XSMPD_Z21_3 VSS
+ VSS nch_hvt l=0.06U
+ w=1.25U
M7333 SMPRS_3 XLCTRL_XSMPD_Z21_3 VSS
+ VSS nch_hvt l=0.06U
+ w=1.25U
M7334 XLCTRL_XSMPD_Z6 XLCTRL_XSMPD_Z5 VSS VSS
+ nch l=0.08U
+ w=0.21U
M7335 XLCTRL_XYLDEC1_N2_2 A_Y_6
+ XLCTRL_XYLDEC1_N3 VSS nch l=0.06U
+ w=0.81U
M7336 XLCTRL_XXLDECA1_N2_1 A_XA_5
+ XLCTRL_XXLDECA1_N3 VSS nch l=0.06U
+ w=0.81U
M7337 XLCTRL_XXLDECB_N2_1 A_XB_1
+ XLCTRL_XXLDECB_N3 VSS nch l=0.06U
+ w=0.81U
M7338 XLCTRL_XSMPD_Z10 XLCTRL_XSMPD_Z1
+ XLCTRL_XSMPD_XI55_NET17 VSS nch l=0.08U
+ w=0.41U
M7339 XLCTRL_XSMPD_XI55_NET17 XLCTRL_XSMPD_Z9
+ XLCTRL_XSMPD_XI55_NET14 VSS nch l=0.08U
+ w=0.41U
M7340 XLCTRL_XSMPD_Z11 XLCTRL_XSMPD_Z10
+ VSS VSS nch l=0.06U
+ w=0.41U
M7341 VSS XLCTRL_XSMPD_Z7
+ XLCTRL_XSMPD_XI55_NET14 VSS nch l=0.08U
+ w=0.41U
M7342 XLCTRL_XSMPD_Z13 XLCTRL_XSMPD_Z12
+ VSS VSS nch l=0.06U
+ w=0.41U
M7343 XLCTRL_XSMPD_Z12 XLCTRL_XSMPD_Z11
+ VSS VSS nch l=0.12U
+ w=0.41U
M7344 XLCTRL_XSMPD_Z9 A_VS_0 XLCTRL_XSMPD_XI30_NET9
+ VSS nch l=0.06U
+	 w=0.41U
M7345 XLCTRL_XSMPD_XI54_NET9 XLCTRL_XSMPD_Z7 VSS
+ VSS nch l=0.08U
+	 w=0.41U
M7346 XLCTRL_XSMPD_Z8 XLCTRL_XSMPD_Z1
+ XLCTRL_XSMPD_XI54_NET9 VSS nch l=0.08U
+ w=0.41U
M7347 VSS XLCTRL_XSMPD_Z8 XLCTRL_XSMPD_XI30_NET9
+ VSS nch l=0.06U
+	 w=0.41U
M7348 XLCTRL_XSMPD_Z7 XLCTRL_XSMPD_Z6 VSS VSS
+ nch l=0.06U
+	 w=0.21U
M7349 XLCTRL_XYLDEC1_N3 ZZ VSS VSS
+ nch l=0.06U
+	 w=0.6U
M7350 XLCTRL_XYLDEC1_N2_3 A_Y_7
+ XLCTRL_XYLDEC1_N3 VSS nch l=0.06U
+ w=0.81U
M7351 XLCTRL_XYLDEC1_N2_3 A_Y_7
+ XLCTRL_XYLDEC1_N3 VSS nch l=0.06U
+ w=0.81U
M7352 XLCTRL_XYLDEC1_N2_2 A_Y_6
+ XLCTRL_XYLDEC1_N3 VSS nch l=0.06U
+ w=0.81U
M7353 XLCTRL_XXLDECA1_N3 ZZ VSS VSS
+ nch l=0.06U
+	 w=0.6U
M7354 XLCTRL_XXLDECA1_N2_0 A_XA_7
+ XLCTRL_XXLDECA1_N3 VSS nch l=0.06U
+ w=0.81U
M7355 XLCTRL_XXLDECA1_N2_0 A_XA_7
+ XLCTRL_XXLDECA1_N3 VSS nch l=0.06U
+ w=0.81U
M7356 XLCTRL_XXLDECA1_N2_1 A_XA_5
+ XLCTRL_XXLDECA1_N3 VSS nch l=0.06U
+ w=0.81U
M7357 XLCTRL_XXLDECB_N3 ZZ VSS VSS
+ nch l=0.06U
+	 w=0.6U
M7358 XLCTRL_XXLDECB_N2_0 A_XB_0
+ XLCTRL_XXLDECB_N3 VSS nch l=0.06U
+ w=0.81U
M7359 XLCTRL_XXLDECB_N2_0 A_XB_0
+ XLCTRL_XXLDECB_N3 VSS nch l=0.06U
+ w=0.81U
M7360 XLCTRL_XXLDECB_N2_1 A_XB_1
+ XLCTRL_XXLDECB_N3 VSS nch l=0.06U
+ w=0.81U
M7361 XLCTRL_XXLDECA0_N2_2 A_XA_2
+ XLCTRL_XXLDECA0_N3 VSS nch l=0.06U
+ w=0.81U
M7362 XLCTRL_XXLDECA0_N3 ZZ VSS VSS
+ nch l=0.06U
+	 w=0.6U
M7363 XLCTRL_XXLDECA0_N2_3 A_XA_0
+ XLCTRL_XXLDECA0_N3 VSS nch l=0.06U
+ w=0.81U
M7364 XLCTRL_XXLDECA0_N2_3 A_XA_0
+ XLCTRL_XXLDECA0_N3 VSS nch l=0.06U
+ w=0.81U
M7365 XLCTRL_XXLDECA0_N2_2 A_XA_2
+ XLCTRL_XXLDECA0_N3 VSS nch l=0.06U
+ w=0.81U
M7366 XLCTRL_XSMPD_Z16 XLCTRL_XSMPD_Z15B
+ VSS VSS nch l=0.14U
+ w=0.41U
M7367 XLCTRL_XSMPD_Z14B XLCTRL_XSMPD_Z15
+ VSS VSS nch l=0.1U
+ w=0.41U
M7368 XLCTRL_XSMPD_Z15B XLCTRL_XSMPD_Z14B
+ VSS VSS nch l=0.06U
+ w=0.41U
M7369 XLCTRL_XSMPD_Z14 XLCTRL_XSMPD_Z13
+ VSS VSS nch l=0.1U
+ w=0.41U
M7370 XLCTRL_XSMPD_Z15 XLCTRL_XSMPD_Z14
+ VSS VSS nch l=0.06U
+ w=0.41U
M7371 XLCTRL_XSMPD_Z5 A_VS_1 XLCTRL_XSMPD_XI32_NET9
+ VSS nch l=0.06U
+	 w=0.41U
M7372 XLCTRL_XSMPD_XI32_NET9 XLCTRL_XSMPD_Z4 VSS
+ VSS nch l=0.06U
+	 w=0.41U
M7373 XLCTRL_XSMPD_Z4 XLCTRL_XSMPD_Z1 VSS VSS
+ nch l=0.08U
+ w=0.21U
M7374 VSS XLCTRL_XSMPD_Z16
+ XLCTRL_XSMPD_XND3_NET9 VSS nch l=0.06U
+ w=0.82U
M7375 XLCTRL_XSMPD_XND3_NET9 XLCTRL_XSMPD_Z1
+ XLCTRL_XSMPD_Z2 VSS nch l=0.06U
+ w=0.82U
M7376 XLCTRL_XYLDEC1_N3 ZZ VSS VSS
+ nch l=0.06U
+	 w=0.6U
M7377 XLCTRL_XYLDEC1_N2_0 A_Y_4
+ XLCTRL_XYLDEC1_N3 VSS nch l=0.06U
+ w=0.81U
M7378 XLCTRL_XYLDEC1_N2_0 A_Y_4
+ XLCTRL_XYLDEC1_N3 VSS nch l=0.06U
+ w=0.81U
M7379 XLCTRL_XYLDEC1_N3 ZZ VSS VSS
+ nch l=0.06U
+	 w=0.6U
M7380 XLCTRL_XYLDEC1_N2_1 A_Y_5
+ XLCTRL_XYLDEC1_N3 VSS nch l=0.06U
+ w=0.81U
M7381 XLCTRL_XYLDEC1_N2_1 A_Y_5
+ XLCTRL_XYLDEC1_N3 VSS nch l=0.06U
+ w=0.81U
M7382 XLCTRL_XYLDEC1_N3 ZZ VSS VSS
+ nch l=0.06U
+	 w=0.6U
M7383 XLCTRL_XXLDECA1_N3 ZZ VSS VSS
+ nch l=0.06U
+	 w=0.6U
M7384 XLCTRL_XXLDECA1_N2_3 A_XA_1
+ XLCTRL_XXLDECA1_N3 VSS nch l=0.06U
+ w=0.81U
M7385 XLCTRL_XXLDECA1_N2_3 A_XA_1
+ XLCTRL_XXLDECA1_N3 VSS nch l=0.06U
+ w=0.81U
M7386 XLCTRL_XXLDECA1_N3 ZZ VSS VSS
+ nch l=0.06U
+	 w=0.6U
M7387 XLCTRL_XXLDECA1_N2_2 A_XA_3
+ XLCTRL_XXLDECA1_N3 VSS nch l=0.06U
+ w=0.81U
M7388 XLCTRL_XXLDECA1_N2_2 A_XA_3
+ XLCTRL_XXLDECA1_N3 VSS nch l=0.06U
+ w=0.81U
M7389 XLCTRL_XXLDECA1_N3 ZZ VSS VSS
+ nch l=0.06U
+	 w=0.6U
M7390 XLCTRL_XXLDECB_N3 ZZ VSS VSS
+ nch l=0.06U
+	 w=0.6U
M7391 XLCTRL_XXLDECB_N2_3 A_XB_3
+ XLCTRL_XXLDECB_N3 VSS nch l=0.06U
+ w=0.81U
M7392 XLCTRL_XXLDECB_N2_3 A_XB_3
+ XLCTRL_XXLDECB_N3 VSS nch l=0.06U
+ w=0.81U
M7393 XLCTRL_XXLDECB_N3 ZZ VSS VSS
+ nch l=0.06U
+	 w=0.6U
M7394 XLCTRL_XXLDECB_N2_2 A_XB_2
+ XLCTRL_XXLDECB_N3 VSS nch l=0.06U
+ w=0.81U
M7395 XLCTRL_XXLDECB_N2_2 A_XB_2
+ XLCTRL_XXLDECB_N3 VSS nch l=0.06U
+ w=0.81U
M7396 XLCTRL_XXLDECB_N3 ZZ VSS VSS
+ nch l=0.06U
+	 w=0.6U
M7397 XLCTRL_XXLDECA0_N3 ZZ VSS VSS
+ nch l=0.06U
+	 w=0.6U
M7398 XLCTRL_XXLDECA0_N2_0 A_XA_6
+ XLCTRL_XXLDECA0_N3 VSS nch l=0.06U
+ w=0.81U
M7399 XLCTRL_XXLDECA0_N2_0 A_XA_6
+ XLCTRL_XXLDECA0_N3 VSS nch l=0.06U
+ w=0.81U
M7400 XLCTRL_XXLDECA0_N3 ZZ VSS VSS
+ nch l=0.06U
+	 w=0.6U
M7401 XLCTRL_XXLDECA0_N2_1 A_XA_4
+ XLCTRL_XXLDECA0_N3 VSS nch l=0.06U
+ w=0.81U
M7402 XLCTRL_XXLDECA0_N2_1 A_XA_4
+ XLCTRL_XXLDECA0_N3 VSS nch l=0.06U
+ w=0.81U
M7403 XLCTRL_XXLDECA0_N3 ZZ VSS VSS
+ nch l=0.06U
+	 w=0.6U
M7404 XLCTRL_XSMPD_XND0_NET9 ZZ VSS VSS
+ nch l=0.06U
+	 w=0.82U
M7405 XLCTRL_XSMPD_XND0_NET9 A_RD
+ XLCTRL_XSMPD_Z1 VSS nch l=0.06U
+ w=0.82U
M7406 XLCTRL_XSMPD_Z17_3 A_RD
+ XLCTRL_XSMPD_N18 VSS nch l=0.06U
+ w=0.41U
M7407 XLCTRL_XSMPD_Z17_3 ZZ VSS VSS
+ nch l=0.06U
+	 w=0.41U
M7408 XLCTRL_XSMPD_Z20_0 A_GCDEC_0
+ XLCTRL_XSMPD_N18 VSS nch l=0.06U
+ w=0.82U
M7409 XLCTRL_XXLDECC1_N3 ZZ VSS VSS
+ nch l=0.06U
+	 w=0.6U
M7410 XLCTRL_XXLDECC1_N2_3 A_XC_7
+ XLCTRL_XXLDECC1_N3 VSS nch l=0.06U
+ w=0.81U
M7411 XLCTRL_XXLDECC1_N2_3 A_XC_7
+ XLCTRL_XXLDECC1_N3 VSS nch l=0.06U
+ w=0.81U
M7412 XLCTRL_XXLDECC1_N3 ZZ VSS VSS
+ nch l=0.06U
+	 w=0.6U
M7413 XLCTRL_XXLDECC1_N2_2 A_XC_6
+ XLCTRL_XXLDECC1_N3 VSS nch l=0.06U
+ w=0.81U
M7414 XLCTRL_XXLDECC1_N2_2 A_XC_6
+ XLCTRL_XXLDECC1_N3 VSS nch l=0.06U
+ w=0.81U
M7415 XLCTRL_XYLDEC0_N3 ZZ VSS VSS
+ nch l=0.06U
+	 w=0.6U
M7416 XLCTRL_XYLDEC0_N2_0 A_Y_0
+ XLCTRL_XYLDEC0_N3 VSS nch l=0.06U
+ w=0.81U
M7417 XLCTRL_XYLDEC0_N2_0 A_Y_0
+ XLCTRL_XYLDEC0_N3 VSS nch l=0.06U
+ w=0.81U
M7418 XLCTRL_XYLDEC0_N3 ZZ VSS VSS
+ nch l=0.06U
+	 w=0.6U
M7419 XLCTRL_XYLDEC0_N2_1 A_Y_1
+ XLCTRL_XYLDEC0_N3 VSS nch l=0.06U
+ w=0.81U
M7420 XLCTRL_XYLDEC0_N2_1 A_Y_1
+ XLCTRL_XYLDEC0_N3 VSS nch l=0.06U
+ w=0.81U
M7421 XLCTRL_XXLDECC0_N3 ZZ VSS VSS
+ nch l=0.06U
+	 w=0.6U
M7422 XLCTRL_XXLDECC0_N2_0 A_XC_0
+ XLCTRL_XXLDECC0_N3 VSS nch l=0.06U
+ w=0.81U
M7423 XLCTRL_XXLDECC0_N2_0 A_XC_0
+ XLCTRL_XXLDECC0_N3 VSS nch l=0.06U
+ w=0.81U
M7424 XLCTRL_XXLDECC0_N3 ZZ VSS VSS
+ nch l=0.06U
+	 w=0.6U
M7425 XLCTRL_XXLDECC0_N2_1 A_XC_1
+ XLCTRL_XXLDECC0_N3 VSS nch l=0.06U
+ w=0.81U
M7426 XLCTRL_XXLDECC0_N2_1 A_XC_1
+ XLCTRL_XXLDECC0_N3 VSS nch l=0.06U
+ w=0.81U
M7427 XLCTRL_XSMPD_Z17_2 A_RD
+ XLCTRL_XSMPD_N18 VSS nch l=0.06U
+ w=0.41U
M7428 XLCTRL_XSMPD_Z17_2 ZZ VSS VSS
+ nch l=0.06U
+	 w=0.41U
M7429 XLCTRL_XSMPD_Z20_2 A_GCDEC_2
+ XLCTRL_XSMPD_N18 VSS nch l=0.06U
+ w=0.82U
M7430 XLCTRL_XRWDEC_Z2 XLCTRL_XRWDEC_RDLC
+ VSS VSS nch l=0.06U
+ w=0.6U
M7431 XLCTRL_XXLDECC1_N3 ZZ VSS VSS
+ nch l=0.06U
+ w=0.6U
M7432 XLCTRL_XXLDECC1_N2_0 A_XC_4
+ XLCTRL_XXLDECC1_N3 VSS nch l=0.06U
+ w=0.81U
M7433 XLCTRL_XXLDECC1_N2_0 A_XC_4
+ XLCTRL_XXLDECC1_N3 VSS nch l=0.06U
+ w=0.81U
M7434 XLCTRL_XYLDEC0_N3 ZZ VSS VSS
+ nch l=0.06U
+	 w=0.6U
M7435 XLCTRL_XYLDEC0_N2_3 A_Y_3
+ XLCTRL_XYLDEC0_N3 VSS nch l=0.06U
+ w=0.81U
M7436 XLCTRL_XYLDEC0_N2_3 A_Y_3
+ XLCTRL_XYLDEC0_N3 VSS nch l=0.06U
+ w=0.81U
M7437 XLCTRL_XSMPD_N18 A_RD
+ XLCTRL_XSMPD_Z17_1 VSS nch l=0.06U
+ w=0.41U
M7438 VSS ZZ XLCTRL_XSMPD_Z17_1 VSS
+ nch l=0.06U
+	 w=0.41U
M7439 XLCTRL_XSMPD_Z20_1 A_GCDEC_1
+ XLCTRL_XSMPD_N18 VSS nch l=0.06U
+ w=0.82U
M7440 XLCTRL_XXLDECC1_N3 ZZ VSS VSS
+ nch l=0.06U
+	 w=0.6U
M7441 XLCTRL_XXLDECC1_N2_1 A_XC_5
+ XLCTRL_XXLDECC1_N3 VSS nch l=0.06U
+ w=0.81U
M7442 XLCTRL_XXLDECC1_N2_1 A_XC_5
+ XLCTRL_XXLDECC1_N3 VSS nch l=0.06U
+ w=0.81U
M7443 XLCTRL_XYLDEC0_N3 ZZ VSS VSS
+ nch l=0.06U
+	 w=0.6U
M7444 XLCTRL_XYLDEC0_N2_2 A_Y_2
+ XLCTRL_XYLDEC0_N3 VSS nch l=0.06U
+ w=0.81U
M7445 XLCTRL_XYLDEC0_N2_2 A_Y_2
+ XLCTRL_XYLDEC0_N3 VSS nch l=0.06U
+ w=0.81U
M7446 VSS ZZ XLCTRL_XRWDEC_Z1 VSS
+ nch l=0.06U
+ w=0.6U
M7447 XLCTRL_XXLDECC0_N3 ZZ VSS VSS
+ nch l=0.06U
+	 w=0.6U
M7448 XLCTRL_XXLDECC0_N2_3 A_XC_3
+ XLCTRL_XXLDECC0_N3 VSS nch l=0.06U
+ w=0.81U
M7449 XLCTRL_XXLDECC0_N2_3 A_XC_3
+ XLCTRL_XXLDECC0_N3 VSS nch l=0.06U
+ w=0.81U
M7450 XLCTRL_XXLDECC0_N3 ZZ VSS VSS
+ nch l=0.06U
+	 w=0.6U
M7451 XLCTRL_XXLDECC0_N2_2 A_XC_2
+ XLCTRL_XXLDECC0_N3 VSS nch l=0.06U
+ w=0.81U
M7452 XLCTRL_XXLDECC0_N2_2 A_XC_2
+ XLCTRL_XXLDECC0_N3 VSS nch l=0.06U
+ w=0.81U
M7453 XLCTRL_XSMPD_Z3 XLCTRL_XSMPD_Z2 VSS VSS
+ nch l=0.06U
+ w=0.41U
M7454 XLCTRL_XSMPD_Z3 XLCTRL_XSMPD_Z2 VSS
+ VSS nch l=0.06U
+	 w=0.41U
M7455 SOE XLCTRL_XSMPD_Z3 VSS VSS nch
+ l=0.06U
+ w=1.875U
M7456 SOE XLCTRL_XSMPD_Z3 VSS VSS
+ nch l=0.06U
+	 w=1.875U
M7457 SOE XLCTRL_XSMPD_Z3 VSS VSS
+ nch l=0.06U
+	 w=1.25U
M7458 XLCTRL_XRWDEC_Z2
+ XLCTRL_XRWDEC_RDLC VSS VSS nch
+ l=0.06U
+ w=0.6U
M7459 VSS ZZ XLCTRL_XRWDEC_Z3 VSS
+ nch l=0.06U
+ w=0.82U
M7460 XLCTRL_XRWDEC_RDLC A_RD
+ XLCTRL_XRWDEC_Z3 VSS nch l=0.06U
+ w=0.82U
M7461 XLCTRL_XSMPD_Z20_3 A_GCDEC_3
+ XLCTRL_XSMPD_N18 VSS nch l=0.06U
+ w=0.82U
M7462 VSS ZZ XLCTRL_XSMPD_Z17_0 VSS
+ nch l=0.06U
+	 w=0.41U
M7463 XLCTRL_XSMPD_N18 A_RD
+ XLCTRL_XSMPD_Z17_0 VSS nch l=0.06U
+ w=0.41U
M7464 XLCTRL_XRWDEC_WRTLC A_WRT
+ XLCTRL_XRWDEC_Z1 VSS nch l=0.06U
+ w=0.81U
M7465 XLCTRL_XRWDEC_WRTLC A_WRT
+ XLCTRL_XRWDEC_Z1 VSS nch l=0.06U
+ w=0.81U
M7466 VSS ZZ XLCTRL_XRWDEC_Z1 VSS
+ nch l=0.06U
+ w=1.4U
.ENDS
* LCTRLB
.SUBCKT SDL400W20S_NLCTRLB A_GCDEC_3 A_GCDEC_2 A_GCDEC_1 A_GCDEC_0 A_RD
+	 A_VS_1 A_VS_0 A_WRT A_XA_7 A_XA_6 A_XA_5 A_XA_4 A_XA_3 A_XA_2
+	 A_XA_1 A_XA_0 A_XB_3 A_XB_2 A_XB_1 A_XB_0 A_XC_7 A_XC_6
+	 A_XC_5 A_XC_4 A_XC_3 A_XC_2 A_XC_1 A_XC_0 A_Y_7 A_Y_6 A_Y_5
+	 A_Y_4 A_Y_3 A_Y_2 A_Y_1 A_Y_0 B_GCDEC_3 B_GCDEC_2 B_GCDEC_1
+	 B_GCDEC_0 B_RD B_VS_1 B_VS_0 B_WRT B_XA_7 B_XA_6 B_XA_5
+	 B_XA_4 B_XA_3 B_XA_2 B_XA_1 B_XA_0 B_XB_3 B_XB_2 B_XB_1
+	 B_XB_0 B_XC_7 B_XC_6 B_XC_5 B_XC_4 B_XC_3 B_XC_2 B_XC_1
+	 B_XC_0 B_Y_7 B_Y_6 B_Y_5 B_Y_4 B_Y_3 B_Y_2 B_Y_1 B_Y_0 ZZ RDL
+	 SMPRS_3 SMPRS_2 SMPRS_1 SMPRS_0 SOE WRTL XLA_7 XLA_6 XLA_5
+	 XLA_4 XLA_3 XLA_2 XLA_1 XLA_0 XLB_3 XLB_2 XLB_1 XLB_0 XLC_7
+	 XLC_6 XLC_5 XLC_4 XLC_3 XLC_2 XLC_1 XLC_0 YSEL_7 YSEL_6
+	 YSEL_5 YSEL_4 YSEL_3 YSEL_2 YSEL_1 YSEL_0 A_Z_7 A_Z_6 A_Z_5
+	 A_Z_4 A_Z_3 A_Z_2 A_Z_1 A_Z_0 B_Z_7 B_Z_6 B_Z_5 B_Z_4 B_Z_3
+	 B_Z_2 B_Z_1 B_Z_0
M7467 VDD ZZ XLCTRL_XSMPD_Z20_3 VDD
+ pch l=0.06U
+	 w=0.41U
M7468 VDD B_RD XLCTRL_XSMPD_Z20_3 VDD
+ pch l=0.06U
+ w=0.41U
M7469 VDD B_GCDEC_3 XLCTRL_XSMPD_Z20_3
+ VDD pch l=0.06U
+	 w=0.41U
M7470 VDD B_GCDEC_2 XLCTRL_XSMPD_Z20_2
+ VDD pch l=0.06U
+	 w=0.41U
M7471 VDD B_RD XLCTRL_XSMPD_Z20_2 VDD
+ pch l=0.06U
+ w=0.41U
M7472 VDD ZZ XLCTRL_XSMPD_Z20_2 VDD
+ pch l=0.06U
+ w=0.41U
M7473 VDD ZZ XLCTRL_XSMPD_Z20_1 VDD
+ pch l=0.06U
+ w=0.41U
M7474 VDD B_RD XLCTRL_XSMPD_Z20_1 VDD
+ pch l=0.06U
+ w=0.41U
M7475 VDD B_GCDEC_1 XLCTRL_XSMPD_Z20_1
+ VDD pch l=0.06U
+	 w=0.41U
M7476 VDD B_GCDEC_0 XLCTRL_XSMPD_Z20_0
+ VDD pch l=0.06U
+	 w=0.41U
M7477 VDD B_RD XLCTRL_XSMPD_Z20_0 VDD
+ pch l=0.06U
+ w=0.41U
M7478 VDD XLCTRL_XSMPD_Z15
+ XLCTRL_XSMPD_Z14B VDD pch l=0.06U
+ w=0.41U
M7479 VDD XLCTRL_XSMPD_Z14B
+ XLCTRL_XSMPD_Z15B VDD pch l=0.1U
+ w=0.41U
M7480 VDD XLCTRL_XSMPD_Z13
+ XLCTRL_XSMPD_Z14 VDD pch l=0.06U
+ w=0.41U
M7481 VDD XLCTRL_XSMPD_Z14
+ XLCTRL_XSMPD_Z15 VDD pch l=0.1U
+ w=0.41U
M7482 VDD B_VS_1 XLCTRL_XSMPD_Z5 VDD pch
+ l=0.06U
+ w=0.41U
M7483 VDD XLCTRL_XSMPD_Z4 XLCTRL_XSMPD_Z5 VDD
+ pch l=0.08U
+ w=0.41U
M7484 VDD XLCTRL_XSMPD_Z1 XLCTRL_XSMPD_Z4 VDD
+ pch l=0.06U
+ w=0.41U
M7485 VDD XLCTRL_XSMPD_Z5 XLCTRL_XSMPD_Z6 VDD
+ pch l=0.06U
+ w=0.41U
M7486 VDD XLCTRL_XSMPD_Z15B
+ XLCTRL_XSMPD_Z16 VDD pch l=0.06U
+ w=0.62U
M7487 VDD XLCTRL_XSMPD_Z6 XLCTRL_XSMPD_Z7 VDD
+ pch l=0.08U
+ w=0.41U
M7488 VDD XLCTRL_XSMPD_Z1 XLCTRL_XSMPD_Z10
+ VDD pch l=0.06U
+ w=0.41U
M7489 VDD B_VS_0 XLCTRL_XSMPD_Z9 VDD pch
+ l=0.06U
+ w=0.41U
M7490 VDD XLCTRL_XSMPD_Z7 XLCTRL_XSMPD_Z8 VDD
+ pch l=0.06U
+ w=0.41U
M7491 VDD XLCTRL_XSMPD_Z1 XLCTRL_XSMPD_Z8 VDD
+ pch l=0.06U
+ w=0.41U
M7492 VDD XLCTRL_XSMPD_Z8 XLCTRL_XSMPD_Z9 VDD
+ pch l=0.08U
+ w=0.41U
M7493 VDD XLCTRL_XSMPD_Z12
+ XLCTRL_XSMPD_Z13 VDD pch l=0.1U
+ w=0.41U
M7494 VDD XLCTRL_XSMPD_Z11
+ XLCTRL_XSMPD_Z12 VDD pch l=0.06U
+ w=0.41U
M7495 VDD XLCTRL_XSMPD_Z9 XLCTRL_XSMPD_Z10
+ VDD pch l=0.06U
+ w=0.41U
M7496 VDD XLCTRL_XSMPD_Z10
+ XLCTRL_XSMPD_Z11 VDD pch l=0.12U
+ w=0.41U
M7497 VDD XLCTRL_XSMPD_Z7 XLCTRL_XSMPD_Z10
+ VDD pch l=0.06U
+ w=0.41U
M7498 VDD ZZ XLCTRL_XSMPD_Z1 VDD pch
+ l=0.06U
+ w=0.82U
M7499 VDD B_RD XLCTRL_XSMPD_Z1 VDD pch
+ l=0.06U
+ w=0.82U
M7500 VDD ZZ XLCTRL_XSMPD_Z20_0 VDD
+ pch l=0.06U
+ w=0.41U
M7501 VDD XLCTRL_XSMPD_Z16
+ XLCTRL_XSMPD_Z2 VDD pch l=0.06U
+ w=0.62U
M7502 VDD XLCTRL_XSMPD_Z1 XLCTRL_XSMPD_Z2 VDD
+ pch l=0.06U
+ w=0.62U
M7503 VDD XLCTRL_XSMPD_Z21_3
+ XLCTRL_XSMPD_Z22_3 VDD pch l=0.06U
+ w=0.62U
M7504 VDD XLCTRL_XSMPD_Z16
+ XLCTRL_XSMPD_Z22_3 VDD pch l=0.06U
+ w=0.62U
M7505 VDD XLCTRL_XSMPD_Z16
+ XLCTRL_XSMPD_Z22_2 VDD pch l=0.06U
+ w=0.62U
M7506 VDD XLCTRL_XSMPD_Z21_2
+ XLCTRL_XSMPD_Z22_2 VDD pch l=0.06U
+ w=0.62U
M7507 VDD XLCTRL_XSMPD_Z21_1
+ XLCTRL_XSMPD_Z22_1 VDD pch l=0.06U
+ w=0.62U
M7508 VDD XLCTRL_XSMPD_Z16
+ XLCTRL_XSMPD_Z22_1 VDD pch l=0.06U
+ w=0.62U
M7509 VDD XLCTRL_XSMPD_Z16
+ XLCTRL_XSMPD_Z22_0 VDD pch l=0.06U
+ w=0.62U
M7510 VDD XLCTRL_XSMPD_Z21_0
+ XLCTRL_XSMPD_Z22_0 VDD pch l=0.06U
+ w=0.62U
M7511 XLCTRL_XSMPD_XND21_3_NET9
+ XLCTRL_XSMPD_Z21_3 VSS VSS nch
+ l=0.06U
+ w=0.62U
M7512 XLCTRL_XSMPD_Z22_3
+	XLCTRL_XSMPD_Z16 XLCTRL_XSMPD_XND21_3_NET9 VSS
+ nch l=0.06U
+ w=0.62U
M7513 XLCTRL_XSMPD_XND21_2_NET9
+	XLCTRL_XSMPD_Z16 XLCTRL_XSMPD_Z22_2 VSS nch
+ l=0.06U
+ w=0.62U
M7514 XLCTRL_XSMPD_XND21_2_NET9
+ XLCTRL_XSMPD_Z21_2 VSS VSS nch
+ l=0.06U
+ w=0.62U
M7515 VSS XLCTRL_XSMPD_Z21_1
+ XLCTRL_XSMPD_XND21_1_NET9 VSS nch
+ l=0.06U
+ w=0.62U
M7516 XLCTRL_XSMPD_Z22_1
+	XLCTRL_XSMPD_Z16 XLCTRL_XSMPD_XND21_1_NET9 VSS
+ nch l=0.06U
+ w=0.62U
M7517 XLCTRL_XSMPD_Z22_0
+	XLCTRL_XSMPD_Z16 XLCTRL_XSMPD_XND21_0_NET9 VSS
+ nch l=0.06U
+ w=0.62U
M7518 XLCTRL_XSMPD_XND21_0_NET9
+ XLCTRL_XSMPD_Z21_0 VSS VSS nch
+ l=0.06U
+ w=0.62U
M7519 VDD ZZ XLCTRL_XYLDEC1_N2_0 VDD
+ pch l=0.06U
+ w=0.41U
M7520 VDD ZZ XLCTRL_XYLDEC1_N2_1 VDD
+ pch l=0.06U
+ w=0.41U
M7521 VDD ZZ XLCTRL_XYLDEC1_N2_2 VDD
+ pch l=0.06U
+ w=0.41U
M7522 VDD ZZ XLCTRL_XYLDEC1_N2_3 VDD
+ pch l=0.06U
+ w=0.41U
M7523 XLCTRL_XSMPD_XND20_3_NET9
+ XLCTRL_XSMPD_Z22_3 VSS VSS nch
+ l=0.06U
+ w=1U
M7524 XLCTRL_XSMPD_Z21_3
+	XLCTRL_XSMPD_Z20_3 XLCTRL_XSMPD_XND20_3_NET9 VSS
+ nch l=0.06U
+ w=1U
M7525 XLCTRL_XSMPD_Z21_3
+	XLCTRL_XSMPD_Z20_3 XLCTRL_XSMPD_XND20_3_NET9 VSS
+ nch l=0.06U
+ w=1U
M7526 VSS XLCTRL_XSMPD_Z22_3
+ XLCTRL_XSMPD_XND20_3_NET9 VSS nch
+ l=0.06U
+ w=1U
M7527 XLCTRL_XSMPD_XND20_2_NET9
+ XLCTRL_XSMPD_Z22_2 VSS VSS nch
+ l=0.06U
+ w=1U
M7528 XLCTRL_XSMPD_Z21_2
+	XLCTRL_XSMPD_Z20_2 XLCTRL_XSMPD_XND20_2_NET9 VSS
+ nch l=0.06U
+ w=1U
M7529 XLCTRL_XSMPD_XND20_2_NET9
+ XLCTRL_XSMPD_Z22_2 VSS VSS nch
+ l=0.06U
+ w=1U
M7530 VSS XLCTRL_XSMPD_Z22_1
+ XLCTRL_XSMPD_XND20_1_NET9 VSS nch
+ l=0.06U
+ w=1U
M7531 XLCTRL_XSMPD_Z21_1
+	XLCTRL_XSMPD_Z20_1 XLCTRL_XSMPD_XND20_1_NET9 VSS
+ nch l=0.06U
+ w=1U
M7532 XLCTRL_XSMPD_XND20_1_NET9
+ XLCTRL_XSMPD_Z22_1 VSS VSS nch
+ l=0.06U
+ w=1U
M7533 XLCTRL_XSMPD_XND20_0_NET9
+ XLCTRL_XSMPD_Z22_0 VSS VSS nch
+ l=0.06U
+ w=1U
M7534 XLCTRL_XSMPD_Z21_0
+	XLCTRL_XSMPD_Z20_0 XLCTRL_XSMPD_XND20_0_NET9 VSS
+ nch l=0.06U
+ w=1U
M7535 XLCTRL_XSMPD_Z21_0
+	XLCTRL_XSMPD_Z20_0 XLCTRL_XSMPD_XND20_0_NET9 VSS
+ nch l=0.06U
+ w=1U
M7536 XLCTRL_XSMPD_XND20_0_NET9
+ XLCTRL_XSMPD_Z22_0 VSS VSS nch
+ l=0.06U
+ w=1U
M7537 XLCTRL_XSMPD_XND20_2_NET9
+	XLCTRL_XSMPD_Z20_2 XLCTRL_XSMPD_Z21_2 VSS nch
+ l=0.06U
+ w=1U
M7538 XLCTRL_XSMPD_Z21_1
+	XLCTRL_XSMPD_Z20_1 XLCTRL_XSMPD_XND20_1_NET9 VSS
+ nch l=0.06U
+ w=1U
M7539 VDD B_Y_4 XLCTRL_XYLDEC1_N2_0 VDD
+ pch l=0.06U
+	 w=0.615U
M7540 VDD B_Y_4 XLCTRL_XYLDEC1_N2_0 VDD
+ pch l=0.06U
+	 w=0.615U
M7541 VDD B_Y_5 XLCTRL_XYLDEC1_N2_1 VDD
+ pch l=0.06U
+	 w=0.615U
M7542 VDD B_Y_5 XLCTRL_XYLDEC1_N2_1 VDD
+ pch l=0.06U
+ w=0.615U
M7543 VDD B_Y_6 XLCTRL_XYLDEC1_N2_2 VDD
+ pch l=0.06U
+ w=0.615U
M7544 VDD B_Y_6 XLCTRL_XYLDEC1_N2_2 VDD
+ pch l=0.06U
+	 w=0.615U
M7545 VDD B_Y_7 XLCTRL_XYLDEC1_N2_3 VDD
+ pch l=0.06U
+	 w=0.615U
M7546 VDD B_Y_7 XLCTRL_XYLDEC1_N2_3 VDD
+ pch l=0.06U
+	 w=0.615U
M7547 VDD XLCTRL_XSMPD_Z20_3
+ XLCTRL_XSMPD_Z21_3 VDD pch l=0.06U
+ w=0.935U
M7548 VDD XLCTRL_XSMPD_Z20_3
+ XLCTRL_XSMPD_Z21_3 VDD pch l=0.06U
+ w=0.935U
M7549 VDD XLCTRL_XSMPD_Z20_3
+ XLCTRL_XSMPD_Z21_3 VDD pch l=0.06U
+ w=0.935U
M7550 VDD XLCTRL_XSMPD_Z22_3
+ XLCTRL_XSMPD_Z21_3 VDD pch l=0.06U
+ w=0.82U
M7551 VDD XLCTRL_XSMPD_Z22_2
+ XLCTRL_XSMPD_Z21_2 VDD pch l=0.06U
+ w=0.82U
M7552 VDD XLCTRL_XSMPD_Z20_2
+ XLCTRL_XSMPD_Z21_2 VDD pch l=0.06U
+ w=0.935U
M7553 VDD XLCTRL_XSMPD_Z20_2
+ XLCTRL_XSMPD_Z21_2 VDD pch l=0.06U
+ w=0.935U
M7554 VDD XLCTRL_XSMPD_Z20_2
+ XLCTRL_XSMPD_Z21_2 VDD pch l=0.06U
+ w=0.935U
M7555 VDD XLCTRL_XSMPD_Z20_1
+ XLCTRL_XSMPD_Z21_1 VDD pch l=0.06U
+ w=0.935U
M7556 VDD XLCTRL_XSMPD_Z20_1
+ XLCTRL_XSMPD_Z21_1 VDD pch l=0.06U
+ w=0.935U
M7557 VDD XLCTRL_XSMPD_Z20_1
+ XLCTRL_XSMPD_Z21_1 VDD pch l=0.06U
+ w=0.935U
M7558 VDD XLCTRL_XSMPD_Z22_1
+ XLCTRL_XSMPD_Z21_1 VDD pch l=0.06U
+ w=0.82U
M7559 VDD XLCTRL_XSMPD_Z22_0
+ XLCTRL_XSMPD_Z21_0 VDD pch l=0.06U
+ w=0.82U
M7560 VDD XLCTRL_XSMPD_Z20_0
+ XLCTRL_XSMPD_Z21_0 VDD pch l=0.06U
+ w=0.935U
M7561 VDD XLCTRL_XSMPD_Z20_0
+ XLCTRL_XSMPD_Z21_0 VDD pch l=0.06U
+ w=0.935U
M7562 VDD XLCTRL_XSMPD_Z20_0
+ XLCTRL_XSMPD_Z21_0 VDD pch l=0.06U
+ w=0.935U
M7563 VDD XLCTRL_XSMPD_Z21_3 SMPRS_3 VDD
+ pch_hvt l=0.06U
+	 w=2.5U
M7564 VDD XLCTRL_XSMPD_Z21_3
+ SMPRS_3 VDD pch_hvt l=0.06U
+ w=2.5U
M7565 VDD XLCTRL_XSMPD_Z21_3
+ SMPRS_3 VDD pch_hvt l=0.06U
+ w=2.5U
M7566 VDD XLCTRL_XSMPD_Z21_3
+ SMPRS_3 VDD pch_hvt l=0.06U
+ w=2.5U
M7567 VDD XLCTRL_XSMPD_Z21_2
+ SMPRS_2 VDD pch_hvt l=0.06U
+ w=2.5U
M7568 VDD XLCTRL_XSMPD_Z21_2
+ SMPRS_2 VDD pch_hvt l=0.06U
+ w=2.5U
M7569 VDD XLCTRL_XSMPD_Z21_2
+ SMPRS_2 VDD pch_hvt l=0.06U
+ w=2.5U
M7570 VDD XLCTRL_XSMPD_Z21_2 SMPRS_2 VDD
+ pch_hvt l=0.06U
+ w=2.5U
M7571 VDD XLCTRL_XSMPD_Z21_1 SMPRS_1 VDD
+ pch_hvt l=0.06U
+ w=2.5U
M7572 VDD XLCTRL_XSMPD_Z21_1
+ SMPRS_1 VDD pch_hvt l=0.06U
+ w=2.5U
M7573 VDD XLCTRL_XSMPD_Z21_1
+ SMPRS_1 VDD pch_hvt l=0.06U
+ w=2.5U
M7574 VDD XLCTRL_XSMPD_Z21_1
+ SMPRS_1 VDD pch_hvt l=0.06U
+ w=2.5U
M7575 VDD XLCTRL_XSMPD_Z21_0
+ SMPRS_0 VDD pch_hvt l=0.06U
+ w=2.5U
M7576 VDD XLCTRL_XSMPD_Z21_0
+ SMPRS_0 VDD pch_hvt l=0.06U
+ w=2.5U
M7577 VDD XLCTRL_XSMPD_Z21_0
+ SMPRS_0 VDD pch_hvt l=0.06U
+ w=2.5U
M7578 VDD XLCTRL_XSMPD_Z21_0 SMPRS_0 VDD
+ pch_hvt l=0.06U
+	 w=2.5U
M7579 VDD XLCTRL_XYLDEC1_N2_0 YSEL_4
+ VDD pch_hvt l=0.06U
+ w=3.335U
M7580 VDD XLCTRL_XYLDEC1_N2_0 YSEL_4
+ VDD pch_hvt l=0.06U
+ w=3.335U
M7581 VDD XLCTRL_XYLDEC1_N2_0 YSEL_4
+ VDD pch_hvt l=0.06U
+ w=3.335U
M7582 VDD XLCTRL_XYLDEC1_N2_1 YSEL_5
+ VDD pch_hvt l=0.06U
+ w=3.335U
M7583 VDD XLCTRL_XYLDEC1_N2_1 YSEL_5
+ VDD pch_hvt l=0.06U
+ w=3.335U
M7584 VDD XLCTRL_XYLDEC1_N2_1 YSEL_5
+ VDD pch_hvt l=0.06U
+ w=3.335U
M7585 VDD XLCTRL_XYLDEC1_N2_2 YSEL_6
+ VDD pch_hvt l=0.06U
+ w=3.335U
M7586 VDD XLCTRL_XYLDEC1_N2_2 YSEL_6
+ VDD pch_hvt l=0.06U
+ w=3.335U
M7587 VDD XLCTRL_XYLDEC1_N2_2 YSEL_6
+ VDD pch_hvt l=0.06U
+ w=3.335U
M7588 VDD XLCTRL_XYLDEC1_N2_3 YSEL_7
+ VDD pch_hvt l=0.06U
+ w=3.335U
M7589 VDD XLCTRL_XYLDEC1_N2_3 YSEL_7
+ VDD pch_hvt l=0.06U
+ w=3.335U
M7590 VDD XLCTRL_XYLDEC1_N2_3 YSEL_7
+ VDD pch_hvt l=0.06U
+ w=3.335U
M7591 YSEL_6 XLCTRL_XYLDEC1_N2_2 VSS
+ VSS nch_hvt l=0.06U
+ w=1.11U
M7592 YSEL_6 XLCTRL_XYLDEC1_N2_2 VSS
+ VSS nch_hvt l=0.06U
+	 w=1.11U
M7593 YSEL_6 XLCTRL_XYLDEC1_N2_2 VSS
+ VSS nch_hvt l=0.06U
+ w=1.11U
M7594 YSEL_5 XLCTRL_XYLDEC1_N2_1 VSS
+ VSS nch_hvt l=0.06U
+ w=1.11U
M7595 YSEL_5 XLCTRL_XYLDEC1_N2_1 VSS
+ VSS nch_hvt l=0.06U
+	 w=1.11U
M7596 YSEL_5 XLCTRL_XYLDEC1_N2_1 VSS
+ VSS nch_hvt l=0.06U
+ w=1.11U
M7597 YSEL_1 XLCTRL_XYLDEC0_N2_1 VSS
+ VSS nch_hvt l=0.06U
+ w=1.11U
M7598 YSEL_1 XLCTRL_XYLDEC0_N2_1 VSS
+ VSS nch_hvt l=0.06U
+	 w=1.11U
M7599 YSEL_1 XLCTRL_XYLDEC0_N2_1 VSS
+ VSS nch_hvt l=0.06U
+ w=1.11U
M7600 YSEL_2 XLCTRL_XYLDEC0_N2_2 VSS
+ VSS nch_hvt l=0.06U
+ w=1.11U
M7601 YSEL_2 XLCTRL_XYLDEC0_N2_2 VSS
+ VSS nch_hvt l=0.06U
+	 w=1.11U
M7602 YSEL_2 XLCTRL_XYLDEC0_N2_2 VSS
+ VSS nch_hvt l=0.06U
+ w=1.11U
M7603 XLB_1 XLCTRL_XXLDECB_N2_1 VSS
+ VSS nch_hvt l=0.06U
+ w=1.11U
M7604 XLB_1 XLCTRL_XXLDECB_N2_1 VSS
+ VSS nch_hvt l=0.06U
+	 w=1.11U
M7605 XLB_1 XLCTRL_XXLDECB_N2_1 VSS
+ VSS nch_hvt l=0.06U
+ w=1.11U
M7606 XLB_2 XLCTRL_XXLDECB_N2_2 VSS
+ VSS nch_hvt l=0.06U
+ w=1.11U
M7607 XLB_2 XLCTRL_XXLDECB_N2_2 VSS
+ VSS nch_hvt l=0.06U
+	 w=1.11U
M7608 XLB_2 XLCTRL_XXLDECB_N2_2 VSS
+ VSS nch_hvt l=0.06U
+ w=1.11U
M7609 VDD XLCTRL_XYLDEC0_N2_3 YSEL_3
+ VDD pch_hvt l=0.06U
+ w=3.335U
M7610 VDD XLCTRL_XYLDEC0_N2_3 YSEL_3
+ VDD pch_hvt l=0.06U
+ w=3.335U
M7611 VDD XLCTRL_XYLDEC0_N2_2 YSEL_2
+ VDD pch_hvt l=0.06U
+ w=3.335U
M7612 VDD XLCTRL_XYLDEC0_N2_2 YSEL_2
+ VDD pch_hvt l=0.06U
+ w=3.335U
M7613 VDD XLCTRL_XYLDEC0_N2_2 YSEL_2
+ VDD pch_hvt l=0.06U
+ w=3.335U
M7614 VDD XLCTRL_XYLDEC0_N2_1 YSEL_1
+ VDD pch_hvt l=0.06U
+ w=3.335U
M7615 VDD XLCTRL_XYLDEC0_N2_1 YSEL_1
+ VDD pch_hvt l=0.06U
+ w=3.335U
M7616 VDD XLCTRL_XYLDEC0_N2_1 YSEL_1
+ VDD pch_hvt l=0.06U
+ w=3.335U
M7617 VDD XLCTRL_XYLDEC0_N2_0 YSEL_0
+ VDD pch_hvt l=0.06U
+ w=3.335U
M7618 VDD XLCTRL_XYLDEC0_N2_0 YSEL_0
+ VDD pch_hvt l=0.06U
+ w=3.335U
M7619 VDD XLCTRL_XYLDEC0_N2_0 YSEL_0
+ VDD pch_hvt l=0.06U
+ w=3.335U
M7620 VDD XLCTRL_XXLDECB_N2_3 XLB_3
+ VDD pch_hvt l=0.06U
+ w=3.335U
M7621 VDD XLCTRL_XXLDECB_N2_3 XLB_3
+ VDD pch_hvt l=0.06U
+ w=3.335U
M7622 VDD XLCTRL_XXLDECB_N2_3 XLB_3
+ VDD pch_hvt l=0.06U
+ w=3.335U
M7623 VDD XLCTRL_XXLDECB_N2_2 XLB_2
+ VDD pch_hvt l=0.06U
+ w=3.335U
M7624 VDD XLCTRL_XXLDECB_N2_2 XLB_2
+ VDD pch_hvt l=0.06U
+ w=3.335U
M7625 VDD XLCTRL_XXLDECB_N2_2 XLB_2
+ VDD pch_hvt l=0.06U
+ w=3.335U
M7626 VDD XLCTRL_XXLDECB_N2_1 XLB_1
+ VDD pch_hvt l=0.06U
+ w=3.335U
M7627 VDD XLCTRL_XXLDECB_N2_1 XLB_1
+ VDD pch_hvt l=0.06U
+ w=3.335U
M7628 VDD XLCTRL_XXLDECB_N2_1 XLB_1
+ VDD pch_hvt l=0.06U
+ w=3.335U
M7629 VDD XLCTRL_XXLDECB_N2_0 XLB_0
+ VDD pch_hvt l=0.06U
+ w=3.335U
M7630 VDD XLCTRL_XXLDECB_N2_0 XLB_0
+ VDD pch_hvt l=0.06U
+ w=3.335U
M7631 VDD XLCTRL_XXLDECB_N2_0 XLB_0
+ VDD pch_hvt l=0.06U
+ w=3.335U
M7632 VDD B_Y_3 XLCTRL_XYLDEC0_N2_3 VDD
+ pch l=0.06U
+	 w=0.615U
M7633 VDD B_Y_2 XLCTRL_XYLDEC0_N2_2 VDD
+ pch l=0.06U
+	 w=0.615U
M7634 VDD B_Y_2 XLCTRL_XYLDEC0_N2_2 VDD
+ pch l=0.06U
+ w=0.615U
M7635 VDD B_Y_1 XLCTRL_XYLDEC0_N2_1 VDD
+ pch l=0.06U
+ w=0.615U
M7636 VDD B_Y_1 XLCTRL_XYLDEC0_N2_1 VDD
+ pch l=0.06U
+	 w=0.615U
M7637 VDD B_Y_0 XLCTRL_XYLDEC0_N2_0 VDD
+ pch l=0.06U
+	 w=0.615U
M7638 VDD B_Y_0 XLCTRL_XYLDEC0_N2_0 VDD
+ pch l=0.06U
+ w=0.615U
M7639 VDD B_XB_3 XLCTRL_XXLDECB_N2_3 VDD
+ pch l=0.06U
+ w=0.615U
M7640 VDD B_XB_3 XLCTRL_XXLDECB_N2_3 VDD
+ pch l=0.06U
+	 w=0.615U
M7641 VDD B_XB_2 XLCTRL_XXLDECB_N2_2 VDD
+ pch l=0.06U
+	 w=0.615U
M7642 VDD B_XB_2 XLCTRL_XXLDECB_N2_2 VDD
+ pch l=0.06U
+ w=0.615U
M7643 VDD B_XB_1 XLCTRL_XXLDECB_N2_1 VDD
+ pch l=0.06U
+ w=0.615U
M7644 VDD B_XB_1 XLCTRL_XXLDECB_N2_1 VDD
+ pch l=0.06U
+	 w=0.615U
M7645 VDD B_XB_0 XLCTRL_XXLDECB_N2_0 VDD
+ pch l=0.06U
+	 w=0.615U
M7646 VDD B_XB_0 XLCTRL_XXLDECB_N2_0 VDD
+ pch l=0.06U
+	 w=0.615U
M7647 VDD ZZ XLCTRL_XYLDEC0_N2_2 VDD
+ pch l=0.06U
+ w=0.41U
M7648 VDD ZZ XLCTRL_XYLDEC0_N2_1 VDD
+ pch l=0.06U
+ w=0.41U
M7649 VDD ZZ XLCTRL_XYLDEC0_N2_0 VDD
+ pch l=0.06U
+ w=0.41U
M7650 VDD ZZ XLCTRL_XXLDECB_N2_3 VDD
+ pch l=0.06U
+ w=0.41U
M7651 VDD ZZ XLCTRL_XXLDECB_N2_2 VDD
+ pch l=0.06U
+ w=0.41U
M7652 VDD ZZ XLCTRL_XXLDECB_N2_1 VDD
+ pch l=0.06U
+ w=0.41U
M7653 VDD ZZ XLCTRL_XXLDECB_N2_0 VDD
+ pch l=0.06U
+ w=0.41U
M7654 VDD XLCTRL_XSMPD_Z3 SOE VDD pch
+ l=0.06U
+	 w=3.33U
M7655 VDD XLCTRL_XSMPD_Z3 SOE VDD
+ pch l=0.06U
+ w=3.335U
M7656 VDD XLCTRL_XSMPD_Z3 SOE VDD
+ pch l=0.06U
+ w=3.335U
M7657 VDD XLCTRL_XSMPD_Z2 XLCTRL_XSMPD_Z3 VDD
+ pch l=0.06U
+ w=0.74U
M7658 VDD XLCTRL_XSMPD_Z2
+ XLCTRL_XSMPD_Z3 VDD pch l=0.06U
+ w=0.74U
M7659 VDD XLCTRL_XSMPD_Z2
+ XLCTRL_XSMPD_Z3 VDD pch l=0.06U
+ w=0.74U
M7660 VDD XLCTRL_XSMPD_Z2
+ XLCTRL_XSMPD_Z3 VDD pch l=0.06U
+ w=0.74U
M7661 VDD XLCTRL_XYLDEC0_N2_3 YSEL_3
+ VDD pch_hvt l=0.06U
+ w=3.335U
M7662 VDD ZZ XLCTRL_XYLDEC0_N2_3 VDD
+ pch l=0.06U
+ w=0.41U
M7663 VDD B_Y_3 XLCTRL_XYLDEC0_N2_3 VDD
+ pch l=0.06U
+ w=0.615U
M7664 VDD ZZ XLCTRL_XXLDECC1_N2_1 VDD
+ pch l=0.06U
+ w=0.41U
M7665 VDD ZZ XLCTRL_XXLDECC1_N2_2 VDD
+ pch l=0.06U
+ w=0.41U
M7666 VDD ZZ XLCTRL_XXLDECC1_N2_3 VDD
+ pch l=0.06U
+ w=0.41U
M7667 VDD ZZ XLCTRL_XXLDECA1_N2_3 VDD
+ pch l=0.06U
+ w=0.41U
M7668 VDD ZZ XLCTRL_XXLDECA1_N2_2 VDD
+ pch l=0.06U
+ w=0.41U
M7669 VDD ZZ XLCTRL_XXLDECA1_N2_1 VDD
+ pch l=0.06U
+ w=0.41U
M7670 VDD ZZ XLCTRL_XXLDECA1_N2_0 VDD
+ pch l=0.06U
+ w=0.41U
M7671 VDD B_XC_4 XLCTRL_XXLDECC1_N2_0
+ VDD pch l=0.06U
+ w=0.615U
M7672 VDD B_XC_5 XLCTRL_XXLDECC1_N2_1
+ VDD pch l=0.06U
+	 w=0.615U
M7673 VDD B_XC_5 XLCTRL_XXLDECC1_N2_1 VDD
+ pch l=0.06U
+ w=0.615U
M7674 VDD B_XC_6 XLCTRL_XXLDECC1_N2_2 VDD
+ pch l=0.06U
+ w=0.615U
M7675 VDD B_XC_6 XLCTRL_XXLDECC1_N2_2
+ VDD pch l=0.06U
+	 w=0.615U
M7676 VDD B_XC_7 XLCTRL_XXLDECC1_N2_3 VDD
+ pch l=0.06U
+	 w=0.615U
M7677 VDD B_XC_7 XLCTRL_XXLDECC1_N2_3
+ VDD pch l=0.06U
+ w=0.615U
M7678 VDD B_XA_1 XLCTRL_XXLDECA1_N2_3
+ VDD pch l=0.06U
+ w=0.615U
M7679 VDD B_XA_1 XLCTRL_XXLDECA1_N2_3 VDD
+ pch l=0.06U
+	 w=0.615U
M7680 VDD B_XA_3 XLCTRL_XXLDECA1_N2_2
+ VDD pch l=0.06U
+	 w=0.615U
M7681 VDD B_XA_3 XLCTRL_XXLDECA1_N2_2 VDD
+ pch l=0.06U
+ w=0.615U
M7682 VDD B_XA_5 XLCTRL_XXLDECA1_N2_1 VDD
+ pch l=0.06U
+ w=0.615U
M7683 VDD B_XA_5 XLCTRL_XXLDECA1_N2_1
+ VDD pch l=0.06U
+	 w=0.615U
M7684 VDD B_XA_7 XLCTRL_XXLDECA1_N2_0
+ VDD pch l=0.06U
+	 w=0.615U
M7685 VDD B_XA_7 XLCTRL_XXLDECA1_N2_0 VDD
+ pch l=0.06U
+	 w=0.615U
M7686 VDD XLCTRL_XXLDECC1_N2_0 XLC_4
+ VDD pch_hvt l=0.06U
+ w=3.335U
M7687 VDD XLCTRL_XXLDECC1_N2_0 XLC_4
+ VDD pch_hvt l=0.06U
+	 w=3.335U
M7688 VDD XLCTRL_XXLDECC1_N2_1 XLC_5
+ VDD pch_hvt l=0.06U
+ w=3.335U
M7689 VDD XLCTRL_XXLDECC1_N2_1 XLC_5
+ VDD pch_hvt l=0.06U
+ w=3.335U
M7690 VDD XLCTRL_XXLDECC1_N2_1 XLC_5
+ VDD pch_hvt l=0.06U
+ w=3.335U
M7691 VDD XLCTRL_XXLDECC1_N2_2 XLC_6
+ VDD pch_hvt l=0.06U
+ w=3.335U
M7692 VDD XLCTRL_XXLDECC1_N2_2 XLC_6
+ VDD pch_hvt l=0.06U
+ w=3.335U
M7693 VDD XLCTRL_XXLDECC1_N2_2 XLC_6
+ VDD pch_hvt l=0.06U
+ w=3.335U
M7694 VDD XLCTRL_XXLDECC1_N2_3 XLC_7
+ VDD pch_hvt l=0.06U
+ w=3.335U
M7695 VDD XLCTRL_XXLDECC1_N2_3 XLC_7
+ VDD pch_hvt l=0.06U
+ w=3.335U
M7696 VDD XLCTRL_XXLDECC1_N2_3 XLC_7
+ VDD pch_hvt l=0.06U
+ w=3.335U
M7697 VDD XLCTRL_XXLDECA1_N2_3 XLA_1
+ VDD pch_hvt l=0.06U
+ w=3.335U
M7698 VDD XLCTRL_XXLDECA1_N2_3 XLA_1
+ VDD pch_hvt l=0.06U
+ w=3.335U
M7699 VDD XLCTRL_XXLDECA1_N2_3 XLA_1
+ VDD pch_hvt l=0.06U
+ w=3.335U
M7700 VDD XLCTRL_XXLDECA1_N2_2 XLA_3
+ VDD pch_hvt l=0.06U
+ w=3.335U
M7701 VDD XLCTRL_XXLDECA1_N2_2 XLA_3
+ VDD pch_hvt l=0.06U
+ w=3.335U
M7702 VDD XLCTRL_XXLDECA1_N2_2 XLA_3
+ VDD pch_hvt l=0.06U
+ w=3.335U
M7703 VDD XLCTRL_XXLDECA1_N2_1 XLA_5
+ VDD pch_hvt l=0.06U
+ w=3.335U
M7704 VDD XLCTRL_XXLDECA1_N2_1 XLA_5
+ VDD pch_hvt l=0.06U
+ w=3.335U
M7705 VDD XLCTRL_XXLDECA1_N2_1 XLA_5
+ VDD pch_hvt l=0.06U
+ w=3.335U
M7706 VDD XLCTRL_XXLDECA1_N2_0 XLA_7
+ VDD pch_hvt l=0.06U
+ w=3.335U
M7707 VDD XLCTRL_XXLDECA1_N2_0 XLA_7
+ VDD pch_hvt l=0.06U
+ w=3.335U
M7708 VDD XLCTRL_XXLDECA1_N2_0 XLA_7
+ VDD pch_hvt l=0.06U
+ w=3.335U
M7709 VDD ZZ XLCTRL_XRWDEC_RDLC VDD
+ pch l=0.06U
+	 w=0.41U
M7710 VDD B_RD XLCTRL_XRWDEC_RDLC VDD
+ pch l=0.06U
+ w=0.82U
M7711 VDD XLCTRL_XRWDEC_RDLC
+ XLCTRL_XRWDEC_Z2 VDD pch l=0.06U
+ w=1.4U
M7712 VDD XLCTRL_XRWDEC_RDLC
+ XLCTRL_XRWDEC_Z2 VDD pch l=0.06U
+ w=1.4U
M7713 VDD XLCTRL_XRWDEC_Z2 RDL VDD
+ pch_hvt l=0.06U
+ w=3.335U
M7714 VDD XLCTRL_XRWDEC_Z2 RDL
+ VDD pch_hvt l=0.06U
+ w=3.335U
M7715 VDD XLCTRL_XRWDEC_Z2 RDL
+ VDD pch_hvt l=0.06U
+ w=3.335U
M7716 VDD XLCTRL_XXLDECC1_N2_0 XLC_4
+ VDD pch_hvt l=0.06U
+ w=3.335U
M7717 VDD B_XC_4 XLCTRL_XXLDECC1_N2_0 VDD
+ pch l=0.06U
+ w=0.615U
M7718 VDD ZZ XLCTRL_XXLDECC1_N2_0 VDD
+ pch l=0.06U
+	 w=0.41U
M7719 XLC_6 XLCTRL_XXLDECC1_N2_2 VSS
+ VSS nch_hvt l=0.06U
+ w=1.11U
M7720 XLC_6 XLCTRL_XXLDECC1_N2_2 VSS
+ VSS nch_hvt l=0.06U
+	 w=1.11U
M7721 XLC_6 XLCTRL_XXLDECC1_N2_2 VSS
+ VSS nch_hvt l=0.06U
+ w=1.11U
M7722 XLC_5 XLCTRL_XXLDECC1_N2_1 VSS
+ VSS nch_hvt l=0.06U
+ w=1.11U
M7723 XLC_5 XLCTRL_XXLDECC1_N2_1 VSS
+ VSS nch_hvt l=0.06U
+	 w=1.11U
M7724 XLC_5 XLCTRL_XXLDECC1_N2_1 VSS
+ VSS nch_hvt l=0.06U
+ w=1.11U
M7725 XLA_5 XLCTRL_XXLDECA1_N2_1 VSS
+ VSS nch_hvt l=0.06U
+ w=1.11U
M7726 XLA_5 XLCTRL_XXLDECA1_N2_1 VSS
+ VSS nch_hvt l=0.06U
+	 w=1.11U
M7727 XLA_5 XLCTRL_XXLDECA1_N2_1 VSS
+ VSS nch_hvt l=0.06U
+ w=1.11U
M7728 XLA_3 XLCTRL_XXLDECA1_N2_2 VSS
+ VSS nch_hvt l=0.06U
+ w=1.11U
M7729 XLA_3 XLCTRL_XXLDECA1_N2_2 VSS
+ VSS nch_hvt l=0.06U
+	 w=1.11U
M7730 XLA_3 XLCTRL_XXLDECA1_N2_2 VSS
+ VSS nch_hvt l=0.06U
+ w=1.11U
M7731 XLC_1 XLCTRL_XXLDECC0_N2_1 VSS
+ VSS nch_hvt l=0.06U
+ w=1.11U
M7732 XLC_1 XLCTRL_XXLDECC0_N2_1 VSS
+ VSS nch_hvt l=0.06U
+	 w=1.11U
M7733 XLC_1 XLCTRL_XXLDECC0_N2_1 VSS
+ VSS nch_hvt l=0.06U
+ w=1.11U
M7734 XLC_2 XLCTRL_XXLDECC0_N2_2 VSS
+ VSS nch_hvt l=0.06U
+ w=1.11U
M7735 XLC_2 XLCTRL_XXLDECC0_N2_2 VSS
+ VSS nch_hvt l=0.06U
+	 w=1.11U
M7736 XLC_2 XLCTRL_XXLDECC0_N2_2 VSS
+ VSS nch_hvt l=0.06U
+ w=1.11U
M7737 XLA_2 XLCTRL_XXLDECA0_N2_2 VSS
+ VSS nch_hvt l=0.06U
+ w=1.11U
M7738 XLA_2 XLCTRL_XXLDECA0_N2_2 VSS
+ VSS nch_hvt l=0.06U
+	 w=1.11U
M7739 XLA_2 XLCTRL_XXLDECA0_N2_2 VSS
+ VSS nch_hvt l=0.06U
+ w=1.11U
M7740 XLA_4 XLCTRL_XXLDECA0_N2_1 VSS
+ VSS nch_hvt l=0.06U
+ w=1.11U
M7741 XLA_4 XLCTRL_XXLDECA0_N2_1 VSS
+ VSS nch_hvt l=0.06U
+	 w=1.11U
M7742 XLA_4 XLCTRL_XXLDECA0_N2_1 VSS
+ VSS nch_hvt l=0.06U
+ w=1.11U
M7743 VDD XLCTRL_XXLDECC0_N2_3 XLC_3
+ VDD pch_hvt l=0.06U
+ w=3.335U
M7744 VDD XLCTRL_XXLDECC0_N2_3 XLC_3
+ VDD pch_hvt l=0.06U
+ w=3.335U
M7745 VDD XLCTRL_XXLDECC0_N2_2 XLC_2
+ VDD pch_hvt l=0.06U
+ w=3.335U
M7746 VDD XLCTRL_XXLDECC0_N2_2 XLC_2
+ VDD pch_hvt l=0.06U
+ w=3.335U
M7747 VDD XLCTRL_XXLDECC0_N2_2 XLC_2
+ VDD pch_hvt l=0.06U
+ w=3.335U
M7748 VDD XLCTRL_XXLDECC0_N2_1 XLC_1
+ VDD pch_hvt l=0.06U
+ w=3.335U
M7749 VDD XLCTRL_XXLDECC0_N2_1 XLC_1
+ VDD pch_hvt l=0.06U
+ w=3.335U
M7750 VDD XLCTRL_XXLDECC0_N2_1 XLC_1
+ VDD pch_hvt l=0.06U
+ w=3.335U
M7751 VDD XLCTRL_XXLDECC0_N2_0 XLC_0
+ VDD pch_hvt l=0.06U
+ w=3.335U
M7752 VDD XLCTRL_XXLDECC0_N2_0 XLC_0
+ VDD pch_hvt l=0.06U
+ w=3.335U
M7753 VDD XLCTRL_XXLDECC0_N2_0 XLC_0
+ VDD pch_hvt l=0.06U
+ w=3.335U
M7754 VDD XLCTRL_XXLDECA0_N2_0 XLA_6
+ VDD pch_hvt l=0.06U
+ w=3.335U
M7755 VDD XLCTRL_XXLDECA0_N2_0 XLA_6
+ VDD pch_hvt l=0.06U
+ w=3.335U
M7756 VDD XLCTRL_XXLDECA0_N2_0 XLA_6
+ VDD pch_hvt l=0.06U
+ w=3.335U
M7757 VDD XLCTRL_XXLDECA0_N2_1 XLA_4
+ VDD pch_hvt l=0.06U
+ w=3.335U
M7758 VDD XLCTRL_XXLDECA0_N2_1 XLA_4
+ VDD pch_hvt l=0.06U
+ w=3.335U
M7759 VDD XLCTRL_XXLDECA0_N2_1 XLA_4
+ VDD pch_hvt l=0.06U
+ w=3.335U
M7760 VDD XLCTRL_XXLDECA0_N2_2 XLA_2
+ VDD pch_hvt l=0.06U
+ w=3.335U
M7761 VDD XLCTRL_XXLDECA0_N2_2 XLA_2
+ VDD pch_hvt l=0.06U
+ w=3.335U
M7762 VDD XLCTRL_XXLDECA0_N2_2 XLA_2
+ VDD pch_hvt l=0.06U
+ w=3.335U
M7763 VDD XLCTRL_XXLDECA0_N2_3 XLA_0
+ VDD pch_hvt l=0.06U
+ w=3.335U
M7764 VDD XLCTRL_XXLDECA0_N2_3 XLA_0
+ VDD pch_hvt l=0.06U
+ w=3.335U
M7765 VDD XLCTRL_XXLDECA0_N2_3 XLA_0
+ VDD pch_hvt l=0.06U
+ w=3.335U
M7766 VDD B_XC_3 XLCTRL_XXLDECC0_N2_3
+ VDD pch l=0.06U
+	 w=0.615U
M7767 VDD B_XC_2 XLCTRL_XXLDECC0_N2_2
+ VDD pch l=0.06U
+	 w=0.615U
M7768 VDD B_XC_2 XLCTRL_XXLDECC0_N2_2 VDD
+ pch l=0.06U
+ w=0.615U
M7769 VDD B_XC_1 XLCTRL_XXLDECC0_N2_1 VDD
+ pch l=0.06U
+ w=0.615U
M7770 VDD B_XC_1 XLCTRL_XXLDECC0_N2_1
+ VDD pch l=0.06U
+	 w=0.615U
M7771 VDD B_XC_0 XLCTRL_XXLDECC0_N2_0 VDD
+ pch l=0.06U
+	 w=0.615U
M7772 VDD B_XC_0 XLCTRL_XXLDECC0_N2_0
+ VDD pch l=0.06U
+ w=0.615U
M7773 VDD B_XA_6 XLCTRL_XXLDECA0_N2_0
+ VDD pch l=0.06U
+ w=0.615U
M7774 VDD B_XA_6 XLCTRL_XXLDECA0_N2_0 VDD
+ pch l=0.06U
+	 w=0.615U
M7775 VDD B_XA_4 XLCTRL_XXLDECA0_N2_1
+ VDD pch l=0.06U
+	 w=0.615U
M7776 VDD B_XA_4 XLCTRL_XXLDECA0_N2_1 VDD
+ pch l=0.06U
+ w=0.615U
M7777 VDD B_XA_2 XLCTRL_XXLDECA0_N2_2 VDD
+ pch l=0.06U
+ w=0.615U
M7778 VDD B_XA_2 XLCTRL_XXLDECA0_N2_2
+ VDD pch l=0.06U
+	 w=0.615U
M7779 VDD B_XA_0 XLCTRL_XXLDECA0_N2_3
+ VDD pch l=0.06U
+	 w=0.615U
M7780 VDD B_XA_0 XLCTRL_XXLDECA0_N2_3 VDD
+ pch l=0.06U
+	 w=0.615U
M7781 VDD ZZ XLCTRL_XXLDECC0_N2_2 VDD
+ pch l=0.06U
+ w=0.41U
M7782 VDD ZZ XLCTRL_XXLDECC0_N2_1 VDD
+ pch l=0.06U
+ w=0.41U
M7783 VDD ZZ XLCTRL_XXLDECC0_N2_0 VDD
+ pch l=0.06U
+ w=0.41U
M7784 VDD ZZ XLCTRL_XXLDECA0_N2_0 VDD
+ pch l=0.06U
+ w=0.41U
M7785 VDD ZZ XLCTRL_XXLDECA0_N2_1 VDD
+ pch l=0.06U
+ w=0.41U
M7786 VDD ZZ XLCTRL_XXLDECA0_N2_2 VDD
+ pch l=0.06U
+ w=0.41U
M7787 VDD ZZ XLCTRL_XXLDECA0_N2_3 VDD
+ pch l=0.06U
+ w=0.41U
M7788 VDD ZZ XLCTRL_XRWDEC_WRTLC VDD
+ pch l=0.06U
+ w=0.41U
M7789 VDD B_WRT XLCTRL_XRWDEC_WRTLC VDD
+ pch l=0.06U
+ w=0.615U
M7790 VDD B_WRT XLCTRL_XRWDEC_WRTLC VDD
+ pch l=0.06U
+ w=0.615U
M7791 VDD XLCTRL_XRWDEC_WRTLC WRTL VDD
+ pch_hvt l=0.06U
+ w=3.335U
M7792 VDD XLCTRL_XRWDEC_WRTLC WRTL
+ VDD pch_hvt l=0.06U
+ w=3.335U
M7793 VDD XLCTRL_XRWDEC_WRTLC WRTL
+ VDD pch_hvt l=0.06U
+ w=3.335U
M7794 VDD XLCTRL_XXLDECC0_N2_3 XLC_3
+ VDD pch_hvt l=0.06U
+ w=3.335U
M7795 VDD ZZ XLCTRL_XXLDECC0_N2_3 VDD
+ pch l=0.06U
+	 w=0.41U
M7796 VDD B_XC_3 XLCTRL_XXLDECC0_N2_3 VDD
+ pch l=0.06U
+ w=0.615U
M7797 XLA_0 XLCTRL_XXLDECA0_N2_3 VSS
+ VSS nch_hvt l=0.06U
+ w=1.11U
M7798 XLA_0 XLCTRL_XXLDECA0_N2_3 VSS
+ VSS nch_hvt l=0.06U
+ w=1.11U
M7799 XLA_0 XLCTRL_XXLDECA0_N2_3 VSS
+ VSS nch_hvt l=0.06U
+ w=1.11U
M7800 XLA_7 XLCTRL_XXLDECA1_N2_0 VSS
+ VSS nch_hvt l=0.06U
+ w=1.11U
M7801 XLA_7 XLCTRL_XXLDECA1_N2_0 VSS
+ VSS nch_hvt l=0.06U
+ w=1.11U
M7802 XLA_7 XLCTRL_XXLDECA1_N2_0 VSS
+ VSS nch_hvt l=0.06U
+ w=1.11U
M7803 XLB_0 XLCTRL_XXLDECB_N2_0 VSS
+ VSS nch_hvt l=0.06U
+ w=1.11U
M7804 XLB_0 XLCTRL_XXLDECB_N2_0 VSS
+ VSS nch_hvt l=0.06U
+ w=1.11U
M7805 XLB_0 XLCTRL_XXLDECB_N2_0 VSS
+ VSS nch_hvt l=0.06U
+ w=1.11U
M7806 YSEL_7 XLCTRL_XYLDEC1_N2_3 VSS
+ VSS nch_hvt l=0.06U
+ w=1.11U
M7807 YSEL_7 XLCTRL_XYLDEC1_N2_3 VSS
+ VSS nch_hvt l=0.06U
+ w=1.11U
M7808 YSEL_7 XLCTRL_XYLDEC1_N2_3 VSS
+ VSS nch_hvt l=0.06U
+ w=1.11U
M7809 XLC_0 XLCTRL_XXLDECC0_N2_0 VSS
+ VSS nch_hvt l=0.06U
+ w=1.11U
M7810 XLC_7 XLCTRL_XXLDECC1_N2_3 VSS
+ VSS nch_hvt l=0.06U
+ w=1.11U
M7811 YSEL_0 XLCTRL_XYLDEC0_N2_0 VSS
+ VSS nch_hvt l=0.06U
+ w=1.11U
M7812 YSEL_4 XLCTRL_XYLDEC1_N2_0 VSS
+ VSS nch_hvt l=0.06U
+	 w=1.11U
M7813 YSEL_4 XLCTRL_XYLDEC1_N2_0 VSS
+ VSS nch_hvt l=0.06U
+ w=1.11U
M7814 YSEL_4 XLCTRL_XYLDEC1_N2_0 VSS
+ VSS nch_hvt l=0.06U
+ w=1.11U
M7815 XLA_6 XLCTRL_XXLDECA0_N2_0 VSS
+ VSS nch_hvt l=0.06U
+	 w=1.11U
M7816 XLA_6 XLCTRL_XXLDECA0_N2_0 VSS
+ VSS nch_hvt l=0.06U
+ w=1.11U
M7817 XLA_6 XLCTRL_XXLDECA0_N2_0 VSS
+ VSS nch_hvt l=0.06U
+ w=1.11U
M7818 XLA_1 XLCTRL_XXLDECA1_N2_3 VSS
+ VSS nch_hvt l=0.06U
+	 w=1.11U
M7819 XLA_1 XLCTRL_XXLDECA1_N2_3 VSS
+ VSS nch_hvt l=0.06U
+ w=1.11U
M7820 XLA_1 XLCTRL_XXLDECA1_N2_3 VSS
+ VSS nch_hvt l=0.06U
+ w=1.11U
M7821 XLB_3 XLCTRL_XXLDECB_N2_3 VSS
+ VSS nch_hvt l=0.06U
+	 w=1.11U
M7822 XLB_3 XLCTRL_XXLDECB_N2_3 VSS
+ VSS nch_hvt l=0.06U
+ w=1.11U
M7823 XLB_3 XLCTRL_XXLDECB_N2_3 VSS
+ VSS nch_hvt l=0.06U
+ w=1.11U
M7824 SMPRS_1 XLCTRL_XSMPD_Z21_1 VSS VSS
+ nch_hvt l=0.06U
+ w=1.25U
M7825 SMPRS_1 XLCTRL_XSMPD_Z21_1 VSS
+ VSS nch_hvt l=0.06U
+ w=1.25U
M7826 SMPRS_0 XLCTRL_XSMPD_Z21_0 VSS VSS
+ nch_hvt l=0.06U
+ w=1.25U
M7827 SMPRS_0 XLCTRL_XSMPD_Z21_0 VSS
+ VSS nch_hvt l=0.06U
+ w=1.25U
M7828 SMPRS_0 XLCTRL_XSMPD_Z21_0 VSS
+ VSS nch_hvt l=0.06U
+ w=1.25U
M7829 SMPRS_0 XLCTRL_XSMPD_Z21_0 VSS
+ VSS nch_hvt l=0.06U
+ w=1.25U
M7830 XLC_0 XLCTRL_XXLDECC0_N2_0 VSS
+ VSS nch_hvt l=0.06U
+ w=1.11U
M7831 XLC_0 XLCTRL_XXLDECC0_N2_0 VSS
+ VSS nch_hvt l=0.06U
+ w=1.11U
M7832 XLC_7 XLCTRL_XXLDECC1_N2_3 VSS
+ VSS nch_hvt l=0.06U
+ w=1.11U
M7833 XLC_7 XLCTRL_XXLDECC1_N2_3 VSS
+ VSS nch_hvt l=0.06U
+ w=1.11U
M7834 YSEL_0 XLCTRL_XYLDEC0_N2_0 VSS
+ VSS nch_hvt l=0.06U
+	 w=1.11U
M7835 YSEL_0 XLCTRL_XYLDEC0_N2_0 VSS
+ VSS nch_hvt l=0.06U
+ w=1.11U
M7836 YSEL_3 XLCTRL_XYLDEC0_N2_3 VSS
+ VSS nch_hvt l=0.06U
+	 w=1.11U
M7837 YSEL_3 XLCTRL_XYLDEC0_N2_3 VSS
+ VSS nch_hvt l=0.06U
+ w=1.11U
M7838 YSEL_3 XLCTRL_XYLDEC0_N2_3 VSS
+ VSS nch_hvt l=0.06U
+ w=1.11U
M7839 RDL XLCTRL_XRWDEC_Z2 VSS VSS
+ nch_hvt l=0.06U
+ w=1.11U
M7840 RDL XLCTRL_XRWDEC_Z2 VSS
+ VSS nch_hvt l=0.06U
+ w=1.11U
M7841 XLC_4 XLCTRL_XXLDECC1_N2_0 VSS
+ VSS nch_hvt l=0.06U
+ w=1.11U
M7842 XLC_4 XLCTRL_XXLDECC1_N2_0 VSS
+ VSS nch_hvt l=0.06U
+ w=1.11U
M7843 XLC_4 XLCTRL_XXLDECC1_N2_0 VSS
+ VSS nch_hvt l=0.06U
+ w=1.11U
M7844 WRTL XLCTRL_XRWDEC_WRTLC VSS VSS
+ nch_hvt l=0.06U
+ w=1.11U
M7845 WRTL XLCTRL_XRWDEC_WRTLC VSS
+ VSS nch_hvt l=0.06U
+ w=1.11U
M7846 XLC_3 XLCTRL_XXLDECC0_N2_3 VSS
+ VSS nch_hvt l=0.06U
+ w=1.11U
M7847 XLC_3 XLCTRL_XXLDECC0_N2_3 VSS
+ VSS nch_hvt l=0.06U
+ w=1.11U
M7848 XLC_3 XLCTRL_XXLDECC0_N2_3 VSS
+ VSS nch_hvt l=0.06U
+ w=1.11U
M7849 SMPRS_2 XLCTRL_XSMPD_Z21_2 VSS VSS
+ nch_hvt l=0.06U
+ w=1.25U
M7850 SMPRS_2 XLCTRL_XSMPD_Z21_2 VSS
+ VSS nch_hvt l=0.06U
+ w=1.25U
M7851 SMPRS_2 XLCTRL_XSMPD_Z21_2 VSS
+ VSS nch_hvt l=0.06U
+ w=1.25U
M7852 SMPRS_2 XLCTRL_XSMPD_Z21_2 VSS
+ VSS nch_hvt l=0.06U
+ w=1.25U
M7853 SMPRS_3 XLCTRL_XSMPD_Z21_3 VSS VSS
+ nch_hvt l=0.06U
+ w=1.25U
M7854 SMPRS_1 XLCTRL_XSMPD_Z21_1 VSS
+ VSS nch_hvt l=0.06U
+ w=1.25U
M7855 SMPRS_1 XLCTRL_XSMPD_Z21_1 VSS
+ VSS nch_hvt l=0.06U
+	 w=1.25U
M7856 RDL XLCTRL_XRWDEC_Z2 VSS
+ VSS nch_hvt l=0.06U
+ w=1.11U
M7857 WRTL XLCTRL_XRWDEC_WRTLC VSS
+ VSS nch_hvt l=0.06U
+ w=1.11U
M7858 SMPRS_3 XLCTRL_XSMPD_Z21_3 VSS
+ VSS nch_hvt l=0.06U
+ w=1.25U
M7859 SMPRS_3 XLCTRL_XSMPD_Z21_3 VSS
+ VSS nch_hvt l=0.06U
+ w=1.25U
M7860 SMPRS_3 XLCTRL_XSMPD_Z21_3 VSS
+ VSS nch_hvt l=0.06U
+ w=1.25U
M7861 XLCTRL_XXLDECA0_N2_2 B_XA_2
+ XLCTRL_XXLDECA0_N3 VSS nch l=0.06U
+ w=0.81U
M7862 XLCTRL_XXLDECA1_N2_1 B_XA_5
+ XLCTRL_XXLDECA1_N3 VSS nch l=0.06U
+ w=0.81U
M7863 XLCTRL_XXLDECB_N2_1 B_XB_1
+ XLCTRL_XXLDECB_N3 VSS nch l=0.06U
+ w=0.81U
M7864 XLCTRL_XXLDECA0_N3 ZZ VSS VSS
+ nch l=0.06U
+	 w=0.6U
M7865 XLCTRL_XXLDECA0_N2_3 B_XA_0
+ XLCTRL_XXLDECA0_N3 VSS nch l=0.06U
+ w=0.81U
M7866 XLCTRL_XXLDECA0_N2_3 B_XA_0
+ XLCTRL_XXLDECA0_N3 VSS nch l=0.06U
+ w=0.81U
M7867 XLCTRL_XXLDECA0_N2_2 B_XA_2
+ XLCTRL_XXLDECA0_N3 VSS nch l=0.06U
+ w=0.81U
M7868 XLCTRL_XXLDECA1_N3 ZZ VSS VSS
+ nch l=0.06U
+	 w=0.6U
M7869 XLCTRL_XXLDECA1_N2_0 B_XA_7
+ XLCTRL_XXLDECA1_N3 VSS nch l=0.06U
+ w=0.81U
M7870 XLCTRL_XXLDECA1_N2_0 B_XA_7
+ XLCTRL_XXLDECA1_N3 VSS nch l=0.06U
+ w=0.81U
M7871 XLCTRL_XXLDECA1_N2_1 B_XA_5
+ XLCTRL_XXLDECA1_N3 VSS nch l=0.06U
+ w=0.81U
M7872 XLCTRL_XXLDECB_N3 ZZ VSS VSS
+ nch l=0.06U
+	 w=0.6U
M7873 XLCTRL_XXLDECB_N2_0 B_XB_0
+ XLCTRL_XXLDECB_N3 VSS nch l=0.06U
+ w=0.81U
M7874 XLCTRL_XXLDECB_N2_0 B_XB_0
+ XLCTRL_XXLDECB_N3 VSS nch l=0.06U
+ w=0.81U
M7875 XLCTRL_XXLDECB_N2_1 B_XB_1
+ XLCTRL_XXLDECB_N3 VSS nch l=0.06U
+ w=0.81U
M7876 XLCTRL_XSMPD_Z6 XLCTRL_XSMPD_Z5 VSS VSS
+ nch l=0.08U
+ w=0.21U
M7877 XLCTRL_XYLDEC1_N2_2 B_Y_6
+ XLCTRL_XYLDEC1_N3 VSS nch l=0.06U
+ w=0.81U
M7878 XLCTRL_XSMPD_Z10 XLCTRL_XSMPD_Z1
+ XLCTRL_XSMPD_XI55_NET17 VSS nch l=0.08U
+ w=0.41U
M7879 XLCTRL_XSMPD_XI55_NET17 XLCTRL_XSMPD_Z9
+ XLCTRL_XSMPD_XI55_NET14 VSS nch l=0.08U
+ w=0.41U
M7880 XLCTRL_XSMPD_Z11 XLCTRL_XSMPD_Z10
+ VSS VSS nch l=0.06U
+ w=0.41U
M7881 VSS XLCTRL_XSMPD_Z7
+ XLCTRL_XSMPD_XI55_NET14 VSS nch l=0.08U
+ w=0.41U
M7882 XLCTRL_XSMPD_Z13 XLCTRL_XSMPD_Z12
+ VSS VSS nch l=0.06U
+ w=0.41U
M7883 XLCTRL_XSMPD_Z12 XLCTRL_XSMPD_Z11
+ VSS VSS nch l=0.12U
+ w=0.41U
M7884 XLCTRL_XSMPD_Z9 B_VS_0 XLCTRL_XSMPD_XI30_NET9
+ VSS nch l=0.06U
+	 w=0.41U
M7885 XLCTRL_XSMPD_XI54_NET9 XLCTRL_XSMPD_Z7 VSS
+ VSS nch l=0.08U
+	 w=0.41U
M7886 XLCTRL_XSMPD_Z8 XLCTRL_XSMPD_Z1
+ XLCTRL_XSMPD_XI54_NET9 VSS nch l=0.08U
+ w=0.41U
M7887 VSS XLCTRL_XSMPD_Z8 XLCTRL_XSMPD_XI30_NET9
+ VSS nch l=0.06U
+	 w=0.41U
M7888 XLCTRL_XSMPD_Z7 XLCTRL_XSMPD_Z6 VSS VSS
+ nch l=0.06U
+	 w=0.21U
M7889 XLCTRL_XYLDEC1_N3 ZZ VSS VSS
+ nch l=0.06U
+	 w=0.6U
M7890 XLCTRL_XYLDEC1_N2_3 B_Y_7
+ XLCTRL_XYLDEC1_N3 VSS nch l=0.06U
+ w=0.81U
M7891 XLCTRL_XYLDEC1_N2_3 B_Y_7
+ XLCTRL_XYLDEC1_N3 VSS nch l=0.06U
+ w=0.81U
M7892 XLCTRL_XYLDEC1_N2_2 B_Y_6
+ XLCTRL_XYLDEC1_N3 VSS nch l=0.06U
+ w=0.81U
M7893 XLCTRL_XXLDECA0_N3 ZZ VSS VSS
+ nch l=0.06U
+	 w=0.6U
M7894 XLCTRL_XXLDECA0_N2_0 B_XA_6
+ XLCTRL_XXLDECA0_N3 VSS nch l=0.06U
+ w=0.81U
M7895 XLCTRL_XXLDECA0_N2_0 B_XA_6
+ XLCTRL_XXLDECA0_N3 VSS nch l=0.06U
+ w=0.81U
M7896 XLCTRL_XXLDECA0_N3 ZZ VSS VSS
+ nch l=0.06U
+	 w=0.6U
M7897 XLCTRL_XXLDECA0_N2_1 B_XA_4
+ XLCTRL_XXLDECA0_N3 VSS nch l=0.06U
+ w=0.81U
M7898 XLCTRL_XXLDECA0_N2_1 B_XA_4
+ XLCTRL_XXLDECA0_N3 VSS nch l=0.06U
+ w=0.81U
M7899 XLCTRL_XXLDECA0_N3 ZZ VSS VSS
+ nch l=0.06U
+	 w=0.6U
M7900 XLCTRL_XXLDECA1_N3 ZZ VSS VSS
+ nch l=0.06U
+	 w=0.6U
M7901 XLCTRL_XXLDECA1_N2_3 B_XA_1
+ XLCTRL_XXLDECA1_N3 VSS nch l=0.06U
+ w=0.81U
M7902 XLCTRL_XXLDECA1_N2_3 B_XA_1
+ XLCTRL_XXLDECA1_N3 VSS nch l=0.06U
+ w=0.81U
M7903 XLCTRL_XXLDECA1_N3 ZZ VSS VSS
+ nch l=0.06U
+	 w=0.6U
M7904 XLCTRL_XXLDECA1_N2_2 B_XA_3
+ XLCTRL_XXLDECA1_N3 VSS nch l=0.06U
+ w=0.81U
M7905 XLCTRL_XXLDECA1_N2_2 B_XA_3
+ XLCTRL_XXLDECA1_N3 VSS nch l=0.06U
+ w=0.81U
M7906 XLCTRL_XXLDECA1_N3 ZZ VSS VSS
+ nch l=0.06U
+	 w=0.6U
M7907 XLCTRL_XXLDECB_N3 ZZ VSS VSS
+ nch l=0.06U
+	 w=0.6U
M7908 XLCTRL_XXLDECB_N2_3 B_XB_3
+ XLCTRL_XXLDECB_N3 VSS nch l=0.06U
+ w=0.81U
M7909 XLCTRL_XXLDECB_N2_3 B_XB_3
+ XLCTRL_XXLDECB_N3 VSS nch l=0.06U
+ w=0.81U
M7910 XLCTRL_XXLDECB_N3 ZZ VSS VSS
+ nch l=0.06U
+	 w=0.6U
M7911 XLCTRL_XXLDECB_N2_2 B_XB_2
+ XLCTRL_XXLDECB_N3 VSS nch l=0.06U
+ w=0.81U
M7912 XLCTRL_XXLDECB_N2_2 B_XB_2
+ XLCTRL_XXLDECB_N3 VSS nch l=0.06U
+ w=0.81U
M7913 XLCTRL_XXLDECB_N3 ZZ VSS VSS
+ nch l=0.06U
+	 w=0.6U
M7914 XLCTRL_XSMPD_Z16 XLCTRL_XSMPD_Z15B
+ VSS VSS nch l=0.14U
+ w=0.41U
M7915 XLCTRL_XSMPD_Z14B XLCTRL_XSMPD_Z15
+ VSS VSS nch l=0.1U
+ w=0.41U
M7916 XLCTRL_XSMPD_Z15B XLCTRL_XSMPD_Z14B
+ VSS VSS nch l=0.06U
+ w=0.41U
M7917 XLCTRL_XSMPD_Z14 XLCTRL_XSMPD_Z13
+ VSS VSS nch l=0.1U
+ w=0.41U
M7918 XLCTRL_XSMPD_Z15 XLCTRL_XSMPD_Z14
+ VSS VSS nch l=0.06U
+ w=0.41U
M7919 XLCTRL_XSMPD_Z5 B_VS_1 XLCTRL_XSMPD_XI32_NET9
+ VSS nch l=0.06U
+	 w=0.41U
M7920 XLCTRL_XSMPD_XI32_NET9 XLCTRL_XSMPD_Z4 VSS
+ VSS nch l=0.06U
+	 w=0.41U
M7921 XLCTRL_XSMPD_Z4 XLCTRL_XSMPD_Z1 VSS VSS
+ nch l=0.08U
+ w=0.21U
M7922 VSS XLCTRL_XSMPD_Z16
+ XLCTRL_XSMPD_XND3_NET9 VSS nch l=0.06U
+ w=0.82U
M7923 XLCTRL_XSMPD_XND3_NET9 XLCTRL_XSMPD_Z1
+ XLCTRL_XSMPD_Z2 VSS nch l=0.06U
+ w=0.82U
M7924 XLCTRL_XYLDEC1_N3 ZZ VSS VSS
+ nch l=0.06U
+	 w=0.6U
M7925 XLCTRL_XYLDEC1_N2_0 B_Y_4
+ XLCTRL_XYLDEC1_N3 VSS nch l=0.06U
+ w=0.81U
M7926 XLCTRL_XYLDEC1_N2_0 B_Y_4
+ XLCTRL_XYLDEC1_N3 VSS nch l=0.06U
+ w=0.81U
M7927 XLCTRL_XYLDEC1_N3 ZZ VSS VSS
+ nch l=0.06U
+	 w=0.6U
M7928 XLCTRL_XYLDEC1_N2_1 B_Y_5
+ XLCTRL_XYLDEC1_N3 VSS nch l=0.06U
+ w=0.81U
M7929 XLCTRL_XYLDEC1_N2_1 B_Y_5
+ XLCTRL_XYLDEC1_N3 VSS nch l=0.06U
+ w=0.81U
M7930 XLCTRL_XYLDEC1_N3 ZZ VSS VSS
+ nch l=0.06U
+	 w=0.6U
M7931 XLCTRL_XXLDECC0_N3 ZZ VSS VSS
+ nch l=0.06U
+	 w=0.6U
M7932 XLCTRL_XXLDECC0_N2_0 B_XC_0
+ XLCTRL_XXLDECC0_N3 VSS nch l=0.06U
+ w=0.81U
M7933 XLCTRL_XXLDECC0_N2_0 B_XC_0
+ XLCTRL_XXLDECC0_N3 VSS nch l=0.06U
+ w=0.81U
M7934 XLCTRL_XXLDECC0_N3 ZZ VSS VSS
+ nch l=0.06U
+	 w=0.6U
M7935 XLCTRL_XXLDECC0_N2_1 B_XC_1
+ XLCTRL_XXLDECC0_N3 VSS nch l=0.06U
+ w=0.81U
M7936 XLCTRL_XXLDECC0_N2_1 B_XC_1
+ XLCTRL_XXLDECC0_N3 VSS nch l=0.06U
+ w=0.81U
M7937 XLCTRL_XXLDECC1_N3 ZZ VSS VSS
+ nch l=0.06U
+	 w=0.6U
M7938 XLCTRL_XXLDECC1_N2_3 B_XC_7
+ XLCTRL_XXLDECC1_N3 VSS nch l=0.06U
+ w=0.81U
M7939 XLCTRL_XXLDECC1_N2_3 B_XC_7
+ XLCTRL_XXLDECC1_N3 VSS nch l=0.06U
+ w=0.81U
M7940 XLCTRL_XXLDECC1_N3 ZZ VSS VSS
+ nch l=0.06U
+	 w=0.6U
M7941 XLCTRL_XXLDECC1_N2_2 B_XC_6
+ XLCTRL_XXLDECC1_N3 VSS nch l=0.06U
+ w=0.81U
M7942 XLCTRL_XXLDECC1_N2_2 B_XC_6
+ XLCTRL_XXLDECC1_N3 VSS nch l=0.06U
+ w=0.81U
M7943 XLCTRL_XYLDEC0_N3 ZZ VSS VSS
+ nch l=0.06U
+	 w=0.6U
M7944 XLCTRL_XYLDEC0_N2_0 B_Y_0
+ XLCTRL_XYLDEC0_N3 VSS nch l=0.06U
+ w=0.81U
M7945 XLCTRL_XYLDEC0_N2_0 B_Y_0
+ XLCTRL_XYLDEC0_N3 VSS nch l=0.06U
+ w=0.81U
M7946 XLCTRL_XYLDEC0_N3 ZZ VSS VSS
+ nch l=0.06U
+	 w=0.6U
M7947 XLCTRL_XYLDEC0_N2_1 B_Y_1
+ XLCTRL_XYLDEC0_N3 VSS nch l=0.06U
+ w=0.81U
M7948 XLCTRL_XYLDEC0_N2_1 B_Y_1
+ XLCTRL_XYLDEC0_N3 VSS nch l=0.06U
+ w=0.81U
M7949 XLCTRL_XSMPD_XND0_NET9 ZZ VSS VSS
+ nch l=0.06U
+	 w=0.82U
M7950 XLCTRL_XSMPD_XND0_NET9 B_RD
+ XLCTRL_XSMPD_Z1 VSS nch l=0.06U
+ w=0.82U
M7951 XLCTRL_XSMPD_Z17_3 B_RD
+ XLCTRL_XSMPD_N18 VSS nch l=0.06U
+ w=0.41U
M7952 XLCTRL_XSMPD_Z17_3 ZZ VSS VSS
+ nch l=0.06U
+	 w=0.41U
M7953 XLCTRL_XSMPD_Z20_0 B_GCDEC_0
+ XLCTRL_XSMPD_N18 VSS nch l=0.06U
+ w=0.82U
M7954 VSS ZZ XLCTRL_XRWDEC_Z1 VSS
+ nch l=0.06U
+ w=0.6U
M7955 XLCTRL_XXLDECC0_N3 ZZ VSS VSS
+ nch l=0.06U
+	 w=0.6U
M7956 XLCTRL_XXLDECC0_N2_3 B_XC_3
+ XLCTRL_XXLDECC0_N3 VSS nch l=0.06U
+ w=0.81U
M7957 XLCTRL_XXLDECC0_N2_3 B_XC_3
+ XLCTRL_XXLDECC0_N3 VSS nch l=0.06U
+ w=0.81U
M7958 XLCTRL_XRWDEC_Z2 XLCTRL_XRWDEC_RDLC
+ VSS VSS nch l=0.06U
+ w=0.6U
M7959 XLCTRL_XXLDECC1_N3 ZZ VSS VSS
+ nch l=0.06U
+ w=0.6U
M7960 XLCTRL_XXLDECC1_N2_0 B_XC_4
+ XLCTRL_XXLDECC1_N3 VSS nch l=0.06U
+ w=0.81U
M7961 XLCTRL_XXLDECC1_N2_0 B_XC_4
+ XLCTRL_XXLDECC1_N3 VSS nch l=0.06U
+ w=0.81U
M7962 XLCTRL_XYLDEC0_N3 ZZ VSS VSS
+ nch l=0.06U
+	 w=0.6U
M7963 XLCTRL_XYLDEC0_N2_3 B_Y_3
+ XLCTRL_XYLDEC0_N3 VSS nch l=0.06U
+ w=0.81U
M7964 XLCTRL_XYLDEC0_N2_3 B_Y_3
+ XLCTRL_XYLDEC0_N3 VSS nch l=0.06U
+ w=0.81U
M7965 XLCTRL_XXLDECC0_N3 ZZ VSS VSS
+ nch l=0.06U
+	 w=0.6U
M7966 XLCTRL_XXLDECC0_N2_2 B_XC_2
+ XLCTRL_XXLDECC0_N3 VSS nch l=0.06U
+ w=0.81U
M7967 XLCTRL_XXLDECC0_N2_2 B_XC_2
+ XLCTRL_XXLDECC0_N3 VSS nch l=0.06U
+ w=0.81U
M7968 XLCTRL_XXLDECC1_N3 ZZ VSS VSS
+ nch l=0.06U
+	 w=0.6U
M7969 XLCTRL_XXLDECC1_N2_1 B_XC_5
+ XLCTRL_XXLDECC1_N3 VSS nch l=0.06U
+ w=0.81U
M7970 XLCTRL_XXLDECC1_N2_1 B_XC_5
+ XLCTRL_XXLDECC1_N3 VSS nch l=0.06U
+ w=0.81U
M7971 XLCTRL_XYLDEC0_N3 ZZ VSS VSS
+ nch l=0.06U
+	 w=0.6U
M7972 XLCTRL_XYLDEC0_N2_2 B_Y_2
+ XLCTRL_XYLDEC0_N3 VSS nch l=0.06U
+ w=0.81U
M7973 XLCTRL_XYLDEC0_N2_2 B_Y_2
+ XLCTRL_XYLDEC0_N3 VSS nch l=0.06U
+ w=0.81U
M7974 XLCTRL_XSMPD_Z17_2 B_RD
+ XLCTRL_XSMPD_N18 VSS nch l=0.06U
+ w=0.41U
M7975 XLCTRL_XSMPD_Z17_2 ZZ VSS VSS
+ nch l=0.06U
+	 w=0.41U
M7976 XLCTRL_XSMPD_Z20_2 B_GCDEC_2
+ XLCTRL_XSMPD_N18 VSS nch l=0.06U
+ w=0.82U
M7977 XLCTRL_XSMPD_N18 B_RD
+ XLCTRL_XSMPD_Z17_1 VSS nch l=0.06U
+ w=0.41U
M7978 VSS ZZ XLCTRL_XSMPD_Z17_1 VSS
+ nch l=0.06U
+	 w=0.41U
M7979 XLCTRL_XSMPD_Z20_1 B_GCDEC_1
+ XLCTRL_XSMPD_N18 VSS nch l=0.06U
+ w=0.82U
M7980 XLCTRL_XSMPD_Z3 XLCTRL_XSMPD_Z2 VSS VSS
+ nch l=0.06U
+ w=0.41U
M7981 XLCTRL_XSMPD_Z3 XLCTRL_XSMPD_Z2 VSS
+ VSS nch l=0.06U
+	 w=0.41U
M7982 XLCTRL_XRWDEC_WRTLC B_WRT
+ XLCTRL_XRWDEC_Z1 VSS nch l=0.06U
+ w=0.81U
M7983 XLCTRL_XRWDEC_WRTLC B_WRT
+ XLCTRL_XRWDEC_Z1 VSS nch l=0.06U
+ w=0.81U
M7984 VSS ZZ XLCTRL_XRWDEC_Z1 VSS
+ nch l=0.06U
+ w=1.4U
M7985 XLCTRL_XRWDEC_Z3 ZZ VSS VSS
+ nch l=0.06U
+ w=0.82U
M7986 XLCTRL_XRWDEC_RDLC B_RD
+ XLCTRL_XRWDEC_Z3 VSS nch l=0.06U
+ w=0.82U
M7987 XLCTRL_XRWDEC_Z2
+ XLCTRL_XRWDEC_RDLC VSS VSS nch
+ l=0.06U
+ w=0.6U
M7988 SOE XLCTRL_XSMPD_Z3 VSS VSS nch
+ l=0.06U
+ w=1.875U
M7989 SOE XLCTRL_XSMPD_Z3 VSS VSS
+ nch l=0.06U
+	 w=1.875U
M7990 SOE XLCTRL_XSMPD_Z3 VSS VSS
+ nch l=0.06U
+	 w=1.25U
M7991 XLCTRL_XSMPD_Z20_3 B_GCDEC_3
+ XLCTRL_XSMPD_N18 VSS nch l=0.06U
+ w=0.82U
M7992 VSS ZZ XLCTRL_XSMPD_Z17_0 VSS
+ nch l=0.06U
+	 w=0.41U
M7993 XLCTRL_XSMPD_N18 B_RD
+ XLCTRL_XSMPD_Z17_0 VSS nch l=0.06U
+ w=0.41U
.ENDS
* MC4X4G
.SUBCKT SDL400W20S_NMC4X4G A_WL_3 A_WL_2 A_WL_1 A_WL_0 A_WLS_3 A_WLS_2
+	 A_WLS_1 A_WLS_0 B_WL_3 B_WL_2 B_WL_1 B_WL_0 B_WLS_3 B_WLS_2
+	 B_WLS_1 B_WLS_0 NWELL SUB A_BL_3 A_BL_2 A_BL_1 A_BL_0 A_BLB_3
+	 A_BLB_2 A_BLB_1 A_BLB_0 B_BL_3 B_BL_2 B_BL_1 B_BL_0 B_BLB_3
+	 B_BLB_2 B_BLB_1 B_BLB_0 GFA_3 GFA_2 GFA_1 GFA_0 GFB_3 GFB_2
+	 GFB_1 GFB_0
M7994 XMC4X4_XMC0_0_BLB_IN XMC4X4_XMC0_0_BL_IN
+ VSS SUB nchpd_hvtdpsr l=0.065U
+ w=0.315U
M7995 XMC4X4_XMC0_1_BLB_IN A_WL_1 A_BLB_0 SUB
+ nchpg_hvtdpsr l=0.08U
+ w=0.105U
M7996 A_BL_0 A_WL_1 XMC4X4_XMC0_1_BL_IN SUB
+ nchpg_hvtdpsr l=0.08U
+ w=0.105U
M7997 A_BL_0 A_WL_2 XMC4X4_XMC0_2_BL_IN SUB
+ nchpg_hvtdpsr l=0.08U
+ w=0.105U
M7998 XMC4X4_XMC0_2_BLB_IN A_WL_2 A_BLB_0 SUB
+ nchpg_hvtdpsr l=0.08U
+ w=0.105U
M7999 XMC4X4_XMC0_3_BLB_IN A_WL_3 A_BLB_0 SUB
+ nchpg_hvtdpsr l=0.08U
+ w=0.105U
M8000 A_BL_0 A_WL_3 XMC4X4_XMC0_3_BL_IN SUB
+ nchpg_hvtdpsr l=0.08U
+ w=0.105U
M8001 A_BL_0 A_WL_0 XMC4X4_XMC0_0_BL_IN SUB
+ nchpg_hvtdpsr l=0.08U
+ w=0.105U
M8002 XMC4X4_XMC0_0_BLB_IN A_WL_0 A_BLB_0 SUB
+ nchpg_hvtdpsr l=0.08U
+ w=0.105U
M8003 XMC4X4_XMC0_3_BLB_IN XMC4X4_XMC0_3_BL_IN
+ VSS SUB nchpd_hvtdpsr l=0.065U
+ w=0.315U
M8004 XMC4X4_XMC0_1_BLB_IN XMC4X4_XMC0_1_BL_IN
+ VSS SUB nchpd_hvtdpsr l=0.065U
+ w=0.315U
M8005 XMC4X4_XMC0_2_BLB_IN XMC4X4_XMC0_2_BL_IN
+ VSS SUB nchpd_hvtdpsr l=0.065U
+ w=0.315U
M8006 VDD XMC4X4_XMC0_0_BL_IN
+ XMC4X4_XMC0_0_BLB_IN NWELL pchpu_hvtdpsr
+ l=0.07U w=0.09U
M8007 VDD XMC4X4_XMC0_3_BL_IN
+ XMC4X4_XMC0_3_BLB_IN NWELL pchpu_hvtdpsr
+ l=0.07U w=0.09U
M8008 XMC4X4_XMC0_1_BL_IN XMC4X4_XMC0_1_BLB_IN
+ VDD NWELL pchpu_hvtdpsr l=0.07U
+ w=0.09U
M8009 XMC4X4_XMC0_0_BL_IN XMC4X4_XMC0_0_BLB_IN
+ VDD NWELL pchpu_hvtdpsr l=0.07U
+ w=0.09U
M8010 VDD XMC4X4_XMC0_1_BL_IN
+ XMC4X4_XMC0_1_BLB_IN NWELL pchpu_hvtdpsr
+ l=0.07U w=0.09U
M8011 XMC4X4_XMC0_2_BL_IN XMC4X4_XMC0_2_BLB_IN
+ VDD NWELL pchpu_hvtdpsr l=0.07U
+ w=0.09U
M8012 VDD XMC4X4_XMC0_2_BL_IN
+ XMC4X4_XMC0_2_BLB_IN NWELL pchpu_hvtdpsr
+ l=0.07U w=0.09U
M8013 XMC4X4_XMC0_3_BL_IN XMC4X4_XMC0_3_BLB_IN
+ VDD NWELL pchpu_hvtdpsr l=0.07U
+ w=0.09U
M8014 B_BL_1 B_WL_0 XMC4X4_XMC1_0_BL_IN SUB
+ nchpg_hvtdpsr l=0.08U
+ w=0.105U
M8015 B_BL_0 B_WL_0 XMC4X4_XMC0_0_BL_IN SUB
+ nchpg_hvtdpsr l=0.08U
+ w=0.105U
M8016 XMC4X4_XMC0_0_BLB_IN B_WL_0 B_BLB_0 SUB
+ nchpg_hvtdpsr l=0.08U
+ w=0.105U
M8017 XMC4X4_XMC1_0_BLB_IN B_WL_0 B_BLB_1 SUB
+ nchpg_hvtdpsr l=0.08U
+ w=0.105U
M8018 B_BL_1 B_WL_3 XMC4X4_XMC1_3_BL_IN SUB
+ nchpg_hvtdpsr l=0.08U
+ w=0.105U
M8019 B_BL_0 B_WL_3 XMC4X4_XMC0_3_BL_IN SUB
+ nchpg_hvtdpsr l=0.08U
+ w=0.105U
M8020 XMC4X4_XMC0_3_BLB_IN B_WL_3 B_BLB_0 SUB
+ nchpg_hvtdpsr l=0.08U
+ w=0.105U
M8021 XMC4X4_XMC1_3_BLB_IN B_WL_3 B_BLB_1 SUB
+ nchpg_hvtdpsr l=0.08U
+ w=0.105U
M8022 B_BL_1 B_WL_1 XMC4X4_XMC1_1_BL_IN SUB
+ nchpg_hvtdpsr l=0.08U
+ w=0.105U
M8023 XMC4X4_XMC1_1_BLB_IN B_WL_1 B_BLB_1 SUB
+ nchpg_hvtdpsr l=0.08U
+ w=0.105U
M8024 B_BL_0 B_WL_1 XMC4X4_XMC0_1_BL_IN SUB
+ nchpg_hvtdpsr l=0.08U
+ w=0.105U
M8025 XMC4X4_XMC0_1_BLB_IN B_WL_1 B_BLB_0 SUB
+ nchpg_hvtdpsr l=0.08U
+ w=0.105U
M8026 B_BL_1 B_WL_2 XMC4X4_XMC1_2_BL_IN SUB
+ nchpg_hvtdpsr l=0.08U
+ w=0.105U
M8027 XMC4X4_XMC1_2_BLB_IN B_WL_2 B_BLB_1 SUB
+ nchpg_hvtdpsr l=0.08U
+ w=0.105U
M8028 B_BL_0 B_WL_2 XMC4X4_XMC0_2_BL_IN SUB
+ nchpg_hvtdpsr l=0.08U
+ w=0.105U
M8029 XMC4X4_XMC0_2_BLB_IN B_WL_2 B_BLB_0 SUB
+ nchpg_hvtdpsr l=0.08U
+ w=0.105U
M8030 VSS XMC4X4_XMC0_1_BLB_IN
+ XMC4X4_XMC0_1_BL_IN SUB nchpd_hvtdpsr
+ l=0.065U w=0.315U
M8031 VSS XMC4X4_XMC1_1_BLB_IN
+ XMC4X4_XMC1_1_BL_IN SUB nchpd_hvtdpsr
+ l=0.065U w=0.315U
M8032 VSS XMC4X4_XMC0_0_BLB_IN
+ XMC4X4_XMC0_0_BL_IN SUB nchpd_hvtdpsr
+ l=0.065U w=0.315U
M8033 VSS XMC4X4_XMC1_0_BLB_IN
+ XMC4X4_XMC1_0_BL_IN SUB nchpd_hvtdpsr
+ l=0.065U w=0.315U
M8034 VSS XMC4X4_XMC0_2_BLB_IN
+ XMC4X4_XMC0_2_BL_IN SUB nchpd_hvtdpsr
+ l=0.065U w=0.315U
M8035 VSS XMC4X4_XMC1_2_BLB_IN
+ XMC4X4_XMC1_2_BL_IN SUB nchpd_hvtdpsr
+ l=0.065U w=0.315U
M8036 VSS XMC4X4_XMC0_3_BLB_IN
+ XMC4X4_XMC0_3_BL_IN SUB nchpd_hvtdpsr
+ l=0.065U w=0.315U
M8037 VSS XMC4X4_XMC1_3_BLB_IN
+ XMC4X4_XMC1_3_BL_IN SUB nchpd_hvtdpsr
+ l=0.065U w=0.315U
M8038 VDD XMC4X4_XMC1_0_BL_IN
+ XMC4X4_XMC1_0_BLB_IN NWELL pchpu_hvtdpsr
+ l=0.07U w=0.09U
M8039 VDD XMC4X4_XMC1_3_BL_IN
+ XMC4X4_XMC1_3_BLB_IN NWELL pchpu_hvtdpsr
+ l=0.07U w=0.09U
M8040 XMC4X4_XMC1_1_BL_IN XMC4X4_XMC1_1_BLB_IN
+ VDD NWELL pchpu_hvtdpsr l=0.07U
+ w=0.09U
M8041 XMC4X4_XMC1_0_BL_IN XMC4X4_XMC1_0_BLB_IN
+ VDD NWELL pchpu_hvtdpsr l=0.07U
+ w=0.09U
M8042 VDD XMC4X4_XMC1_1_BL_IN
+ XMC4X4_XMC1_1_BLB_IN NWELL pchpu_hvtdpsr
+ l=0.07U w=0.09U
M8043 XMC4X4_XMC1_2_BL_IN XMC4X4_XMC1_2_BLB_IN
+ VDD NWELL pchpu_hvtdpsr l=0.07U
+ w=0.09U
M8044 VDD XMC4X4_XMC1_2_BL_IN
+ XMC4X4_XMC1_2_BLB_IN NWELL pchpu_hvtdpsr
+ l=0.07U w=0.09U
M8045 XMC4X4_XMC1_3_BL_IN XMC4X4_XMC1_3_BLB_IN
+ VDD NWELL pchpu_hvtdpsr l=0.07U
+ w=0.09U
M8046 XMC4X4_XMC1_0_BLB_IN XMC4X4_XMC1_0_BL_IN
+ VSS SUB nchpd_hvtdpsr l=0.065U
+ w=0.315U
M8047 XMC4X4_XMC2_0_BLB_IN XMC4X4_XMC2_0_BL_IN
+ VSS SUB nchpd_hvtdpsr l=0.065U
+ w=0.315U
M8048 XMC4X4_XMC1_1_BLB_IN A_WL_1 A_BLB_1 SUB
+ nchpg_hvtdpsr l=0.08U
+ w=0.105U
M8049 XMC4X4_XMC2_1_BLB_IN A_WL_1 A_BLB_2 SUB
+ nchpg_hvtdpsr l=0.08U
+ w=0.105U
M8050 A_BL_1 A_WL_1 XMC4X4_XMC1_1_BL_IN SUB
+ nchpg_hvtdpsr l=0.08U
+ w=0.105U
M8051 A_BL_2 A_WL_1 XMC4X4_XMC2_1_BL_IN SUB
+ nchpg_hvtdpsr l=0.08U
+ w=0.105U
M8052 A_BL_1 A_WL_2 XMC4X4_XMC1_2_BL_IN SUB
+ nchpg_hvtdpsr l=0.08U
+ w=0.105U
M8053 XMC4X4_XMC1_2_BLB_IN A_WL_2 A_BLB_1 SUB
+ nchpg_hvtdpsr l=0.08U
+ w=0.105U
M8054 A_BL_2 A_WL_2 XMC4X4_XMC2_2_BL_IN SUB
+ nchpg_hvtdpsr l=0.08U
+ w=0.105U
M8055 XMC4X4_XMC2_2_BLB_IN A_WL_2 A_BLB_2 SUB
+ nchpg_hvtdpsr l=0.08U
+ w=0.105U
M8056 XMC4X4_XMC2_3_BLB_IN A_WL_3 A_BLB_2 SUB
+ nchpg_hvtdpsr l=0.08U
+ w=0.105U
M8057 A_BL_2 A_WL_3 XMC4X4_XMC2_3_BL_IN SUB
+ nchpg_hvtdpsr l=0.08U
+ w=0.105U
M8058 XMC4X4_XMC1_3_BLB_IN A_WL_3 A_BLB_1 SUB
+ nchpg_hvtdpsr l=0.08U
+ w=0.105U
M8059 A_BL_1 A_WL_3 XMC4X4_XMC1_3_BL_IN SUB
+ nchpg_hvtdpsr l=0.08U
+ w=0.105U
M8060 A_BL_2 A_WL_0 XMC4X4_XMC2_0_BL_IN SUB
+ nchpg_hvtdpsr l=0.08U
+ w=0.105U
M8061 A_BL_1 A_WL_0 XMC4X4_XMC1_0_BL_IN SUB
+ nchpg_hvtdpsr l=0.08U
+ w=0.105U
M8062 XMC4X4_XMC2_0_BLB_IN A_WL_0 A_BLB_2 SUB
+ nchpg_hvtdpsr l=0.08U
+ w=0.105U
M8063 XMC4X4_XMC1_0_BLB_IN A_WL_0 A_BLB_1 SUB
+ nchpg_hvtdpsr l=0.08U
+ w=0.105U
M8064 XMC4X4_XMC1_3_BLB_IN XMC4X4_XMC1_3_BL_IN
+ VSS SUB nchpd_hvtdpsr l=0.065U
+ w=0.315U
M8065 XMC4X4_XMC2_3_BLB_IN XMC4X4_XMC2_3_BL_IN
+ VSS SUB nchpd_hvtdpsr l=0.065U
+ w=0.315U
M8066 XMC4X4_XMC2_1_BLB_IN XMC4X4_XMC2_1_BL_IN
+ VSS SUB nchpd_hvtdpsr l=0.065U
+ w=0.315U
M8067 XMC4X4_XMC1_1_BLB_IN XMC4X4_XMC1_1_BL_IN
+ VSS SUB nchpd_hvtdpsr l=0.065U
+ w=0.315U
M8068 XMC4X4_XMC2_2_BLB_IN XMC4X4_XMC2_2_BL_IN
+ VSS SUB nchpd_hvtdpsr l=0.065U
+ w=0.315U
M8069 XMC4X4_XMC1_2_BLB_IN XMC4X4_XMC1_2_BL_IN
+ VSS SUB nchpd_hvtdpsr l=0.065U
+ w=0.315U
M8070 VDD XMC4X4_XMC2_0_BL_IN
+ XMC4X4_XMC2_0_BLB_IN NWELL pchpu_hvtdpsr
+ l=0.07U w=0.09U
M8071 VDD XMC4X4_XMC2_3_BL_IN
+ XMC4X4_XMC2_3_BLB_IN NWELL pchpu_hvtdpsr
+ l=0.07U w=0.09U
M8072 XMC4X4_XMC2_1_BL_IN XMC4X4_XMC2_1_BLB_IN
+ VDD NWELL pchpu_hvtdpsr l=0.07U
+ w=0.09U
M8073 XMC4X4_XMC2_0_BL_IN XMC4X4_XMC2_0_BLB_IN
+ VDD NWELL pchpu_hvtdpsr l=0.07U
+ w=0.09U
M8074 VDD XMC4X4_XMC2_1_BL_IN
+ XMC4X4_XMC2_1_BLB_IN NWELL pchpu_hvtdpsr
+ l=0.07U w=0.09U
M8075 XMC4X4_XMC2_2_BL_IN XMC4X4_XMC2_2_BLB_IN
+ VDD NWELL pchpu_hvtdpsr l=0.07U
+ w=0.09U
M8076 VDD XMC4X4_XMC2_2_BL_IN
+ XMC4X4_XMC2_2_BLB_IN NWELL pchpu_hvtdpsr
+ l=0.07U w=0.09U
M8077 XMC4X4_XMC2_3_BL_IN XMC4X4_XMC2_3_BLB_IN
+ VDD NWELL pchpu_hvtdpsr l=0.07U
+ w=0.09U
M8078 B_BL_3 B_WL_0 XMC4X4_XMC3_0_BL_IN SUB
+ nchpg_hvtdpsr l=0.08U
+ w=0.105U
M8079 B_BL_2 B_WL_0 XMC4X4_XMC2_0_BL_IN SUB
+ nchpg_hvtdpsr l=0.08U
+ w=0.105U
M8080 XMC4X4_XMC3_0_BLB_IN B_WL_0 B_BLB_3 SUB
+ nchpg_hvtdpsr l=0.08U
+ w=0.105U
M8081 XMC4X4_XMC2_0_BLB_IN B_WL_0 B_BLB_2 SUB
+ nchpg_hvtdpsr l=0.08U
+ w=0.105U
M8082 B_BL_3 B_WL_3 XMC4X4_XMC3_3_BL_IN SUB
+ nchpg_hvtdpsr l=0.08U
+ w=0.105U
M8083 B_BL_2 B_WL_3 XMC4X4_XMC2_3_BL_IN SUB
+ nchpg_hvtdpsr l=0.08U
+ w=0.105U
M8084 XMC4X4_XMC3_3_BLB_IN B_WL_3 B_BLB_3 SUB
+ nchpg_hvtdpsr l=0.08U
+ w=0.105U
M8085 XMC4X4_XMC2_3_BLB_IN B_WL_3 B_BLB_2 SUB
+ nchpg_hvtdpsr l=0.08U
+ w=0.105U
M8086 B_BL_3 B_WL_1 XMC4X4_XMC3_1_BL_IN SUB
+ nchpg_hvtdpsr l=0.08U
+ w=0.105U
M8087 B_BL_2 B_WL_1 XMC4X4_XMC2_1_BL_IN SUB
+ nchpg_hvtdpsr l=0.08U
+ w=0.105U
M8088 XMC4X4_XMC2_1_BLB_IN B_WL_1 B_BLB_2 SUB
+ nchpg_hvtdpsr l=0.08U
+ w=0.105U
M8089 XMC4X4_XMC3_1_BLB_IN B_WL_1 B_BLB_3 SUB
+ nchpg_hvtdpsr l=0.08U
+ w=0.105U
M8090 B_BL_3 B_WL_2 XMC4X4_XMC3_2_BL_IN SUB
+ nchpg_hvtdpsr l=0.08U
+ w=0.105U
M8091 B_BL_2 B_WL_2 XMC4X4_XMC2_2_BL_IN SUB
+ nchpg_hvtdpsr l=0.08U
+ w=0.105U
M8092 XMC4X4_XMC2_2_BLB_IN B_WL_2 B_BLB_2 SUB
+ nchpg_hvtdpsr l=0.08U
+ w=0.105U
M8093 XMC4X4_XMC3_2_BLB_IN B_WL_2 B_BLB_3 SUB
+ nchpg_hvtdpsr l=0.08U
+ w=0.105U
M8094 VSS XMC4X4_XMC3_1_BLB_IN
+ XMC4X4_XMC3_1_BL_IN SUB nchpd_hvtdpsr
+ l=0.065U w=0.315U
M8095 VSS XMC4X4_XMC2_1_BLB_IN
+ XMC4X4_XMC2_1_BL_IN SUB nchpd_hvtdpsr
+ l=0.065U w=0.315U
M8096 VSS XMC4X4_XMC3_0_BLB_IN
+ XMC4X4_XMC3_0_BL_IN SUB nchpd_hvtdpsr
+ l=0.065U w=0.315U
M8097 VSS XMC4X4_XMC2_0_BLB_IN
+ XMC4X4_XMC2_0_BL_IN SUB nchpd_hvtdpsr
+ l=0.065U w=0.315U
M8098 VSS XMC4X4_XMC3_2_BLB_IN
+ XMC4X4_XMC3_2_BL_IN SUB nchpd_hvtdpsr
+ l=0.065U w=0.315U
M8099 VSS XMC4X4_XMC2_2_BLB_IN
+ XMC4X4_XMC2_2_BL_IN SUB nchpd_hvtdpsr
+ l=0.065U w=0.315U
M8100 VSS XMC4X4_XMC3_3_BLB_IN
+ XMC4X4_XMC3_3_BL_IN SUB nchpd_hvtdpsr
+ l=0.065U w=0.315U
M8101 VSS XMC4X4_XMC2_3_BLB_IN
+ XMC4X4_XMC2_3_BL_IN SUB nchpd_hvtdpsr
+ l=0.065U w=0.315U
M8102 VDD XMC4X4_XMC3_0_BL_IN
+ XMC4X4_XMC3_0_BLB_IN NWELL pchpu_hvtdpsr
+ l=0.07U w=0.09U
M8103 VDD XMC4X4_XMC3_3_BL_IN
+ XMC4X4_XMC3_3_BLB_IN NWELL pchpu_hvtdpsr
+ l=0.07U w=0.09U
M8104 XMC4X4_XMC3_1_BL_IN XMC4X4_XMC3_1_BLB_IN
+ VDD NWELL pchpu_hvtdpsr l=0.07U
+ w=0.09U
M8105 XMC4X4_XMC3_0_BL_IN XMC4X4_XMC3_0_BLB_IN
+ VDD NWELL pchpu_hvtdpsr l=0.07U
+ w=0.09U
M8106 VDD XMC4X4_XMC3_1_BL_IN
+ XMC4X4_XMC3_1_BLB_IN NWELL pchpu_hvtdpsr
+ l=0.07U w=0.09U
M8107 XMC4X4_XMC3_2_BL_IN XMC4X4_XMC3_2_BLB_IN
+ VDD NWELL pchpu_hvtdpsr l=0.07U
+ w=0.09U
M8108 VDD XMC4X4_XMC3_2_BL_IN
+ XMC4X4_XMC3_2_BLB_IN NWELL pchpu_hvtdpsr
+ l=0.07U w=0.09U
M8109 XMC4X4_XMC3_3_BL_IN XMC4X4_XMC3_3_BLB_IN
+ VDD NWELL pchpu_hvtdpsr l=0.07U
+ w=0.09U
M8110 XMC4X4_XMC3_0_BLB_IN XMC4X4_XMC3_0_BL_IN
+ VSS SUB nchpd_hvtdpsr l=0.065U
+ w=0.315U
M8111 XMC4X4_XMC3_1_BLB_IN A_WL_1 A_BLB_3 SUB
+ nchpg_hvtdpsr l=0.08U
+ w=0.105U
M8112 A_BL_3 A_WL_1 XMC4X4_XMC3_1_BL_IN SUB
+ nchpg_hvtdpsr l=0.08U
+ w=0.105U
M8113 A_BL_3 A_WL_2 XMC4X4_XMC3_2_BL_IN SUB
+ nchpg_hvtdpsr l=0.08U
+ w=0.105U
M8114 XMC4X4_XMC3_2_BLB_IN A_WL_2 A_BLB_3 SUB
+ nchpg_hvtdpsr l=0.08U
+ w=0.105U
M8115 XMC4X4_XMC3_3_BLB_IN A_WL_3 A_BLB_3 SUB
+ nchpg_hvtdpsr l=0.08U
+ w=0.105U
M8116 A_BL_3 A_WL_3 XMC4X4_XMC3_3_BL_IN SUB
+ nchpg_hvtdpsr l=0.08U
+ w=0.105U
M8117 A_BL_3 A_WL_0 XMC4X4_XMC3_0_BL_IN SUB
+ nchpg_hvtdpsr l=0.08U
+ w=0.105U
M8118 XMC4X4_XMC3_0_BLB_IN A_WL_0 A_BLB_3 SUB
+ nchpg_hvtdpsr l=0.08U
+ w=0.105U
M8119 XMC4X4_XMC3_3_BLB_IN XMC4X4_XMC3_3_BL_IN
+ VSS SUB nchpd_hvtdpsr l=0.065U
+ w=0.315U
M8120 XMC4X4_XMC3_1_BLB_IN XMC4X4_XMC3_1_BL_IN
+ VSS SUB nchpd_hvtdpsr l=0.065U
+ w=0.315U
M8121 XMC4X4_XMC3_2_BLB_IN XMC4X4_XMC3_2_BL_IN
+ VSS SUB nchpd_hvtdpsr l=0.065U
+ w=0.315U
.ENDS
* MC4X4GF
.SUBCKT SDL400W20S_NMC4X4GF A_WL_3 A_WL_2 A_WL_1 A_WL_0 A_WLS_3 A_WLS_2
+	 A_WLS_1 A_WLS_0 B_WL_3 B_WL_2 B_WL_1 B_WL_0 B_WLS_3 B_WLS_2
+	 B_WLS_1 B_WLS_0 NWELL SUB A_BL_3 A_BL_2 A_BL_1 A_BL_0 A_BLB_3
+	 A_BLB_2 A_BLB_1 A_BLB_0 B_BL_3 B_BL_2 B_BL_1 B_BL_0 B_BLB_3
+	 B_BLB_2 B_BLB_1 B_BLB_0 GFA_3 GFA_2 GFA_1 GFA_0 GFB_3 GFB_2
+	 GFB_1 GFB_0
M8122 XMC4X4_XMC0_0_BLB_IN A_WL_0 A_BLB_0 SUB
+ nchpg_hvtdpsr l=0.08U
+ w=0.105U
M8123 A_BL_0 A_WL_0 XMC4X4_XMC0_0_BL_IN SUB
+ nchpg_hvtdpsr l=0.08U
+ w=0.105U
M8124 XMC4X4_XMC0_3_BLB_IN A_WL_3 A_BLB_0 SUB
+ nchpg_hvtdpsr l=0.08U
+ w=0.105U
M8125 A_BL_0 A_WL_3 XMC4X4_XMC0_3_BL_IN SUB
+ nchpg_hvtdpsr l=0.08U
+ w=0.105U
M8126 A_BL_0 A_WL_1 XMC4X4_XMC0_1_BL_IN SUB
+ nchpg_hvtdpsr l=0.08U
+ w=0.105U
M8127 XMC4X4_XMC0_1_BLB_IN A_WL_1 A_BLB_0 SUB
+ nchpg_hvtdpsr l=0.08U
+ w=0.105U
M8128 A_BL_0 A_WL_2 XMC4X4_XMC0_2_BL_IN SUB
+ nchpg_hvtdpsr l=0.08U
+ w=0.105U
M8129 XMC4X4_XMC0_2_BLB_IN A_WL_2 A_BLB_0 SUB
+ nchpg_hvtdpsr l=0.08U
+ w=0.105U
M8130 XMC4X4_XMC0_1_BLB_IN XMC4X4_XMC0_1_BL_IN
+ VSS SUB nchpd_hvtdpsr l=0.065U
+ w=0.315U
M8131 XMC4X4_XMC0_0_BLB_IN XMC4X4_XMC0_0_BL_IN
+ VSS SUB nchpd_hvtdpsr l=0.065U
+ w=0.315U
M8132 XMC4X4_XMC0_2_BLB_IN XMC4X4_XMC0_2_BL_IN
+ VSS SUB nchpd_hvtdpsr l=0.065U
+ w=0.315U
M8133 XMC4X4_XMC0_3_BLB_IN XMC4X4_XMC0_3_BL_IN
+ VSS SUB nchpd_hvtdpsr l=0.065U
+ w=0.315U
M8134 XMC4X4_XMC0_0_BL_IN XMC4X4_XMC0_0_BLB_IN
+ VDD NWELL pchpu_hvtdpsr l=0.07U
+ w=0.09U
M8135 XMC4X4_XMC0_3_BL_IN XMC4X4_XMC0_3_BLB_IN
+ VDD NWELL pchpu_hvtdpsr l=0.07U
+ w=0.09U
M8136 VDD XMC4X4_XMC0_1_BL_IN
+ XMC4X4_XMC0_1_BLB_IN NWELL pchpu_hvtdpsr
+ l=0.07U w=0.09U
M8137 VDD XMC4X4_XMC0_0_BL_IN
+ XMC4X4_XMC0_0_BLB_IN NWELL pchpu_hvtdpsr
+ l=0.07U w=0.09U
M8138 XMC4X4_XMC0_1_BL_IN XMC4X4_XMC0_1_BLB_IN
+ VDD NWELL pchpu_hvtdpsr l=0.07U
+ w=0.09U
M8139 VDD XMC4X4_XMC0_2_BL_IN
+ XMC4X4_XMC0_2_BLB_IN NWELL pchpu_hvtdpsr
+ l=0.07U w=0.09U
M8140 XMC4X4_XMC0_2_BL_IN XMC4X4_XMC0_2_BLB_IN
+ VDD NWELL pchpu_hvtdpsr l=0.07U
+ w=0.09U
M8141 VDD XMC4X4_XMC0_3_BL_IN
+ XMC4X4_XMC0_3_BLB_IN NWELL pchpu_hvtdpsr
+ l=0.07U w=0.09U
M8142 VSS XMC4X4_XMC0_0_BLB_IN
+ XMC4X4_XMC0_0_BL_IN SUB nchpd_hvtdpsr
+ l=0.065U w=0.315U
M8143 VSS XMC4X4_XMC1_0_BLB_IN
+ XMC4X4_XMC1_0_BL_IN SUB nchpd_hvtdpsr
+ l=0.065U w=0.315U
M8144 B_BL_0 B_WL_1 XMC4X4_XMC0_1_BL_IN SUB
+ nchpg_hvtdpsr l=0.08U
+ w=0.105U
M8145 B_BL_1 B_WL_1 XMC4X4_XMC1_1_BL_IN SUB
+ nchpg_hvtdpsr l=0.08U
+ w=0.105U
M8146 XMC4X4_XMC1_1_BLB_IN B_WL_1 B_BLB_1 SUB
+ nchpg_hvtdpsr l=0.08U
+ w=0.105U
M8147 XMC4X4_XMC0_1_BLB_IN B_WL_1 B_BLB_0 SUB
+ nchpg_hvtdpsr l=0.08U
+ w=0.105U
M8148 XMC4X4_XMC0_2_BLB_IN B_WL_2 B_BLB_0 SUB
+ nchpg_hvtdpsr l=0.08U
+ w=0.105U
M8149 B_BL_0 B_WL_2 XMC4X4_XMC0_2_BL_IN SUB
+ nchpg_hvtdpsr l=0.08U
+ w=0.105U
M8150 XMC4X4_XMC1_2_BLB_IN B_WL_2 B_BLB_1 SUB
+ nchpg_hvtdpsr l=0.08U
+ w=0.105U
M8151 B_BL_1 B_WL_2 XMC4X4_XMC1_2_BL_IN SUB
+ nchpg_hvtdpsr l=0.08U
+ w=0.105U
M8152 B_BL_1 B_WL_3 XMC4X4_XMC1_3_BL_IN SUB
+ nchpg_hvtdpsr l=0.08U
+ w=0.105U
M8153 XMC4X4_XMC1_3_BLB_IN B_WL_3 B_BLB_1 SUB
+ nchpg_hvtdpsr l=0.08U
+ w=0.105U
M8154 B_BL_0 B_WL_3 XMC4X4_XMC0_3_BL_IN SUB
+ nchpg_hvtdpsr l=0.08U
+ w=0.105U
M8155 XMC4X4_XMC0_3_BLB_IN B_WL_3 B_BLB_0 SUB
+ nchpg_hvtdpsr l=0.08U
+ w=0.105U
M8156 XMC4X4_XMC0_0_BLB_IN B_WL_0 B_BLB_0 SUB
+ nchpg_hvtdpsr l=0.08U
+ w=0.105U
M8157 XMC4X4_XMC1_0_BLB_IN B_WL_0 B_BLB_1 SUB
+ nchpg_hvtdpsr l=0.08U
+ w=0.105U
M8158 B_BL_1 B_WL_0 XMC4X4_XMC1_0_BL_IN SUB
+ nchpg_hvtdpsr l=0.08U
+ w=0.105U
M8159 B_BL_0 B_WL_0 XMC4X4_XMC0_0_BL_IN SUB
+ nchpg_hvtdpsr l=0.08U
+ w=0.105U
M8160 VSS XMC4X4_XMC1_3_BLB_IN
+ XMC4X4_XMC1_3_BL_IN SUB nchpd_hvtdpsr
+ l=0.065U w=0.315U
M8161 VSS XMC4X4_XMC0_3_BLB_IN
+ XMC4X4_XMC0_3_BL_IN SUB nchpd_hvtdpsr
+ l=0.065U w=0.315U
M8162 VSS XMC4X4_XMC0_1_BLB_IN
+ XMC4X4_XMC0_1_BL_IN SUB nchpd_hvtdpsr
+ l=0.065U w=0.315U
M8163 VSS XMC4X4_XMC1_1_BLB_IN
+ XMC4X4_XMC1_1_BL_IN SUB nchpd_hvtdpsr
+ l=0.065U w=0.315U
M8164 VSS XMC4X4_XMC1_2_BLB_IN
+ XMC4X4_XMC1_2_BL_IN SUB nchpd_hvtdpsr
+ l=0.065U w=0.315U
M8165 VSS XMC4X4_XMC0_2_BLB_IN
+ XMC4X4_XMC0_2_BL_IN SUB nchpd_hvtdpsr
+ l=0.065U w=0.315U
M8166 XMC4X4_XMC1_0_BL_IN XMC4X4_XMC1_0_BLB_IN
+ VDD NWELL pchpu_hvtdpsr l=0.07U
+ w=0.09U
M8167 XMC4X4_XMC1_3_BL_IN XMC4X4_XMC1_3_BLB_IN
+ VDD NWELL pchpu_hvtdpsr l=0.07U
+ w=0.09U
M8168 VDD XMC4X4_XMC1_1_BL_IN
+ XMC4X4_XMC1_1_BLB_IN NWELL pchpu_hvtdpsr
+ l=0.07U w=0.09U
M8169 VDD XMC4X4_XMC1_0_BL_IN
+ XMC4X4_XMC1_0_BLB_IN NWELL pchpu_hvtdpsr
+ l=0.07U w=0.09U
M8170 XMC4X4_XMC1_1_BL_IN XMC4X4_XMC1_1_BLB_IN
+ VDD NWELL pchpu_hvtdpsr l=0.07U
+ w=0.09U
M8171 VDD XMC4X4_XMC1_2_BL_IN
+ XMC4X4_XMC1_2_BLB_IN NWELL pchpu_hvtdpsr
+ l=0.07U w=0.09U
M8172 XMC4X4_XMC1_2_BL_IN XMC4X4_XMC1_2_BLB_IN
+ VDD NWELL pchpu_hvtdpsr l=0.07U
+ w=0.09U
M8173 VDD XMC4X4_XMC1_3_BL_IN
+ XMC4X4_XMC1_3_BLB_IN NWELL pchpu_hvtdpsr
+ l=0.07U w=0.09U
M8174 XMC4X4_XMC2_0_BLB_IN A_WL_0 A_BLB_2 SUB
+ nchpg_hvtdpsr l=0.08U
+ w=0.105U
M8175 XMC4X4_XMC1_0_BLB_IN A_WL_0 A_BLB_1 SUB
+ nchpg_hvtdpsr l=0.08U
+ w=0.105U
M8176 A_BL_1 A_WL_0 XMC4X4_XMC1_0_BL_IN SUB
+ nchpg_hvtdpsr l=0.08U
+ w=0.105U
M8177 A_BL_2 A_WL_0 XMC4X4_XMC2_0_BL_IN SUB
+ nchpg_hvtdpsr l=0.08U
+ w=0.105U
M8178 XMC4X4_XMC2_3_BLB_IN A_WL_3 A_BLB_2 SUB
+ nchpg_hvtdpsr l=0.08U
+ w=0.105U
M8179 XMC4X4_XMC1_3_BLB_IN A_WL_3 A_BLB_1 SUB
+ nchpg_hvtdpsr l=0.08U
+ w=0.105U
M8180 A_BL_2 A_WL_3 XMC4X4_XMC2_3_BL_IN SUB
+ nchpg_hvtdpsr l=0.08U
+ w=0.105U
M8181 A_BL_1 A_WL_3 XMC4X4_XMC1_3_BL_IN SUB
+ nchpg_hvtdpsr l=0.08U
+ w=0.105U
M8182 A_BL_2 A_WL_1 XMC4X4_XMC2_1_BL_IN SUB
+ nchpg_hvtdpsr l=0.08U
+ w=0.105U
M8183 A_BL_1 A_WL_1 XMC4X4_XMC1_1_BL_IN SUB
+ nchpg_hvtdpsr l=0.08U
+ w=0.105U
M8184 XMC4X4_XMC2_1_BLB_IN A_WL_1 A_BLB_2 SUB
+ nchpg_hvtdpsr l=0.08U
+ w=0.105U
M8185 XMC4X4_XMC1_1_BLB_IN A_WL_1 A_BLB_1 SUB
+ nchpg_hvtdpsr l=0.08U
+ w=0.105U
M8186 A_BL_2 A_WL_2 XMC4X4_XMC2_2_BL_IN SUB
+ nchpg_hvtdpsr l=0.08U
+ w=0.105U
M8187 A_BL_1 A_WL_2 XMC4X4_XMC1_2_BL_IN SUB
+ nchpg_hvtdpsr l=0.08U
+ w=0.105U
M8188 XMC4X4_XMC2_2_BLB_IN A_WL_2 A_BLB_2 SUB
+ nchpg_hvtdpsr l=0.08U
+ w=0.105U
M8189 XMC4X4_XMC1_2_BLB_IN A_WL_2 A_BLB_1 SUB
+ nchpg_hvtdpsr l=0.08U
+ w=0.105U
M8190 XMC4X4_XMC2_1_BLB_IN XMC4X4_XMC2_1_BL_IN
+ VSS SUB nchpd_hvtdpsr l=0.065U
+ w=0.315U
M8191 XMC4X4_XMC1_1_BLB_IN XMC4X4_XMC1_1_BL_IN
+ VSS SUB nchpd_hvtdpsr l=0.065U
+ w=0.315U
M8192 XMC4X4_XMC1_0_BLB_IN XMC4X4_XMC1_0_BL_IN
+ VSS SUB nchpd_hvtdpsr l=0.065U
+ w=0.315U
M8193 XMC4X4_XMC2_0_BLB_IN XMC4X4_XMC2_0_BL_IN
+ VSS SUB nchpd_hvtdpsr l=0.065U
+ w=0.315U
M8194 XMC4X4_XMC1_2_BLB_IN XMC4X4_XMC1_2_BL_IN
+ VSS SUB nchpd_hvtdpsr l=0.065U
+ w=0.315U
M8195 XMC4X4_XMC2_2_BLB_IN XMC4X4_XMC2_2_BL_IN
+ VSS SUB nchpd_hvtdpsr l=0.065U
+ w=0.315U
M8196 XMC4X4_XMC2_3_BLB_IN XMC4X4_XMC2_3_BL_IN
+ VSS SUB nchpd_hvtdpsr l=0.065U
+ w=0.315U
M8197 XMC4X4_XMC1_3_BLB_IN XMC4X4_XMC1_3_BL_IN
+ VSS SUB nchpd_hvtdpsr l=0.065U
+ w=0.315U
M8198 XMC4X4_XMC2_0_BL_IN XMC4X4_XMC2_0_BLB_IN
+ VDD NWELL pchpu_hvtdpsr l=0.07U
+ w=0.09U
M8199 XMC4X4_XMC2_3_BL_IN XMC4X4_XMC2_3_BLB_IN
+ VDD NWELL pchpu_hvtdpsr l=0.07U
+ w=0.09U
M8200 VDD XMC4X4_XMC2_1_BL_IN
+ XMC4X4_XMC2_1_BLB_IN NWELL pchpu_hvtdpsr
+ l=0.07U w=0.09U
M8201 VDD XMC4X4_XMC2_0_BL_IN
+ XMC4X4_XMC2_0_BLB_IN NWELL pchpu_hvtdpsr
+ l=0.07U w=0.09U
M8202 XMC4X4_XMC2_1_BL_IN XMC4X4_XMC2_1_BLB_IN
+ VDD NWELL pchpu_hvtdpsr l=0.07U
+ w=0.09U
M8203 VDD XMC4X4_XMC2_2_BL_IN
+ XMC4X4_XMC2_2_BLB_IN NWELL pchpu_hvtdpsr
+ l=0.07U w=0.09U
M8204 XMC4X4_XMC2_2_BL_IN XMC4X4_XMC2_2_BLB_IN
+ VDD NWELL pchpu_hvtdpsr l=0.07U
+ w=0.09U
M8205 VDD XMC4X4_XMC2_3_BL_IN
+ XMC4X4_XMC2_3_BLB_IN NWELL pchpu_hvtdpsr
+ l=0.07U w=0.09U
M8206 VSS XMC4X4_XMC3_0_BLB_IN
+ XMC4X4_XMC3_0_BL_IN SUB nchpd_hvtdpsr
+ l=0.065U w=0.315U
M8207 VSS XMC4X4_XMC2_0_BLB_IN
+ XMC4X4_XMC2_0_BL_IN SUB nchpd_hvtdpsr
+ l=0.065U w=0.315U
M8208 B_BL_2 B_WL_1 XMC4X4_XMC2_1_BL_IN SUB
+ nchpg_hvtdpsr l=0.08U
+ w=0.105U
M8209 XMC4X4_XMC2_1_BLB_IN B_WL_1 B_BLB_2 SUB
+ nchpg_hvtdpsr l=0.08U
+ w=0.105U
M8210 XMC4X4_XMC3_1_BLB_IN B_WL_1 B_BLB_3 SUB
+ nchpg_hvtdpsr l=0.08U
+ w=0.105U
M8211 B_BL_3 B_WL_1 XMC4X4_XMC3_1_BL_IN SUB
+ nchpg_hvtdpsr l=0.08U
+ w=0.105U
M8212 XMC4X4_XMC3_2_BLB_IN B_WL_2 B_BLB_3 SUB
+ nchpg_hvtdpsr l=0.08U
+ w=0.105U
M8213 XMC4X4_XMC2_2_BLB_IN B_WL_2 B_BLB_2 SUB
+ nchpg_hvtdpsr l=0.08U
+ w=0.105U
M8214 B_BL_2 B_WL_2 XMC4X4_XMC2_2_BL_IN SUB
+ nchpg_hvtdpsr l=0.08U
+ w=0.105U
M8215 B_BL_3 B_WL_2 XMC4X4_XMC3_2_BL_IN SUB
+ nchpg_hvtdpsr l=0.08U
+ w=0.105U
M8216 B_BL_3 B_WL_3 XMC4X4_XMC3_3_BL_IN SUB
+ nchpg_hvtdpsr l=0.08U
+ w=0.105U
M8217 B_BL_2 B_WL_3 XMC4X4_XMC2_3_BL_IN SUB
+ nchpg_hvtdpsr l=0.08U
+ w=0.105U
M8218 XMC4X4_XMC2_3_BLB_IN B_WL_3 B_BLB_2 SUB
+ nchpg_hvtdpsr l=0.08U
+ w=0.105U
M8219 XMC4X4_XMC3_3_BLB_IN B_WL_3 B_BLB_3 SUB
+ nchpg_hvtdpsr l=0.08U
+ w=0.105U
M8220 B_BL_3 B_WL_0 XMC4X4_XMC3_0_BL_IN SUB
+ nchpg_hvtdpsr l=0.08U
+ w=0.105U
M8221 XMC4X4_XMC3_0_BLB_IN B_WL_0 B_BLB_3 SUB
+ nchpg_hvtdpsr l=0.08U
+ w=0.105U
M8222 XMC4X4_XMC2_0_BLB_IN B_WL_0 B_BLB_2 SUB
+ nchpg_hvtdpsr l=0.08U
+ w=0.105U
M8223 B_BL_2 B_WL_0 XMC4X4_XMC2_0_BL_IN SUB
+ nchpg_hvtdpsr l=0.08U
+ w=0.105U
M8224 VSS XMC4X4_XMC2_3_BLB_IN
+ XMC4X4_XMC2_3_BL_IN SUB nchpd_hvtdpsr
+ l=0.065U w=0.315U
M8225 VSS XMC4X4_XMC3_3_BLB_IN
+ XMC4X4_XMC3_3_BL_IN SUB nchpd_hvtdpsr
+ l=0.065U w=0.315U
M8226 VSS XMC4X4_XMC3_1_BLB_IN
+ XMC4X4_XMC3_1_BL_IN SUB nchpd_hvtdpsr
+ l=0.065U w=0.315U
M8227 VSS XMC4X4_XMC2_1_BLB_IN
+ XMC4X4_XMC2_1_BL_IN SUB nchpd_hvtdpsr
+ l=0.065U w=0.315U
M8228 VSS XMC4X4_XMC2_2_BLB_IN
+ XMC4X4_XMC2_2_BL_IN SUB nchpd_hvtdpsr
+ l=0.065U w=0.315U
M8229 VSS XMC4X4_XMC3_2_BLB_IN
+ XMC4X4_XMC3_2_BL_IN SUB nchpd_hvtdpsr
+ l=0.065U w=0.315U
M8230 XMC4X4_XMC3_0_BL_IN XMC4X4_XMC3_0_BLB_IN
+ VDD NWELL pchpu_hvtdpsr l=0.07U
+ w=0.09U
M8231 XMC4X4_XMC3_3_BL_IN XMC4X4_XMC3_3_BLB_IN
+ VDD NWELL pchpu_hvtdpsr l=0.07U
+ w=0.09U
M8232 VDD XMC4X4_XMC3_1_BL_IN
+ XMC4X4_XMC3_1_BLB_IN NWELL pchpu_hvtdpsr
+ l=0.07U w=0.09U
M8233 VDD XMC4X4_XMC3_0_BL_IN
+ XMC4X4_XMC3_0_BLB_IN NWELL pchpu_hvtdpsr
+ l=0.07U w=0.09U
M8234 XMC4X4_XMC3_1_BL_IN XMC4X4_XMC3_1_BLB_IN
+ VDD NWELL pchpu_hvtdpsr l=0.07U
+ w=0.09U
M8235 VDD XMC4X4_XMC3_2_BL_IN
+ XMC4X4_XMC3_2_BLB_IN NWELL pchpu_hvtdpsr
+ l=0.07U w=0.09U
M8236 XMC4X4_XMC3_2_BL_IN XMC4X4_XMC3_2_BLB_IN
+ VDD NWELL pchpu_hvtdpsr l=0.07U
+ w=0.09U
M8237 VDD XMC4X4_XMC3_3_BL_IN
+ XMC4X4_XMC3_3_BLB_IN NWELL pchpu_hvtdpsr
+ l=0.07U w=0.09U
M8238 XMC4X4_XMC3_0_BLB_IN A_WL_0 A_BLB_3 SUB
+ nchpg_hvtdpsr l=0.08U
+ w=0.105U
M8239 A_BL_3 A_WL_0 XMC4X4_XMC3_0_BL_IN SUB
+ nchpg_hvtdpsr l=0.08U
+ w=0.105U
M8240 XMC4X4_XMC3_3_BLB_IN A_WL_3 A_BLB_3 SUB
+ nchpg_hvtdpsr l=0.08U
+ w=0.105U
M8241 A_BL_3 A_WL_3 XMC4X4_XMC3_3_BL_IN SUB
+ nchpg_hvtdpsr l=0.08U
+ w=0.105U
M8242 A_BL_3 A_WL_1 XMC4X4_XMC3_1_BL_IN SUB
+ nchpg_hvtdpsr l=0.08U
+ w=0.105U
M8243 XMC4X4_XMC3_1_BLB_IN A_WL_1 A_BLB_3 SUB
+ nchpg_hvtdpsr l=0.08U
+ w=0.105U
M8244 A_BL_3 A_WL_2 XMC4X4_XMC3_2_BL_IN SUB
+ nchpg_hvtdpsr l=0.08U
+ w=0.105U
M8245 XMC4X4_XMC3_2_BLB_IN A_WL_2 A_BLB_3 SUB
+ nchpg_hvtdpsr l=0.08U
+ w=0.105U
M8246 XMC4X4_XMC3_1_BLB_IN XMC4X4_XMC3_1_BL_IN
+ VSS SUB nchpd_hvtdpsr l=0.065U
+ w=0.315U
M8247 XMC4X4_XMC3_0_BLB_IN XMC4X4_XMC3_0_BL_IN
+ VSS SUB nchpd_hvtdpsr l=0.065U
+ w=0.315U
M8248 XMC4X4_XMC3_2_BLB_IN XMC4X4_XMC3_2_BL_IN
+ VSS SUB nchpd_hvtdpsr l=0.065U
+ w=0.315U
M8249 XMC4X4_XMC3_3_BLB_IN XMC4X4_XMC3_3_BL_IN
+ VSS SUB nchpd_hvtdpsr l=0.065U
+ w=0.315U
.ENDS
* MC4X4GT
.SUBCKT SDL400W20S_NMC4X4GT A_WL_3 A_WL_2 A_WL_1 A_WL_0 B_WL_3 B_WL_2
+	 B_WL_1 B_WL_0 NWELL SUB A_BL_3 A_BL_2 A_BL_1 A_BL_0 A_BLB_3
+	 A_BLB_2 A_BLB_1 A_BLB_0 B_BL_3 B_BL_2 B_BL_1 B_BL_0 B_BLB_3
+	 B_BLB_2 B_BLB_1 B_BLB_0 GFA_3 GFA_2 GFA_1 GFA_0 GFB_3 GFB_2
+	 GFB_1 GFB_0
M8250 XMC4X4_XMC0_0_BLB_IN XMC4X4_XMC0_0_BL_IN
+ VSS SUB nchpd_hvtdpsr l=0.065U
+ w=0.315U
M8251 XMC4X4_XMC0_1_BLB_IN A_WL_1 A_BLB_0 SUB
+ nchpg_hvtdpsr l=0.08U
+ w=0.105U
M8252 A_BL_0 A_WL_1 XMC4X4_XMC0_1_BL_IN SUB
+ nchpg_hvtdpsr l=0.08U
+ w=0.105U
M8253 A_BL_0 A_WL_2 XMC4X4_XMC0_2_BL_IN SUB
+ nchpg_hvtdpsr l=0.08U
+ w=0.105U
M8254 XMC4X4_XMC0_2_BLB_IN A_WL_2 A_BLB_0 SUB
+ nchpg_hvtdpsr l=0.08U
+ w=0.105U
M8255 XMC4X4_XMC0_3_BLB_IN A_WL_3 A_BLB_0 SUB
+ nchpg_hvtdpsr l=0.08U
+ w=0.105U
M8256 A_BL_0 A_WL_3 XMC4X4_XMC0_3_BL_IN SUB
+ nchpg_hvtdpsr l=0.08U
+ w=0.105U
M8257 A_BL_0 A_WL_0 XMC4X4_XMC0_0_BL_IN SUB
+ nchpg_hvtdpsr l=0.08U
+ w=0.105U
M8258 XMC4X4_XMC0_0_BLB_IN A_WL_0 A_BLB_0 SUB
+ nchpg_hvtdpsr l=0.08U
+ w=0.105U
M8259 XMC4X4_XMC0_3_BLB_IN XMC4X4_XMC0_3_BL_IN
+ VSS SUB nchpd_hvtdpsr l=0.065U
+ w=0.315U
M8260 XMC4X4_XMC0_1_BLB_IN XMC4X4_XMC0_1_BL_IN
+ VSS SUB nchpd_hvtdpsr l=0.065U
+ w=0.315U
M8261 XMC4X4_XMC0_2_BLB_IN XMC4X4_XMC0_2_BL_IN
+ VSS SUB nchpd_hvtdpsr l=0.065U
+ w=0.315U
M8262 VDD XMC4X4_XMC0_0_BL_IN
+ XMC4X4_XMC0_0_BLB_IN NWELL pchpu_hvtdpsr
+ l=0.07U w=0.09U
M8263 VDD XMC4X4_XMC0_3_BL_IN
+ XMC4X4_XMC0_3_BLB_IN NWELL pchpu_hvtdpsr
+ l=0.07U w=0.09U
M8264 XMC4X4_XMC0_1_BL_IN XMC4X4_XMC0_1_BLB_IN
+ VDD NWELL pchpu_hvtdpsr l=0.07U
+ w=0.09U
M8265 XMC4X4_XMC0_0_BL_IN XMC4X4_XMC0_0_BLB_IN
+ VDD NWELL pchpu_hvtdpsr l=0.07U
+ w=0.09U
M8266 VDD XMC4X4_XMC0_1_BL_IN
+ XMC4X4_XMC0_1_BLB_IN NWELL pchpu_hvtdpsr
+ l=0.07U w=0.09U
M8267 XMC4X4_XMC0_2_BL_IN XMC4X4_XMC0_2_BLB_IN
+ VDD NWELL pchpu_hvtdpsr l=0.07U
+ w=0.09U
M8268 VDD XMC4X4_XMC0_2_BL_IN
+ XMC4X4_XMC0_2_BLB_IN NWELL pchpu_hvtdpsr
+ l=0.07U w=0.09U
M8269 XMC4X4_XMC0_3_BL_IN XMC4X4_XMC0_3_BLB_IN
+ VDD NWELL pchpu_hvtdpsr l=0.07U
+ w=0.09U
M8270 B_BL_1 B_WL_0 XMC4X4_XMC1_0_BL_IN SUB
+ nchpg_hvtdpsr l=0.08U
+ w=0.105U
M8271 B_BL_0 B_WL_0 XMC4X4_XMC0_0_BL_IN SUB
+ nchpg_hvtdpsr l=0.08U
+ w=0.105U
M8272 XMC4X4_XMC0_0_BLB_IN B_WL_0 B_BLB_0 SUB
+ nchpg_hvtdpsr l=0.08U
+ w=0.105U
M8273 XMC4X4_XMC1_0_BLB_IN B_WL_0 B_BLB_1 SUB
+ nchpg_hvtdpsr l=0.08U
+ w=0.105U
M8274 B_BL_1 B_WL_3 XMC4X4_XMC1_3_BL_IN SUB
+ nchpg_hvtdpsr l=0.08U
+ w=0.105U
M8275 B_BL_0 B_WL_3 XMC4X4_XMC0_3_BL_IN SUB
+ nchpg_hvtdpsr l=0.08U
+ w=0.105U
M8276 XMC4X4_XMC0_3_BLB_IN B_WL_3 B_BLB_0 SUB
+ nchpg_hvtdpsr l=0.08U
+ w=0.105U
M8277 XMC4X4_XMC1_3_BLB_IN B_WL_3 B_BLB_1 SUB
+ nchpg_hvtdpsr l=0.08U
+ w=0.105U
M8278 B_BL_1 B_WL_1 XMC4X4_XMC1_1_BL_IN SUB
+ nchpg_hvtdpsr l=0.08U
+ w=0.105U
M8279 XMC4X4_XMC1_1_BLB_IN B_WL_1 B_BLB_1 SUB
+ nchpg_hvtdpsr l=0.08U
+ w=0.105U
M8280 B_BL_0 B_WL_1 XMC4X4_XMC0_1_BL_IN SUB
+ nchpg_hvtdpsr l=0.08U
+ w=0.105U
M8281 XMC4X4_XMC0_1_BLB_IN B_WL_1 B_BLB_0 SUB
+ nchpg_hvtdpsr l=0.08U
+ w=0.105U
M8282 B_BL_1 B_WL_2 XMC4X4_XMC1_2_BL_IN SUB
+ nchpg_hvtdpsr l=0.08U
+ w=0.105U
M8283 XMC4X4_XMC1_2_BLB_IN B_WL_2 B_BLB_1 SUB
+ nchpg_hvtdpsr l=0.08U
+ w=0.105U
M8284 B_BL_0 B_WL_2 XMC4X4_XMC0_2_BL_IN SUB
+ nchpg_hvtdpsr l=0.08U
+ w=0.105U
M8285 XMC4X4_XMC0_2_BLB_IN B_WL_2 B_BLB_0 SUB
+ nchpg_hvtdpsr l=0.08U
+ w=0.105U
M8286 VSS XMC4X4_XMC0_1_BLB_IN
+ XMC4X4_XMC0_1_BL_IN SUB nchpd_hvtdpsr
+ l=0.065U w=0.315U
M8287 VSS XMC4X4_XMC1_1_BLB_IN
+ XMC4X4_XMC1_1_BL_IN SUB nchpd_hvtdpsr
+ l=0.065U w=0.315U
M8288 VSS XMC4X4_XMC0_0_BLB_IN
+ XMC4X4_XMC0_0_BL_IN SUB nchpd_hvtdpsr
+ l=0.065U w=0.315U
M8289 VSS XMC4X4_XMC1_0_BLB_IN
+ XMC4X4_XMC1_0_BL_IN SUB nchpd_hvtdpsr
+ l=0.065U w=0.315U
M8290 VSS XMC4X4_XMC0_2_BLB_IN
+ XMC4X4_XMC0_2_BL_IN SUB nchpd_hvtdpsr
+ l=0.065U w=0.315U
M8291 VSS XMC4X4_XMC1_2_BLB_IN
+ XMC4X4_XMC1_2_BL_IN SUB nchpd_hvtdpsr
+ l=0.065U w=0.315U
M8292 VSS XMC4X4_XMC0_3_BLB_IN
+ XMC4X4_XMC0_3_BL_IN SUB nchpd_hvtdpsr
+ l=0.065U w=0.315U
M8293 VSS XMC4X4_XMC1_3_BLB_IN
+ XMC4X4_XMC1_3_BL_IN SUB nchpd_hvtdpsr
+ l=0.065U w=0.315U
M8294 VDD XMC4X4_XMC1_0_BL_IN
+ XMC4X4_XMC1_0_BLB_IN NWELL pchpu_hvtdpsr
+ l=0.07U w=0.09U
M8295 VDD XMC4X4_XMC1_3_BL_IN
+ XMC4X4_XMC1_3_BLB_IN NWELL pchpu_hvtdpsr
+ l=0.07U w=0.09U
M8296 XMC4X4_XMC1_1_BL_IN XMC4X4_XMC1_1_BLB_IN
+ VDD NWELL pchpu_hvtdpsr l=0.07U
+ w=0.09U
M8297 XMC4X4_XMC1_0_BL_IN XMC4X4_XMC1_0_BLB_IN
+ VDD NWELL pchpu_hvtdpsr l=0.07U
+ w=0.09U
M8298 VDD XMC4X4_XMC1_1_BL_IN
+ XMC4X4_XMC1_1_BLB_IN NWELL pchpu_hvtdpsr
+ l=0.07U w=0.09U
M8299 XMC4X4_XMC1_2_BL_IN XMC4X4_XMC1_2_BLB_IN
+ VDD NWELL pchpu_hvtdpsr l=0.07U
+ w=0.09U
M8300 VDD XMC4X4_XMC1_2_BL_IN
+ XMC4X4_XMC1_2_BLB_IN NWELL pchpu_hvtdpsr
+ l=0.07U w=0.09U
M8301 XMC4X4_XMC1_3_BL_IN XMC4X4_XMC1_3_BLB_IN
+ VDD NWELL pchpu_hvtdpsr l=0.07U
+ w=0.09U
M8302 XMC4X4_XMC1_0_BLB_IN XMC4X4_XMC1_0_BL_IN
+ VSS SUB nchpd_hvtdpsr l=0.065U
+ w=0.315U
M8303 XMC4X4_XMC2_0_BLB_IN XMC4X4_XMC2_0_BL_IN
+ VSS SUB nchpd_hvtdpsr l=0.065U
+ w=0.315U
M8304 XMC4X4_XMC1_1_BLB_IN A_WL_1 A_BLB_1 SUB
+ nchpg_hvtdpsr l=0.08U
+ w=0.105U
M8305 XMC4X4_XMC2_1_BLB_IN A_WL_1 A_BLB_2 SUB
+ nchpg_hvtdpsr l=0.08U
+ w=0.105U
M8306 A_BL_1 A_WL_1 XMC4X4_XMC1_1_BL_IN SUB
+ nchpg_hvtdpsr l=0.08U
+ w=0.105U
M8307 A_BL_2 A_WL_1 XMC4X4_XMC2_1_BL_IN SUB
+ nchpg_hvtdpsr l=0.08U
+ w=0.105U
M8308 A_BL_1 A_WL_2 XMC4X4_XMC1_2_BL_IN SUB
+ nchpg_hvtdpsr l=0.08U
+ w=0.105U
M8309 XMC4X4_XMC1_2_BLB_IN A_WL_2 A_BLB_1 SUB
+ nchpg_hvtdpsr l=0.08U
+ w=0.105U
M8310 A_BL_2 A_WL_2 XMC4X4_XMC2_2_BL_IN SUB
+ nchpg_hvtdpsr l=0.08U
+ w=0.105U
M8311 XMC4X4_XMC2_2_BLB_IN A_WL_2 A_BLB_2 SUB
+ nchpg_hvtdpsr l=0.08U
+ w=0.105U
M8312 XMC4X4_XMC2_3_BLB_IN A_WL_3 A_BLB_2 SUB
+ nchpg_hvtdpsr l=0.08U
+ w=0.105U
M8313 A_BL_2 A_WL_3 XMC4X4_XMC2_3_BL_IN SUB
+ nchpg_hvtdpsr l=0.08U
+ w=0.105U
M8314 XMC4X4_XMC1_3_BLB_IN A_WL_3 A_BLB_1 SUB
+ nchpg_hvtdpsr l=0.08U
+ w=0.105U
M8315 A_BL_1 A_WL_3 XMC4X4_XMC1_3_BL_IN SUB
+ nchpg_hvtdpsr l=0.08U
+ w=0.105U
M8316 A_BL_2 A_WL_0 XMC4X4_XMC2_0_BL_IN SUB
+ nchpg_hvtdpsr l=0.08U
+ w=0.105U
M8317 A_BL_1 A_WL_0 XMC4X4_XMC1_0_BL_IN SUB
+ nchpg_hvtdpsr l=0.08U
+ w=0.105U
M8318 XMC4X4_XMC2_0_BLB_IN A_WL_0 A_BLB_2 SUB
+ nchpg_hvtdpsr l=0.08U
+ w=0.105U
M8319 XMC4X4_XMC1_0_BLB_IN A_WL_0 A_BLB_1 SUB
+ nchpg_hvtdpsr l=0.08U
+ w=0.105U
M8320 XMC4X4_XMC1_3_BLB_IN XMC4X4_XMC1_3_BL_IN
+ VSS SUB nchpd_hvtdpsr l=0.065U
+ w=0.315U
M8321 XMC4X4_XMC2_3_BLB_IN XMC4X4_XMC2_3_BL_IN
+ VSS SUB nchpd_hvtdpsr l=0.065U
+ w=0.315U
M8322 XMC4X4_XMC2_1_BLB_IN XMC4X4_XMC2_1_BL_IN
+ VSS SUB nchpd_hvtdpsr l=0.065U
+ w=0.315U
M8323 XMC4X4_XMC1_1_BLB_IN XMC4X4_XMC1_1_BL_IN
+ VSS SUB nchpd_hvtdpsr l=0.065U
+ w=0.315U
M8324 XMC4X4_XMC2_2_BLB_IN XMC4X4_XMC2_2_BL_IN
+ VSS SUB nchpd_hvtdpsr l=0.065U
+ w=0.315U
M8325 XMC4X4_XMC1_2_BLB_IN XMC4X4_XMC1_2_BL_IN
+ VSS SUB nchpd_hvtdpsr l=0.065U
+ w=0.315U
M8326 VDD XMC4X4_XMC2_0_BL_IN
+ XMC4X4_XMC2_0_BLB_IN NWELL pchpu_hvtdpsr
+ l=0.07U w=0.09U
M8327 VDD XMC4X4_XMC2_3_BL_IN
+ XMC4X4_XMC2_3_BLB_IN NWELL pchpu_hvtdpsr
+ l=0.07U w=0.09U
M8328 XMC4X4_XMC2_1_BL_IN XMC4X4_XMC2_1_BLB_IN
+ VDD NWELL pchpu_hvtdpsr l=0.07U
+ w=0.09U
M8329 XMC4X4_XMC2_0_BL_IN XMC4X4_XMC2_0_BLB_IN
+ VDD NWELL pchpu_hvtdpsr l=0.07U
+ w=0.09U
M8330 VDD XMC4X4_XMC2_1_BL_IN
+ XMC4X4_XMC2_1_BLB_IN NWELL pchpu_hvtdpsr
+ l=0.07U w=0.09U
M8331 XMC4X4_XMC2_2_BL_IN XMC4X4_XMC2_2_BLB_IN
+ VDD NWELL pchpu_hvtdpsr l=0.07U
+ w=0.09U
M8332 VDD XMC4X4_XMC2_2_BL_IN
+ XMC4X4_XMC2_2_BLB_IN NWELL pchpu_hvtdpsr
+ l=0.07U w=0.09U
M8333 XMC4X4_XMC2_3_BL_IN XMC4X4_XMC2_3_BLB_IN
+ VDD NWELL pchpu_hvtdpsr l=0.07U
+ w=0.09U
M8334 B_BL_3 B_WL_0 XMC4X4_XMC3_0_BL_IN SUB
+ nchpg_hvtdpsr l=0.08U
+ w=0.105U
M8335 B_BL_2 B_WL_0 XMC4X4_XMC2_0_BL_IN SUB
+ nchpg_hvtdpsr l=0.08U
+ w=0.105U
M8336 XMC4X4_XMC3_0_BLB_IN B_WL_0 B_BLB_3 SUB
+ nchpg_hvtdpsr l=0.08U
+ w=0.105U
M8337 XMC4X4_XMC2_0_BLB_IN B_WL_0 B_BLB_2 SUB
+ nchpg_hvtdpsr l=0.08U
+ w=0.105U
M8338 B_BL_3 B_WL_3 XMC4X4_XMC3_3_BL_IN SUB
+ nchpg_hvtdpsr l=0.08U
+ w=0.105U
M8339 B_BL_2 B_WL_3 XMC4X4_XMC2_3_BL_IN SUB
+ nchpg_hvtdpsr l=0.08U
+ w=0.105U
M8340 XMC4X4_XMC3_3_BLB_IN B_WL_3 B_BLB_3 SUB
+ nchpg_hvtdpsr l=0.08U
+ w=0.105U
M8341 XMC4X4_XMC2_3_BLB_IN B_WL_3 B_BLB_2 SUB
+ nchpg_hvtdpsr l=0.08U
+ w=0.105U
M8342 B_BL_3 B_WL_1 XMC4X4_XMC3_1_BL_IN SUB
+ nchpg_hvtdpsr l=0.08U
+ w=0.105U
M8343 B_BL_2 B_WL_1 XMC4X4_XMC2_1_BL_IN SUB
+ nchpg_hvtdpsr l=0.08U
+ w=0.105U
M8344 XMC4X4_XMC2_1_BLB_IN B_WL_1 B_BLB_2 SUB
+ nchpg_hvtdpsr l=0.08U
+ w=0.105U
M8345 XMC4X4_XMC3_1_BLB_IN B_WL_1 B_BLB_3 SUB
+ nchpg_hvtdpsr l=0.08U
+ w=0.105U
M8346 B_BL_3 B_WL_2 XMC4X4_XMC3_2_BL_IN SUB
+ nchpg_hvtdpsr l=0.08U
+ w=0.105U
M8347 B_BL_2 B_WL_2 XMC4X4_XMC2_2_BL_IN SUB
+ nchpg_hvtdpsr l=0.08U
+ w=0.105U
M8348 XMC4X4_XMC2_2_BLB_IN B_WL_2 B_BLB_2 SUB
+ nchpg_hvtdpsr l=0.08U
+ w=0.105U
M8349 XMC4X4_XMC3_2_BLB_IN B_WL_2 B_BLB_3 SUB
+ nchpg_hvtdpsr l=0.08U
+ w=0.105U
M8350 VSS XMC4X4_XMC3_1_BLB_IN
+ XMC4X4_XMC3_1_BL_IN SUB nchpd_hvtdpsr
+ l=0.065U w=0.315U
M8351 VSS XMC4X4_XMC2_1_BLB_IN
+ XMC4X4_XMC2_1_BL_IN SUB nchpd_hvtdpsr
+ l=0.065U w=0.315U
M8352 VSS XMC4X4_XMC3_0_BLB_IN
+ XMC4X4_XMC3_0_BL_IN SUB nchpd_hvtdpsr
+ l=0.065U w=0.315U
M8353 VSS XMC4X4_XMC2_0_BLB_IN
+ XMC4X4_XMC2_0_BL_IN SUB nchpd_hvtdpsr
+ l=0.065U w=0.315U
M8354 VSS XMC4X4_XMC3_2_BLB_IN
+ XMC4X4_XMC3_2_BL_IN SUB nchpd_hvtdpsr
+ l=0.065U w=0.315U
M8355 VSS XMC4X4_XMC2_2_BLB_IN
+ XMC4X4_XMC2_2_BL_IN SUB nchpd_hvtdpsr
+ l=0.065U w=0.315U
M8356 VSS XMC4X4_XMC3_3_BLB_IN
+ XMC4X4_XMC3_3_BL_IN SUB nchpd_hvtdpsr
+ l=0.065U w=0.315U
M8357 VSS XMC4X4_XMC2_3_BLB_IN
+ XMC4X4_XMC2_3_BL_IN SUB nchpd_hvtdpsr
+ l=0.065U w=0.315U
M8358 VDD XMC4X4_XMC3_0_BL_IN
+ XMC4X4_XMC3_0_BLB_IN NWELL pchpu_hvtdpsr
+ l=0.07U w=0.09U
M8359 VDD XMC4X4_XMC3_3_BL_IN
+ XMC4X4_XMC3_3_BLB_IN NWELL pchpu_hvtdpsr
+ l=0.07U w=0.09U
M8360 XMC4X4_XMC3_1_BL_IN XMC4X4_XMC3_1_BLB_IN
+ VDD NWELL pchpu_hvtdpsr l=0.07U
+ w=0.09U
M8361 XMC4X4_XMC3_0_BL_IN XMC4X4_XMC3_0_BLB_IN
+ VDD NWELL pchpu_hvtdpsr l=0.07U
+ w=0.09U
M8362 VDD XMC4X4_XMC3_1_BL_IN
+ XMC4X4_XMC3_1_BLB_IN NWELL pchpu_hvtdpsr
+ l=0.07U w=0.09U
M8363 XMC4X4_XMC3_2_BL_IN XMC4X4_XMC3_2_BLB_IN
+ VDD NWELL pchpu_hvtdpsr l=0.07U
+ w=0.09U
M8364 VDD XMC4X4_XMC3_2_BL_IN
+ XMC4X4_XMC3_2_BLB_IN NWELL pchpu_hvtdpsr
+ l=0.07U w=0.09U
M8365 XMC4X4_XMC3_3_BL_IN XMC4X4_XMC3_3_BLB_IN
+ VDD NWELL pchpu_hvtdpsr l=0.07U
+ w=0.09U
M8366 XMC4X4_XMC3_0_BLB_IN XMC4X4_XMC3_0_BL_IN
+ VSS SUB nchpd_hvtdpsr l=0.065U
+ w=0.315U
M8367 XMC4X4_XMC3_1_BLB_IN A_WL_1 A_BLB_3 SUB
+ nchpg_hvtdpsr l=0.08U
+ w=0.105U
M8368 A_BL_3 A_WL_1 XMC4X4_XMC3_1_BL_IN SUB
+ nchpg_hvtdpsr l=0.08U
+ w=0.105U
M8369 A_BL_3 A_WL_2 XMC4X4_XMC3_2_BL_IN SUB
+ nchpg_hvtdpsr l=0.08U
+ w=0.105U
M8370 XMC4X4_XMC3_2_BLB_IN A_WL_2 A_BLB_3 SUB
+ nchpg_hvtdpsr l=0.08U
+ w=0.105U
M8371 XMC4X4_XMC3_3_BLB_IN A_WL_3 A_BLB_3 SUB
+ nchpg_hvtdpsr l=0.08U
+ w=0.105U
M8372 A_BL_3 A_WL_3 XMC4X4_XMC3_3_BL_IN SUB
+ nchpg_hvtdpsr l=0.08U
+ w=0.105U
M8373 A_BL_3 A_WL_0 XMC4X4_XMC3_0_BL_IN SUB
+ nchpg_hvtdpsr l=0.08U
+ w=0.105U
M8374 XMC4X4_XMC3_0_BLB_IN A_WL_0 A_BLB_3 SUB
+ nchpg_hvtdpsr l=0.08U
+ w=0.105U
M8375 XMC4X4_XMC3_3_BLB_IN XMC4X4_XMC3_3_BL_IN
+ VSS SUB nchpd_hvtdpsr l=0.065U
+ w=0.315U
M8376 XMC4X4_XMC3_1_BLB_IN XMC4X4_XMC3_1_BL_IN
+ VSS SUB nchpd_hvtdpsr l=0.065U
+ w=0.315U
M8377 XMC4X4_XMC3_2_BLB_IN XMC4X4_XMC3_2_BL_IN
+ VSS SUB nchpd_hvtdpsr l=0.065U
+ w=0.315U
.ENDS
* MC4X4GTF
.SUBCKT SDL400W20S_NMC4X4GTF A_WL_3 A_WL_2 A_WL_1 A_WL_0 B_WL_3 B_WL_2
+	 B_WL_1 B_WL_0 NWELL SUB A_BL_3 A_BL_2 A_BL_1 A_BL_0 A_BLB_3
+	 A_BLB_2 A_BLB_1 A_BLB_0 B_BL_3 B_BL_2 B_BL_1 B_BL_0 B_BLB_3
+	 B_BLB_2 B_BLB_1 B_BLB_0 GFA_3 GFA_2 GFA_1 GFA_0 GFB_3 GFB_2
+	 GFB_1 GFB_0
M8378 XMC4X4_XMC0_0_BLB_IN A_WL_0 A_BLB_0 SUB
+ nchpg_hvtdpsr l=0.08U
+ w=0.105U
M8379 A_BL_0 A_WL_0 XMC4X4_XMC0_0_BL_IN SUB
+ nchpg_hvtdpsr l=0.08U
+ w=0.105U
M8380 XMC4X4_XMC0_3_BLB_IN A_WL_3 A_BLB_0 SUB
+ nchpg_hvtdpsr l=0.08U
+ w=0.105U
M8381 A_BL_0 A_WL_3 XMC4X4_XMC0_3_BL_IN SUB
+ nchpg_hvtdpsr l=0.08U
+ w=0.105U
M8382 A_BL_0 A_WL_1 XMC4X4_XMC0_1_BL_IN SUB
+ nchpg_hvtdpsr l=0.08U
+ w=0.105U
M8383 XMC4X4_XMC0_1_BLB_IN A_WL_1 A_BLB_0 SUB
+ nchpg_hvtdpsr l=0.08U
+ w=0.105U
M8384 A_BL_0 A_WL_2 XMC4X4_XMC0_2_BL_IN SUB
+ nchpg_hvtdpsr l=0.08U
+ w=0.105U
M8385 XMC4X4_XMC0_2_BLB_IN A_WL_2 A_BLB_0 SUB
+ nchpg_hvtdpsr l=0.08U
+ w=0.105U
M8386 XMC4X4_XMC0_1_BLB_IN XMC4X4_XMC0_1_BL_IN
+ VSS SUB nchpd_hvtdpsr l=0.065U
+ w=0.315U
M8387 XMC4X4_XMC0_0_BLB_IN XMC4X4_XMC0_0_BL_IN
+ VSS SUB nchpd_hvtdpsr l=0.065U
+ w=0.315U
M8388 XMC4X4_XMC0_2_BLB_IN XMC4X4_XMC0_2_BL_IN
+ VSS SUB nchpd_hvtdpsr l=0.065U
+ w=0.315U
M8389 XMC4X4_XMC0_3_BLB_IN XMC4X4_XMC0_3_BL_IN
+ VSS SUB nchpd_hvtdpsr l=0.065U
+ w=0.315U
M8390 XMC4X4_XMC0_0_BL_IN XMC4X4_XMC0_0_BLB_IN
+ VDD NWELL pchpu_hvtdpsr l=0.07U
+ w=0.09U
M8391 XMC4X4_XMC0_3_BL_IN XMC4X4_XMC0_3_BLB_IN
+ VDD NWELL pchpu_hvtdpsr l=0.07U
+ w=0.09U
M8392 VDD XMC4X4_XMC0_1_BL_IN
+ XMC4X4_XMC0_1_BLB_IN NWELL pchpu_hvtdpsr
+ l=0.07U w=0.09U
M8393 VDD XMC4X4_XMC0_0_BL_IN
+ XMC4X4_XMC0_0_BLB_IN NWELL pchpu_hvtdpsr
+ l=0.07U w=0.09U
M8394 XMC4X4_XMC0_1_BL_IN XMC4X4_XMC0_1_BLB_IN
+ VDD NWELL pchpu_hvtdpsr l=0.07U
+ w=0.09U
M8395 VDD XMC4X4_XMC0_2_BL_IN
+ XMC4X4_XMC0_2_BLB_IN NWELL pchpu_hvtdpsr
+ l=0.07U w=0.09U
M8396 XMC4X4_XMC0_2_BL_IN XMC4X4_XMC0_2_BLB_IN
+ VDD NWELL pchpu_hvtdpsr l=0.07U
+ w=0.09U
M8397 VDD XMC4X4_XMC0_3_BL_IN
+ XMC4X4_XMC0_3_BLB_IN NWELL pchpu_hvtdpsr
+ l=0.07U w=0.09U
M8398 VSS XMC4X4_XMC0_0_BLB_IN
+ XMC4X4_XMC0_0_BL_IN SUB nchpd_hvtdpsr
+ l=0.065U w=0.315U
M8399 VSS XMC4X4_XMC1_0_BLB_IN
+ XMC4X4_XMC1_0_BL_IN SUB nchpd_hvtdpsr
+ l=0.065U w=0.315U
M8400 B_BL_0 B_WL_1 XMC4X4_XMC0_1_BL_IN SUB
+ nchpg_hvtdpsr l=0.08U
+ w=0.105U
M8401 B_BL_1 B_WL_1 XMC4X4_XMC1_1_BL_IN SUB
+ nchpg_hvtdpsr l=0.08U
+ w=0.105U
M8402 XMC4X4_XMC1_1_BLB_IN B_WL_1 B_BLB_1 SUB
+ nchpg_hvtdpsr l=0.08U
+ w=0.105U
M8403 XMC4X4_XMC0_1_BLB_IN B_WL_1 B_BLB_0 SUB
+ nchpg_hvtdpsr l=0.08U
+ w=0.105U
M8404 XMC4X4_XMC0_2_BLB_IN B_WL_2 B_BLB_0 SUB
+ nchpg_hvtdpsr l=0.08U
+ w=0.105U
M8405 B_BL_0 B_WL_2 XMC4X4_XMC0_2_BL_IN SUB
+ nchpg_hvtdpsr l=0.08U
+ w=0.105U
M8406 XMC4X4_XMC1_2_BLB_IN B_WL_2 B_BLB_1 SUB
+ nchpg_hvtdpsr l=0.08U
+ w=0.105U
M8407 B_BL_1 B_WL_2 XMC4X4_XMC1_2_BL_IN SUB
+ nchpg_hvtdpsr l=0.08U
+ w=0.105U
M8408 B_BL_1 B_WL_3 XMC4X4_XMC1_3_BL_IN SUB
+ nchpg_hvtdpsr l=0.08U
+ w=0.105U
M8409 XMC4X4_XMC1_3_BLB_IN B_WL_3 B_BLB_1 SUB
+ nchpg_hvtdpsr l=0.08U
+ w=0.105U
M8410 B_BL_0 B_WL_3 XMC4X4_XMC0_3_BL_IN SUB
+ nchpg_hvtdpsr l=0.08U
+ w=0.105U
M8411 XMC4X4_XMC0_3_BLB_IN B_WL_3 B_BLB_0 SUB
+ nchpg_hvtdpsr l=0.08U
+ w=0.105U
M8412 XMC4X4_XMC0_0_BLB_IN B_WL_0 B_BLB_0 SUB
+ nchpg_hvtdpsr l=0.08U
+ w=0.105U
M8413 XMC4X4_XMC1_0_BLB_IN B_WL_0 B_BLB_1 SUB
+ nchpg_hvtdpsr l=0.08U
+ w=0.105U
M8414 B_BL_1 B_WL_0 XMC4X4_XMC1_0_BL_IN SUB
+ nchpg_hvtdpsr l=0.08U
+ w=0.105U
M8415 B_BL_0 B_WL_0 XMC4X4_XMC0_0_BL_IN SUB
+ nchpg_hvtdpsr l=0.08U
+ w=0.105U
M8416 VSS XMC4X4_XMC1_3_BLB_IN
+ XMC4X4_XMC1_3_BL_IN SUB nchpd_hvtdpsr
+ l=0.065U w=0.315U
M8417 VSS XMC4X4_XMC0_3_BLB_IN
+ XMC4X4_XMC0_3_BL_IN SUB nchpd_hvtdpsr
+ l=0.065U w=0.315U
M8418 VSS XMC4X4_XMC0_1_BLB_IN
+ XMC4X4_XMC0_1_BL_IN SUB nchpd_hvtdpsr
+ l=0.065U w=0.315U
M8419 VSS XMC4X4_XMC1_1_BLB_IN
+ XMC4X4_XMC1_1_BL_IN SUB nchpd_hvtdpsr
+ l=0.065U w=0.315U
M8420 VSS XMC4X4_XMC1_2_BLB_IN
+ XMC4X4_XMC1_2_BL_IN SUB nchpd_hvtdpsr
+ l=0.065U w=0.315U
M8421 VSS XMC4X4_XMC0_2_BLB_IN
+ XMC4X4_XMC0_2_BL_IN SUB nchpd_hvtdpsr
+ l=0.065U w=0.315U
M8422 XMC4X4_XMC1_0_BL_IN XMC4X4_XMC1_0_BLB_IN
+ VDD NWELL pchpu_hvtdpsr l=0.07U
+ w=0.09U
M8423 XMC4X4_XMC1_3_BL_IN XMC4X4_XMC1_3_BLB_IN
+ VDD NWELL pchpu_hvtdpsr l=0.07U
+ w=0.09U
M8424 VDD XMC4X4_XMC1_1_BL_IN
+ XMC4X4_XMC1_1_BLB_IN NWELL pchpu_hvtdpsr
+ l=0.07U w=0.09U
M8425 VDD XMC4X4_XMC1_0_BL_IN
+ XMC4X4_XMC1_0_BLB_IN NWELL pchpu_hvtdpsr
+ l=0.07U w=0.09U
M8426 XMC4X4_XMC1_1_BL_IN XMC4X4_XMC1_1_BLB_IN
+ VDD NWELL pchpu_hvtdpsr l=0.07U
+ w=0.09U
M8427 VDD XMC4X4_XMC1_2_BL_IN
+ XMC4X4_XMC1_2_BLB_IN NWELL pchpu_hvtdpsr
+ l=0.07U w=0.09U
M8428 XMC4X4_XMC1_2_BL_IN XMC4X4_XMC1_2_BLB_IN
+ VDD NWELL pchpu_hvtdpsr l=0.07U
+ w=0.09U
M8429 VDD XMC4X4_XMC1_3_BL_IN
+ XMC4X4_XMC1_3_BLB_IN NWELL pchpu_hvtdpsr
+ l=0.07U w=0.09U
M8430 XMC4X4_XMC2_0_BLB_IN A_WL_0 A_BLB_2 SUB
+ nchpg_hvtdpsr l=0.08U
+ w=0.105U
M8431 XMC4X4_XMC1_0_BLB_IN A_WL_0 A_BLB_1 SUB
+ nchpg_hvtdpsr l=0.08U
+ w=0.105U
M8432 A_BL_1 A_WL_0 XMC4X4_XMC1_0_BL_IN SUB
+ nchpg_hvtdpsr l=0.08U
+ w=0.105U
M8433 A_BL_2 A_WL_0 XMC4X4_XMC2_0_BL_IN SUB
+ nchpg_hvtdpsr l=0.08U
+ w=0.105U
M8434 XMC4X4_XMC2_3_BLB_IN A_WL_3 A_BLB_2 SUB
+ nchpg_hvtdpsr l=0.08U
+ w=0.105U
M8435 XMC4X4_XMC1_3_BLB_IN A_WL_3 A_BLB_1 SUB
+ nchpg_hvtdpsr l=0.08U
+ w=0.105U
M8436 A_BL_2 A_WL_3 XMC4X4_XMC2_3_BL_IN SUB
+ nchpg_hvtdpsr l=0.08U
+ w=0.105U
M8437 A_BL_1 A_WL_3 XMC4X4_XMC1_3_BL_IN SUB
+ nchpg_hvtdpsr l=0.08U
+ w=0.105U
M8438 A_BL_2 A_WL_1 XMC4X4_XMC2_1_BL_IN SUB
+ nchpg_hvtdpsr l=0.08U
+ w=0.105U
M8439 A_BL_1 A_WL_1 XMC4X4_XMC1_1_BL_IN SUB
+ nchpg_hvtdpsr l=0.08U
+ w=0.105U
M8440 XMC4X4_XMC2_1_BLB_IN A_WL_1 A_BLB_2 SUB
+ nchpg_hvtdpsr l=0.08U
+ w=0.105U
M8441 XMC4X4_XMC1_1_BLB_IN A_WL_1 A_BLB_1 SUB
+ nchpg_hvtdpsr l=0.08U
+ w=0.105U
M8442 A_BL_2 A_WL_2 XMC4X4_XMC2_2_BL_IN SUB
+ nchpg_hvtdpsr l=0.08U
+ w=0.105U
M8443 A_BL_1 A_WL_2 XMC4X4_XMC1_2_BL_IN SUB
+ nchpg_hvtdpsr l=0.08U
+ w=0.105U
M8444 XMC4X4_XMC2_2_BLB_IN A_WL_2 A_BLB_2 SUB
+ nchpg_hvtdpsr l=0.08U
+ w=0.105U
M8445 XMC4X4_XMC1_2_BLB_IN A_WL_2 A_BLB_1 SUB
+ nchpg_hvtdpsr l=0.08U
+ w=0.105U
M8446 XMC4X4_XMC2_1_BLB_IN XMC4X4_XMC2_1_BL_IN
+ VSS SUB nchpd_hvtdpsr l=0.065U
+ w=0.315U
M8447 XMC4X4_XMC1_1_BLB_IN XMC4X4_XMC1_1_BL_IN
+ VSS SUB nchpd_hvtdpsr l=0.065U
+ w=0.315U
M8448 XMC4X4_XMC1_0_BLB_IN XMC4X4_XMC1_0_BL_IN
+ VSS SUB nchpd_hvtdpsr l=0.065U
+ w=0.315U
M8449 XMC4X4_XMC2_0_BLB_IN XMC4X4_XMC2_0_BL_IN
+ VSS SUB nchpd_hvtdpsr l=0.065U
+ w=0.315U
M8450 XMC4X4_XMC1_2_BLB_IN XMC4X4_XMC1_2_BL_IN
+ VSS SUB nchpd_hvtdpsr l=0.065U
+ w=0.315U
M8451 XMC4X4_XMC2_2_BLB_IN XMC4X4_XMC2_2_BL_IN
+ VSS SUB nchpd_hvtdpsr l=0.065U
+ w=0.315U
M8452 XMC4X4_XMC2_3_BLB_IN XMC4X4_XMC2_3_BL_IN
+ VSS SUB nchpd_hvtdpsr l=0.065U
+ w=0.315U
M8453 XMC4X4_XMC1_3_BLB_IN XMC4X4_XMC1_3_BL_IN
+ VSS SUB nchpd_hvtdpsr l=0.065U
+ w=0.315U
M8454 XMC4X4_XMC2_0_BL_IN XMC4X4_XMC2_0_BLB_IN
+ VDD NWELL pchpu_hvtdpsr l=0.07U
+ w=0.09U
M8455 XMC4X4_XMC2_3_BL_IN XMC4X4_XMC2_3_BLB_IN
+ VDD NWELL pchpu_hvtdpsr l=0.07U
+ w=0.09U
M8456 VDD XMC4X4_XMC2_1_BL_IN
+ XMC4X4_XMC2_1_BLB_IN NWELL pchpu_hvtdpsr
+ l=0.07U w=0.09U
M8457 VDD XMC4X4_XMC2_0_BL_IN
+ XMC4X4_XMC2_0_BLB_IN NWELL pchpu_hvtdpsr
+ l=0.07U w=0.09U
M8458 XMC4X4_XMC2_1_BL_IN XMC4X4_XMC2_1_BLB_IN
+ VDD NWELL pchpu_hvtdpsr l=0.07U
+ w=0.09U
M8459 VDD XMC4X4_XMC2_2_BL_IN
+ XMC4X4_XMC2_2_BLB_IN NWELL pchpu_hvtdpsr
+ l=0.07U w=0.09U
M8460 XMC4X4_XMC2_2_BL_IN XMC4X4_XMC2_2_BLB_IN
+ VDD NWELL pchpu_hvtdpsr l=0.07U
+ w=0.09U
M8461 VDD XMC4X4_XMC2_3_BL_IN
+ XMC4X4_XMC2_3_BLB_IN NWELL pchpu_hvtdpsr
+ l=0.07U w=0.09U
M8462 VSS XMC4X4_XMC3_0_BLB_IN
+ XMC4X4_XMC3_0_BL_IN SUB nchpd_hvtdpsr
+ l=0.065U w=0.315U
M8463 VSS XMC4X4_XMC2_0_BLB_IN
+ XMC4X4_XMC2_0_BL_IN SUB nchpd_hvtdpsr
+ l=0.065U w=0.315U
M8464 B_BL_2 B_WL_1 XMC4X4_XMC2_1_BL_IN SUB
+ nchpg_hvtdpsr l=0.08U
+ w=0.105U
M8465 XMC4X4_XMC2_1_BLB_IN B_WL_1 B_BLB_2 SUB
+ nchpg_hvtdpsr l=0.08U
+ w=0.105U
M8466 XMC4X4_XMC3_1_BLB_IN B_WL_1 B_BLB_3 SUB
+ nchpg_hvtdpsr l=0.08U
+ w=0.105U
M8467 B_BL_3 B_WL_1 XMC4X4_XMC3_1_BL_IN SUB
+ nchpg_hvtdpsr l=0.08U
+ w=0.105U
M8468 XMC4X4_XMC3_2_BLB_IN B_WL_2 B_BLB_3 SUB
+ nchpg_hvtdpsr l=0.08U
+ w=0.105U
M8469 XMC4X4_XMC2_2_BLB_IN B_WL_2 B_BLB_2 SUB
+ nchpg_hvtdpsr l=0.08U
+ w=0.105U
M8470 B_BL_2 B_WL_2 XMC4X4_XMC2_2_BL_IN SUB
+ nchpg_hvtdpsr l=0.08U
+ w=0.105U
M8471 B_BL_3 B_WL_2 XMC4X4_XMC3_2_BL_IN SUB
+ nchpg_hvtdpsr l=0.08U
+ w=0.105U
M8472 B_BL_3 B_WL_3 XMC4X4_XMC3_3_BL_IN SUB
+ nchpg_hvtdpsr l=0.08U
+ w=0.105U
M8473 B_BL_2 B_WL_3 XMC4X4_XMC2_3_BL_IN SUB
+ nchpg_hvtdpsr l=0.08U
+ w=0.105U
M8474 XMC4X4_XMC2_3_BLB_IN B_WL_3 B_BLB_2 SUB
+ nchpg_hvtdpsr l=0.08U
+ w=0.105U
M8475 XMC4X4_XMC3_3_BLB_IN B_WL_3 B_BLB_3 SUB
+ nchpg_hvtdpsr l=0.08U
+ w=0.105U
M8476 B_BL_3 B_WL_0 XMC4X4_XMC3_0_BL_IN SUB
+ nchpg_hvtdpsr l=0.08U
+ w=0.105U
M8477 XMC4X4_XMC3_0_BLB_IN B_WL_0 B_BLB_3 SUB
+ nchpg_hvtdpsr l=0.08U
+ w=0.105U
M8478 XMC4X4_XMC2_0_BLB_IN B_WL_0 B_BLB_2 SUB
+ nchpg_hvtdpsr l=0.08U
+ w=0.105U
M8479 B_BL_2 B_WL_0 XMC4X4_XMC2_0_BL_IN SUB
+ nchpg_hvtdpsr l=0.08U
+ w=0.105U
M8480 VSS XMC4X4_XMC2_3_BLB_IN
+ XMC4X4_XMC2_3_BL_IN SUB nchpd_hvtdpsr
+ l=0.065U w=0.315U
M8481 VSS XMC4X4_XMC3_3_BLB_IN
+ XMC4X4_XMC3_3_BL_IN SUB nchpd_hvtdpsr
+ l=0.065U w=0.315U
M8482 VSS XMC4X4_XMC3_1_BLB_IN
+ XMC4X4_XMC3_1_BL_IN SUB nchpd_hvtdpsr
+ l=0.065U w=0.315U
M8483 VSS XMC4X4_XMC2_1_BLB_IN
+ XMC4X4_XMC2_1_BL_IN SUB nchpd_hvtdpsr
+ l=0.065U w=0.315U
M8484 VSS XMC4X4_XMC2_2_BLB_IN
+ XMC4X4_XMC2_2_BL_IN SUB nchpd_hvtdpsr
+ l=0.065U w=0.315U
M8485 VSS XMC4X4_XMC3_2_BLB_IN
+ XMC4X4_XMC3_2_BL_IN SUB nchpd_hvtdpsr
+ l=0.065U w=0.315U
M8486 XMC4X4_XMC3_0_BL_IN XMC4X4_XMC3_0_BLB_IN
+ VDD NWELL pchpu_hvtdpsr l=0.07U
+ w=0.09U
M8487 XMC4X4_XMC3_3_BL_IN XMC4X4_XMC3_3_BLB_IN
+ VDD NWELL pchpu_hvtdpsr l=0.07U
+ w=0.09U
M8488 VDD XMC4X4_XMC3_1_BL_IN
+ XMC4X4_XMC3_1_BLB_IN NWELL pchpu_hvtdpsr
+ l=0.07U w=0.09U
M8489 VDD XMC4X4_XMC3_0_BL_IN
+ XMC4X4_XMC3_0_BLB_IN NWELL pchpu_hvtdpsr
+ l=0.07U w=0.09U
M8490 XMC4X4_XMC3_1_BL_IN XMC4X4_XMC3_1_BLB_IN
+ VDD NWELL pchpu_hvtdpsr l=0.07U
+ w=0.09U
M8491 VDD XMC4X4_XMC3_2_BL_IN
+ XMC4X4_XMC3_2_BLB_IN NWELL pchpu_hvtdpsr
+ l=0.07U w=0.09U
M8492 XMC4X4_XMC3_2_BL_IN XMC4X4_XMC3_2_BLB_IN
+ VDD NWELL pchpu_hvtdpsr l=0.07U
+ w=0.09U
M8493 VDD XMC4X4_XMC3_3_BL_IN
+ XMC4X4_XMC3_3_BLB_IN NWELL pchpu_hvtdpsr
+ l=0.07U w=0.09U
M8494 XMC4X4_XMC3_0_BLB_IN A_WL_0 A_BLB_3 SUB
+ nchpg_hvtdpsr l=0.08U
+ w=0.105U
M8495 A_BL_3 A_WL_0 XMC4X4_XMC3_0_BL_IN SUB
+ nchpg_hvtdpsr l=0.08U
+ w=0.105U
M8496 XMC4X4_XMC3_3_BLB_IN A_WL_3 A_BLB_3 SUB
+ nchpg_hvtdpsr l=0.08U
+ w=0.105U
M8497 A_BL_3 A_WL_3 XMC4X4_XMC3_3_BL_IN SUB
+ nchpg_hvtdpsr l=0.08U
+ w=0.105U
M8498 A_BL_3 A_WL_1 XMC4X4_XMC3_1_BL_IN SUB
+ nchpg_hvtdpsr l=0.08U
+ w=0.105U
M8499 XMC4X4_XMC3_1_BLB_IN A_WL_1 A_BLB_3 SUB
+ nchpg_hvtdpsr l=0.08U
+ w=0.105U
M8500 A_BL_3 A_WL_2 XMC4X4_XMC3_2_BL_IN SUB
+ nchpg_hvtdpsr l=0.08U
+ w=0.105U
M8501 XMC4X4_XMC3_2_BLB_IN A_WL_2 A_BLB_3 SUB
+ nchpg_hvtdpsr l=0.08U
+ w=0.105U
M8502 XMC4X4_XMC3_1_BLB_IN XMC4X4_XMC3_1_BL_IN
+ VSS SUB nchpd_hvtdpsr l=0.065U
+ w=0.315U
M8503 XMC4X4_XMC3_0_BLB_IN XMC4X4_XMC3_0_BL_IN
+ VSS SUB nchpd_hvtdpsr l=0.065U
+ w=0.315U
M8504 XMC4X4_XMC3_2_BLB_IN XMC4X4_XMC3_2_BL_IN
+ VSS SUB nchpd_hvtdpsr l=0.065U
+ w=0.315U
M8505 XMC4X4_XMC3_3_BLB_IN XMC4X4_XMC3_3_BL_IN
+ VSS SUB nchpd_hvtdpsr l=0.065U
+ w=0.315U
.ENDS
* MC4X4V
.SUBCKT SDL400W20S_NMC4X4V A_WL_3 A_WL_2 A_WL_1 A_WL_0 A_WLS_3 A_WLS_2
+	 A_WLS_1 A_WLS_0 B_WL_3 B_WL_2 B_WL_1 B_WL_0 B_WLS_3 B_WLS_2
+	 B_WLS_1 B_WLS_0 NWELL SUB A_BL_3 A_BL_2 A_BL_1 A_BL_0 A_BLB_3
+	 A_BLB_2 A_BLB_1 A_BLB_0 B_BL_3 B_BL_2 B_BL_1 B_BL_0 B_BLB_3
+	 B_BLB_2 B_BLB_1 B_BLB_0 GFA_3 GFA_2 GFA_1 GFA_0 GFB_3 GFB_2
+	 GFB_1 GFB_0
M8506 XMC4X4_XMC0_0_BLB_IN XMC4X4_XMC0_0_BL_IN
+ VSS SUB nchpd_hvtdpsr l=0.065U
+ w=0.315U
M8507 XMC4X4_XMC0_1_BLB_IN A_WL_1 A_BLB_0 SUB
+ nchpg_hvtdpsr l=0.08U
+ w=0.105U
M8508 A_BL_0 A_WL_1 XMC4X4_XMC0_1_BL_IN SUB
+ nchpg_hvtdpsr l=0.08U
+ w=0.105U
M8509 A_BL_0 A_WL_2 XMC4X4_XMC0_2_BL_IN SUB
+ nchpg_hvtdpsr l=0.08U
+ w=0.105U
M8510 XMC4X4_XMC0_2_BLB_IN A_WL_2 A_BLB_0 SUB
+ nchpg_hvtdpsr l=0.08U
+ w=0.105U
M8511 XMC4X4_XMC0_3_BLB_IN A_WL_3 A_BLB_0 SUB
+ nchpg_hvtdpsr l=0.08U
+ w=0.105U
M8512 A_BL_0 A_WL_3 XMC4X4_XMC0_3_BL_IN SUB
+ nchpg_hvtdpsr l=0.08U
+ w=0.105U
M8513 A_BL_0 A_WL_0 XMC4X4_XMC0_0_BL_IN SUB
+ nchpg_hvtdpsr l=0.08U
+ w=0.105U
M8514 XMC4X4_XMC0_0_BLB_IN A_WL_0 A_BLB_0 SUB
+ nchpg_hvtdpsr l=0.08U
+ w=0.105U
M8515 XMC4X4_XMC0_3_BLB_IN XMC4X4_XMC0_3_BL_IN
+ VSS SUB nchpd_hvtdpsr l=0.065U
+ w=0.315U
M8516 XMC4X4_XMC0_1_BLB_IN XMC4X4_XMC0_1_BL_IN
+ VSS SUB nchpd_hvtdpsr l=0.065U
+ w=0.315U
M8517 XMC4X4_XMC0_2_BLB_IN XMC4X4_XMC0_2_BL_IN
+ VSS SUB nchpd_hvtdpsr l=0.065U
+ w=0.315U
M8518 VDD XMC4X4_XMC0_0_BL_IN
+ XMC4X4_XMC0_0_BLB_IN NWELL pchpu_hvtdpsr
+ l=0.07U w=0.09U
M8519 VDD XMC4X4_XMC0_3_BL_IN
+ XMC4X4_XMC0_3_BLB_IN NWELL pchpu_hvtdpsr
+ l=0.07U w=0.09U
M8520 XMC4X4_XMC0_1_BL_IN XMC4X4_XMC0_1_BLB_IN
+ VDD NWELL pchpu_hvtdpsr l=0.07U
+ w=0.09U
M8521 XMC4X4_XMC0_0_BL_IN XMC4X4_XMC0_0_BLB_IN
+ VDD NWELL pchpu_hvtdpsr l=0.07U
+ w=0.09U
M8522 VDD XMC4X4_XMC0_1_BL_IN
+ XMC4X4_XMC0_1_BLB_IN NWELL pchpu_hvtdpsr
+ l=0.07U w=0.09U
M8523 XMC4X4_XMC0_2_BL_IN XMC4X4_XMC0_2_BLB_IN
+ VDD NWELL pchpu_hvtdpsr l=0.07U
+ w=0.09U
M8524 VDD XMC4X4_XMC0_2_BL_IN
+ XMC4X4_XMC0_2_BLB_IN NWELL pchpu_hvtdpsr
+ l=0.07U w=0.09U
M8525 XMC4X4_XMC0_3_BL_IN XMC4X4_XMC0_3_BLB_IN
+ VDD NWELL pchpu_hvtdpsr l=0.07U
+ w=0.09U
M8526 B_BL_1 B_WL_0 XMC4X4_XMC1_0_BL_IN SUB
+ nchpg_hvtdpsr l=0.08U
+ w=0.105U
M8527 B_BL_0 B_WL_0 XMC4X4_XMC0_0_BL_IN SUB
+ nchpg_hvtdpsr l=0.08U
+ w=0.105U
M8528 XMC4X4_XMC0_0_BLB_IN B_WL_0 B_BLB_0 SUB
+ nchpg_hvtdpsr l=0.08U
+ w=0.105U
M8529 XMC4X4_XMC1_0_BLB_IN B_WL_0 B_BLB_1 SUB
+ nchpg_hvtdpsr l=0.08U
+ w=0.105U
M8530 B_BL_1 B_WL_3 XMC4X4_XMC1_3_BL_IN SUB
+ nchpg_hvtdpsr l=0.08U
+ w=0.105U
M8531 B_BL_0 B_WL_3 XMC4X4_XMC0_3_BL_IN SUB
+ nchpg_hvtdpsr l=0.08U
+ w=0.105U
M8532 XMC4X4_XMC0_3_BLB_IN B_WL_3 B_BLB_0 SUB
+ nchpg_hvtdpsr l=0.08U
+ w=0.105U
M8533 XMC4X4_XMC1_3_BLB_IN B_WL_3 B_BLB_1 SUB
+ nchpg_hvtdpsr l=0.08U
+ w=0.105U
M8534 B_BL_1 B_WL_1 XMC4X4_XMC1_1_BL_IN SUB
+ nchpg_hvtdpsr l=0.08U
+ w=0.105U
M8535 XMC4X4_XMC1_1_BLB_IN B_WL_1 B_BLB_1 SUB
+ nchpg_hvtdpsr l=0.08U
+ w=0.105U
M8536 B_BL_0 B_WL_1 XMC4X4_XMC0_1_BL_IN SUB
+ nchpg_hvtdpsr l=0.08U
+ w=0.105U
M8537 XMC4X4_XMC0_1_BLB_IN B_WL_1 B_BLB_0 SUB
+ nchpg_hvtdpsr l=0.08U
+ w=0.105U
M8538 B_BL_1 B_WL_2 XMC4X4_XMC1_2_BL_IN SUB
+ nchpg_hvtdpsr l=0.08U
+ w=0.105U
M8539 XMC4X4_XMC1_2_BLB_IN B_WL_2 B_BLB_1 SUB
+ nchpg_hvtdpsr l=0.08U
+ w=0.105U
M8540 B_BL_0 B_WL_2 XMC4X4_XMC0_2_BL_IN SUB
+ nchpg_hvtdpsr l=0.08U
+ w=0.105U
M8541 XMC4X4_XMC0_2_BLB_IN B_WL_2 B_BLB_0 SUB
+ nchpg_hvtdpsr l=0.08U
+ w=0.105U
M8542 VSS XMC4X4_XMC0_1_BLB_IN
+ XMC4X4_XMC0_1_BL_IN SUB nchpd_hvtdpsr
+ l=0.065U w=0.315U
M8543 VSS XMC4X4_XMC1_1_BLB_IN
+ XMC4X4_XMC1_1_BL_IN SUB nchpd_hvtdpsr
+ l=0.065U w=0.315U
M8544 VSS XMC4X4_XMC0_0_BLB_IN
+ XMC4X4_XMC0_0_BL_IN SUB nchpd_hvtdpsr
+ l=0.065U w=0.315U
M8545 VSS XMC4X4_XMC1_0_BLB_IN
+ XMC4X4_XMC1_0_BL_IN SUB nchpd_hvtdpsr
+ l=0.065U w=0.315U
M8546 VSS XMC4X4_XMC0_2_BLB_IN
+ XMC4X4_XMC0_2_BL_IN SUB nchpd_hvtdpsr
+ l=0.065U w=0.315U
M8547 VSS XMC4X4_XMC1_2_BLB_IN
+ XMC4X4_XMC1_2_BL_IN SUB nchpd_hvtdpsr
+ l=0.065U w=0.315U
M8548 VSS XMC4X4_XMC0_3_BLB_IN
+ XMC4X4_XMC0_3_BL_IN SUB nchpd_hvtdpsr
+ l=0.065U w=0.315U
M8549 VSS XMC4X4_XMC1_3_BLB_IN
+ XMC4X4_XMC1_3_BL_IN SUB nchpd_hvtdpsr
+ l=0.065U w=0.315U
M8550 VDD XMC4X4_XMC1_0_BL_IN
+ XMC4X4_XMC1_0_BLB_IN NWELL pchpu_hvtdpsr
+ l=0.07U w=0.09U
M8551 VDD XMC4X4_XMC1_3_BL_IN
+ XMC4X4_XMC1_3_BLB_IN NWELL pchpu_hvtdpsr
+ l=0.07U w=0.09U
M8552 XMC4X4_XMC1_1_BL_IN XMC4X4_XMC1_1_BLB_IN
+ VDD NWELL pchpu_hvtdpsr l=0.07U
+ w=0.09U
M8553 XMC4X4_XMC1_0_BL_IN XMC4X4_XMC1_0_BLB_IN
+ VDD NWELL pchpu_hvtdpsr l=0.07U
+ w=0.09U
M8554 VDD XMC4X4_XMC1_1_BL_IN
+ XMC4X4_XMC1_1_BLB_IN NWELL pchpu_hvtdpsr
+ l=0.07U w=0.09U
M8555 XMC4X4_XMC1_2_BL_IN XMC4X4_XMC1_2_BLB_IN
+ VDD NWELL pchpu_hvtdpsr l=0.07U
+ w=0.09U
M8556 VDD XMC4X4_XMC1_2_BL_IN
+ XMC4X4_XMC1_2_BLB_IN NWELL pchpu_hvtdpsr
+ l=0.07U w=0.09U
M8557 XMC4X4_XMC1_3_BL_IN XMC4X4_XMC1_3_BLB_IN
+ VDD NWELL pchpu_hvtdpsr l=0.07U
+ w=0.09U
M8558 XMC4X4_XMC1_0_BLB_IN XMC4X4_XMC1_0_BL_IN
+ VSS SUB nchpd_hvtdpsr l=0.065U
+ w=0.315U
M8559 XMC4X4_XMC2_0_BLB_IN XMC4X4_XMC2_0_BL_IN
+ VSS SUB nchpd_hvtdpsr l=0.065U
+ w=0.315U
M8560 XMC4X4_XMC1_1_BLB_IN A_WL_1 A_BLB_1 SUB
+ nchpg_hvtdpsr l=0.08U
+ w=0.105U
M8561 XMC4X4_XMC2_1_BLB_IN A_WL_1 A_BLB_2 SUB
+ nchpg_hvtdpsr l=0.08U
+ w=0.105U
M8562 A_BL_1 A_WL_1 XMC4X4_XMC1_1_BL_IN SUB
+ nchpg_hvtdpsr l=0.08U
+ w=0.105U
M8563 A_BL_2 A_WL_1 XMC4X4_XMC2_1_BL_IN SUB
+ nchpg_hvtdpsr l=0.08U
+ w=0.105U
M8564 A_BL_1 A_WL_2 XMC4X4_XMC1_2_BL_IN SUB
+ nchpg_hvtdpsr l=0.08U
+ w=0.105U
M8565 XMC4X4_XMC1_2_BLB_IN A_WL_2 A_BLB_1 SUB
+ nchpg_hvtdpsr l=0.08U
+ w=0.105U
M8566 A_BL_2 A_WL_2 XMC4X4_XMC2_2_BL_IN SUB
+ nchpg_hvtdpsr l=0.08U
+ w=0.105U
M8567 XMC4X4_XMC2_2_BLB_IN A_WL_2 A_BLB_2 SUB
+ nchpg_hvtdpsr l=0.08U
+ w=0.105U
M8568 XMC4X4_XMC2_3_BLB_IN A_WL_3 A_BLB_2 SUB
+ nchpg_hvtdpsr l=0.08U
+ w=0.105U
M8569 A_BL_2 A_WL_3 XMC4X4_XMC2_3_BL_IN SUB
+ nchpg_hvtdpsr l=0.08U
+ w=0.105U
M8570 XMC4X4_XMC1_3_BLB_IN A_WL_3 A_BLB_1 SUB
+ nchpg_hvtdpsr l=0.08U
+ w=0.105U
M8571 A_BL_1 A_WL_3 XMC4X4_XMC1_3_BL_IN SUB
+ nchpg_hvtdpsr l=0.08U
+ w=0.105U
M8572 A_BL_2 A_WL_0 XMC4X4_XMC2_0_BL_IN SUB
+ nchpg_hvtdpsr l=0.08U
+ w=0.105U
M8573 A_BL_1 A_WL_0 XMC4X4_XMC1_0_BL_IN SUB
+ nchpg_hvtdpsr l=0.08U
+ w=0.105U
M8574 XMC4X4_XMC2_0_BLB_IN A_WL_0 A_BLB_2 SUB
+ nchpg_hvtdpsr l=0.08U
+ w=0.105U
M8575 XMC4X4_XMC1_0_BLB_IN A_WL_0 A_BLB_1 SUB
+ nchpg_hvtdpsr l=0.08U
+ w=0.105U
M8576 XMC4X4_XMC1_3_BLB_IN XMC4X4_XMC1_3_BL_IN
+ VSS SUB nchpd_hvtdpsr l=0.065U
+ w=0.315U
M8577 XMC4X4_XMC2_3_BLB_IN XMC4X4_XMC2_3_BL_IN
+ VSS SUB nchpd_hvtdpsr l=0.065U
+ w=0.315U
M8578 XMC4X4_XMC2_1_BLB_IN XMC4X4_XMC2_1_BL_IN
+ VSS SUB nchpd_hvtdpsr l=0.065U
+ w=0.315U
M8579 XMC4X4_XMC1_1_BLB_IN XMC4X4_XMC1_1_BL_IN
+ VSS SUB nchpd_hvtdpsr l=0.065U
+ w=0.315U
M8580 XMC4X4_XMC2_2_BLB_IN XMC4X4_XMC2_2_BL_IN
+ VSS SUB nchpd_hvtdpsr l=0.065U
+ w=0.315U
M8581 XMC4X4_XMC1_2_BLB_IN XMC4X4_XMC1_2_BL_IN
+ VSS SUB nchpd_hvtdpsr l=0.065U
+ w=0.315U
M8582 VDD XMC4X4_XMC2_0_BL_IN
+ XMC4X4_XMC2_0_BLB_IN NWELL pchpu_hvtdpsr
+ l=0.07U w=0.09U
M8583 VDD XMC4X4_XMC2_3_BL_IN
+ XMC4X4_XMC2_3_BLB_IN NWELL pchpu_hvtdpsr
+ l=0.07U w=0.09U
M8584 XMC4X4_XMC2_1_BL_IN XMC4X4_XMC2_1_BLB_IN
+ VDD NWELL pchpu_hvtdpsr l=0.07U
+ w=0.09U
M8585 XMC4X4_XMC2_0_BL_IN XMC4X4_XMC2_0_BLB_IN
+ VDD NWELL pchpu_hvtdpsr l=0.07U
+ w=0.09U
M8586 VDD XMC4X4_XMC2_1_BL_IN
+ XMC4X4_XMC2_1_BLB_IN NWELL pchpu_hvtdpsr
+ l=0.07U w=0.09U
M8587 XMC4X4_XMC2_2_BL_IN XMC4X4_XMC2_2_BLB_IN
+ VDD NWELL pchpu_hvtdpsr l=0.07U
+ w=0.09U
M8588 VDD XMC4X4_XMC2_2_BL_IN
+ XMC4X4_XMC2_2_BLB_IN NWELL pchpu_hvtdpsr
+ l=0.07U w=0.09U
M8589 XMC4X4_XMC2_3_BL_IN XMC4X4_XMC2_3_BLB_IN
+ VDD NWELL pchpu_hvtdpsr l=0.07U
+ w=0.09U
M8590 B_BL_3 B_WL_0 XMC4X4_XMC3_0_BL_IN SUB
+ nchpg_hvtdpsr l=0.08U
+ w=0.105U
M8591 B_BL_2 B_WL_0 XMC4X4_XMC2_0_BL_IN SUB
+ nchpg_hvtdpsr l=0.08U
+ w=0.105U
M8592 XMC4X4_XMC3_0_BLB_IN B_WL_0 B_BLB_3 SUB
+ nchpg_hvtdpsr l=0.08U
+ w=0.105U
M8593 XMC4X4_XMC2_0_BLB_IN B_WL_0 B_BLB_2 SUB
+ nchpg_hvtdpsr l=0.08U
+ w=0.105U
M8594 B_BL_3 B_WL_3 XMC4X4_XMC3_3_BL_IN SUB
+ nchpg_hvtdpsr l=0.08U
+ w=0.105U
M8595 B_BL_2 B_WL_3 XMC4X4_XMC2_3_BL_IN SUB
+ nchpg_hvtdpsr l=0.08U
+ w=0.105U
M8596 XMC4X4_XMC3_3_BLB_IN B_WL_3 B_BLB_3 SUB
+ nchpg_hvtdpsr l=0.08U
+ w=0.105U
M8597 XMC4X4_XMC2_3_BLB_IN B_WL_3 B_BLB_2 SUB
+ nchpg_hvtdpsr l=0.08U
+ w=0.105U
M8598 B_BL_3 B_WL_1 XMC4X4_XMC3_1_BL_IN SUB
+ nchpg_hvtdpsr l=0.08U
+ w=0.105U
M8599 B_BL_2 B_WL_1 XMC4X4_XMC2_1_BL_IN SUB
+ nchpg_hvtdpsr l=0.08U
+ w=0.105U
M8600 XMC4X4_XMC2_1_BLB_IN B_WL_1 B_BLB_2 SUB
+ nchpg_hvtdpsr l=0.08U
+ w=0.105U
M8601 XMC4X4_XMC3_1_BLB_IN B_WL_1 B_BLB_3 SUB
+ nchpg_hvtdpsr l=0.08U
+ w=0.105U
M8602 B_BL_3 B_WL_2 XMC4X4_XMC3_2_BL_IN SUB
+ nchpg_hvtdpsr l=0.08U
+ w=0.105U
M8603 B_BL_2 B_WL_2 XMC4X4_XMC2_2_BL_IN SUB
+ nchpg_hvtdpsr l=0.08U
+ w=0.105U
M8604 XMC4X4_XMC2_2_BLB_IN B_WL_2 B_BLB_2 SUB
+ nchpg_hvtdpsr l=0.08U
+ w=0.105U
M8605 XMC4X4_XMC3_2_BLB_IN B_WL_2 B_BLB_3 SUB
+ nchpg_hvtdpsr l=0.08U
+ w=0.105U
M8606 VSS XMC4X4_XMC3_1_BLB_IN
+ XMC4X4_XMC3_1_BL_IN SUB nchpd_hvtdpsr
+ l=0.065U w=0.315U
M8607 VSS XMC4X4_XMC2_1_BLB_IN
+ XMC4X4_XMC2_1_BL_IN SUB nchpd_hvtdpsr
+ l=0.065U w=0.315U
M8608 VSS XMC4X4_XMC3_0_BLB_IN
+ XMC4X4_XMC3_0_BL_IN SUB nchpd_hvtdpsr
+ l=0.065U w=0.315U
M8609 VSS XMC4X4_XMC2_0_BLB_IN
+ XMC4X4_XMC2_0_BL_IN SUB nchpd_hvtdpsr
+ l=0.065U w=0.315U
M8610 VSS XMC4X4_XMC3_2_BLB_IN
+ XMC4X4_XMC3_2_BL_IN SUB nchpd_hvtdpsr
+ l=0.065U w=0.315U
M8611 VSS XMC4X4_XMC2_2_BLB_IN
+ XMC4X4_XMC2_2_BL_IN SUB nchpd_hvtdpsr
+ l=0.065U w=0.315U
M8612 VSS XMC4X4_XMC3_3_BLB_IN
+ XMC4X4_XMC3_3_BL_IN SUB nchpd_hvtdpsr
+ l=0.065U w=0.315U
M8613 VSS XMC4X4_XMC2_3_BLB_IN
+ XMC4X4_XMC2_3_BL_IN SUB nchpd_hvtdpsr
+ l=0.065U w=0.315U
M8614 VDD XMC4X4_XMC3_0_BL_IN
+ XMC4X4_XMC3_0_BLB_IN NWELL pchpu_hvtdpsr
+ l=0.07U w=0.09U
M8615 VDD XMC4X4_XMC3_3_BL_IN
+ XMC4X4_XMC3_3_BLB_IN NWELL pchpu_hvtdpsr
+ l=0.07U w=0.09U
M8616 XMC4X4_XMC3_1_BL_IN XMC4X4_XMC3_1_BLB_IN
+ VDD NWELL pchpu_hvtdpsr l=0.07U
+ w=0.09U
M8617 XMC4X4_XMC3_0_BL_IN XMC4X4_XMC3_0_BLB_IN
+ VDD NWELL pchpu_hvtdpsr l=0.07U
+ w=0.09U
M8618 VDD XMC4X4_XMC3_1_BL_IN
+ XMC4X4_XMC3_1_BLB_IN NWELL pchpu_hvtdpsr
+ l=0.07U w=0.09U
M8619 XMC4X4_XMC3_2_BL_IN XMC4X4_XMC3_2_BLB_IN
+ VDD NWELL pchpu_hvtdpsr l=0.07U
+ w=0.09U
M8620 VDD XMC4X4_XMC3_2_BL_IN
+ XMC4X4_XMC3_2_BLB_IN NWELL pchpu_hvtdpsr
+ l=0.07U w=0.09U
M8621 XMC4X4_XMC3_3_BL_IN XMC4X4_XMC3_3_BLB_IN
+ VDD NWELL pchpu_hvtdpsr l=0.07U
+ w=0.09U
M8622 XMC4X4_XMC3_0_BLB_IN XMC4X4_XMC3_0_BL_IN
+ VSS SUB nchpd_hvtdpsr l=0.065U
+ w=0.315U
M8623 XMC4X4_XMC3_1_BLB_IN A_WL_1 A_BLB_3 SUB
+ nchpg_hvtdpsr l=0.08U
+ w=0.105U
M8624 A_BL_3 A_WL_1 XMC4X4_XMC3_1_BL_IN SUB
+ nchpg_hvtdpsr l=0.08U
+ w=0.105U
M8625 A_BL_3 A_WL_2 XMC4X4_XMC3_2_BL_IN SUB
+ nchpg_hvtdpsr l=0.08U
+ w=0.105U
M8626 XMC4X4_XMC3_2_BLB_IN A_WL_2 A_BLB_3 SUB
+ nchpg_hvtdpsr l=0.08U
+ w=0.105U
M8627 XMC4X4_XMC3_3_BLB_IN A_WL_3 A_BLB_3 SUB
+ nchpg_hvtdpsr l=0.08U
+ w=0.105U
M8628 A_BL_3 A_WL_3 XMC4X4_XMC3_3_BL_IN SUB
+ nchpg_hvtdpsr l=0.08U
+ w=0.105U
M8629 A_BL_3 A_WL_0 XMC4X4_XMC3_0_BL_IN SUB
+ nchpg_hvtdpsr l=0.08U
+ w=0.105U
M8630 XMC4X4_XMC3_0_BLB_IN A_WL_0 A_BLB_3 SUB
+ nchpg_hvtdpsr l=0.08U
+ w=0.105U
M8631 XMC4X4_XMC3_3_BLB_IN XMC4X4_XMC3_3_BL_IN
+ VSS SUB nchpd_hvtdpsr l=0.065U
+ w=0.315U
M8632 XMC4X4_XMC3_1_BLB_IN XMC4X4_XMC3_1_BL_IN
+ VSS SUB nchpd_hvtdpsr l=0.065U
+ w=0.315U
M8633 XMC4X4_XMC3_2_BLB_IN XMC4X4_XMC3_2_BL_IN
+ VSS SUB nchpd_hvtdpsr l=0.065U
+ w=0.315U
.ENDS
* MC4X4VF
.SUBCKT SDL400W20S_NMC4X4VF A_WL_3 A_WL_2 A_WL_1 A_WL_0 A_WLS_3 A_WLS_2
+	 A_WLS_1 A_WLS_0 B_WL_3 B_WL_2 B_WL_1 B_WL_0 B_WLS_3 B_WLS_2
+	 B_WLS_1 B_WLS_0 NWELL SUB A_BL_3 A_BL_2 A_BL_1 A_BL_0 A_BLB_3
+	 A_BLB_2 A_BLB_1 A_BLB_0 B_BL_3 B_BL_2 B_BL_1 B_BL_0 B_BLB_3
+	 B_BLB_2 B_BLB_1 B_BLB_0 GFA_3 GFA_2 GFA_1 GFA_0 GFB_3 GFB_2
+	 GFB_1 GFB_0
M8634 XMC4X4_XMC0_0_BLB_IN A_WL_0 A_BLB_0 SUB
+ nchpg_hvtdpsr l=0.08U
+ w=0.105U
M8635 A_BL_0 A_WL_0 XMC4X4_XMC0_0_BL_IN SUB
+ nchpg_hvtdpsr l=0.08U
+ w=0.105U
M8636 XMC4X4_XMC0_3_BLB_IN A_WL_3 A_BLB_0 SUB
+ nchpg_hvtdpsr l=0.08U
+ w=0.105U
M8637 A_BL_0 A_WL_3 XMC4X4_XMC0_3_BL_IN SUB
+ nchpg_hvtdpsr l=0.08U
+ w=0.105U
M8638 A_BL_0 A_WL_1 XMC4X4_XMC0_1_BL_IN SUB
+ nchpg_hvtdpsr l=0.08U
+ w=0.105U
M8639 XMC4X4_XMC0_1_BLB_IN A_WL_1 A_BLB_0 SUB
+ nchpg_hvtdpsr l=0.08U
+ w=0.105U
M8640 A_BL_0 A_WL_2 XMC4X4_XMC0_2_BL_IN SUB
+ nchpg_hvtdpsr l=0.08U
+ w=0.105U
M8641 XMC4X4_XMC0_2_BLB_IN A_WL_2 A_BLB_0 SUB
+ nchpg_hvtdpsr l=0.08U
+ w=0.105U
M8642 XMC4X4_XMC0_1_BLB_IN XMC4X4_XMC0_1_BL_IN
+ VSS SUB nchpd_hvtdpsr l=0.065U
+ w=0.315U
M8643 XMC4X4_XMC0_0_BLB_IN XMC4X4_XMC0_0_BL_IN
+ VSS SUB nchpd_hvtdpsr l=0.065U
+ w=0.315U
M8644 XMC4X4_XMC0_2_BLB_IN XMC4X4_XMC0_2_BL_IN
+ VSS SUB nchpd_hvtdpsr l=0.065U
+ w=0.315U
M8645 XMC4X4_XMC0_3_BLB_IN XMC4X4_XMC0_3_BL_IN
+ VSS SUB nchpd_hvtdpsr l=0.065U
+ w=0.315U
M8646 XMC4X4_XMC0_0_BL_IN XMC4X4_XMC0_0_BLB_IN
+ VDD NWELL pchpu_hvtdpsr l=0.07U
+ w=0.09U
M8647 XMC4X4_XMC0_3_BL_IN XMC4X4_XMC0_3_BLB_IN
+ VDD NWELL pchpu_hvtdpsr l=0.07U
+ w=0.09U
M8648 VDD XMC4X4_XMC0_1_BL_IN
+ XMC4X4_XMC0_1_BLB_IN NWELL pchpu_hvtdpsr
+ l=0.07U w=0.09U
M8649 VDD XMC4X4_XMC0_0_BL_IN
+ XMC4X4_XMC0_0_BLB_IN NWELL pchpu_hvtdpsr
+ l=0.07U w=0.09U
M8650 XMC4X4_XMC0_1_BL_IN XMC4X4_XMC0_1_BLB_IN
+ VDD NWELL pchpu_hvtdpsr l=0.07U
+ w=0.09U
M8651 VDD XMC4X4_XMC0_2_BL_IN
+ XMC4X4_XMC0_2_BLB_IN NWELL pchpu_hvtdpsr
+ l=0.07U w=0.09U
M8652 XMC4X4_XMC0_2_BL_IN XMC4X4_XMC0_2_BLB_IN
+ VDD NWELL pchpu_hvtdpsr l=0.07U
+ w=0.09U
M8653 VDD XMC4X4_XMC0_3_BL_IN
+ XMC4X4_XMC0_3_BLB_IN NWELL pchpu_hvtdpsr
+ l=0.07U w=0.09U
M8654 VSS XMC4X4_XMC0_0_BLB_IN
+ XMC4X4_XMC0_0_BL_IN SUB nchpd_hvtdpsr
+ l=0.065U w=0.315U
M8655 VSS XMC4X4_XMC1_0_BLB_IN
+ XMC4X4_XMC1_0_BL_IN SUB nchpd_hvtdpsr
+ l=0.065U w=0.315U
M8656 B_BL_0 B_WL_1 XMC4X4_XMC0_1_BL_IN SUB
+ nchpg_hvtdpsr l=0.08U
+ w=0.105U
M8657 B_BL_1 B_WL_1 XMC4X4_XMC1_1_BL_IN SUB
+ nchpg_hvtdpsr l=0.08U
+ w=0.105U
M8658 XMC4X4_XMC1_1_BLB_IN B_WL_1 B_BLB_1 SUB
+ nchpg_hvtdpsr l=0.08U
+ w=0.105U
M8659 XMC4X4_XMC0_1_BLB_IN B_WL_1 B_BLB_0 SUB
+ nchpg_hvtdpsr l=0.08U
+ w=0.105U
M8660 XMC4X4_XMC0_2_BLB_IN B_WL_2 B_BLB_0 SUB
+ nchpg_hvtdpsr l=0.08U
+ w=0.105U
M8661 B_BL_0 B_WL_2 XMC4X4_XMC0_2_BL_IN SUB
+ nchpg_hvtdpsr l=0.08U
+ w=0.105U
M8662 XMC4X4_XMC1_2_BLB_IN B_WL_2 B_BLB_1 SUB
+ nchpg_hvtdpsr l=0.08U
+ w=0.105U
M8663 B_BL_1 B_WL_2 XMC4X4_XMC1_2_BL_IN SUB
+ nchpg_hvtdpsr l=0.08U
+ w=0.105U
M8664 B_BL_1 B_WL_3 XMC4X4_XMC1_3_BL_IN SUB
+ nchpg_hvtdpsr l=0.08U
+ w=0.105U
M8665 XMC4X4_XMC1_3_BLB_IN B_WL_3 B_BLB_1 SUB
+ nchpg_hvtdpsr l=0.08U
+ w=0.105U
M8666 B_BL_0 B_WL_3 XMC4X4_XMC0_3_BL_IN SUB
+ nchpg_hvtdpsr l=0.08U
+ w=0.105U
M8667 XMC4X4_XMC0_3_BLB_IN B_WL_3 B_BLB_0 SUB
+ nchpg_hvtdpsr l=0.08U
+ w=0.105U
M8668 XMC4X4_XMC0_0_BLB_IN B_WL_0 B_BLB_0 SUB
+ nchpg_hvtdpsr l=0.08U
+ w=0.105U
M8669 XMC4X4_XMC1_0_BLB_IN B_WL_0 B_BLB_1 SUB
+ nchpg_hvtdpsr l=0.08U
+ w=0.105U
M8670 B_BL_1 B_WL_0 XMC4X4_XMC1_0_BL_IN SUB
+ nchpg_hvtdpsr l=0.08U
+ w=0.105U
M8671 B_BL_0 B_WL_0 XMC4X4_XMC0_0_BL_IN SUB
+ nchpg_hvtdpsr l=0.08U
+ w=0.105U
M8672 VSS XMC4X4_XMC1_3_BLB_IN
+ XMC4X4_XMC1_3_BL_IN SUB nchpd_hvtdpsr
+ l=0.065U w=0.315U
M8673 VSS XMC4X4_XMC0_3_BLB_IN
+ XMC4X4_XMC0_3_BL_IN SUB nchpd_hvtdpsr
+ l=0.065U w=0.315U
M8674 VSS XMC4X4_XMC0_1_BLB_IN
+ XMC4X4_XMC0_1_BL_IN SUB nchpd_hvtdpsr
+ l=0.065U w=0.315U
M8675 VSS XMC4X4_XMC1_1_BLB_IN
+ XMC4X4_XMC1_1_BL_IN SUB nchpd_hvtdpsr
+ l=0.065U w=0.315U
M8676 VSS XMC4X4_XMC1_2_BLB_IN
+ XMC4X4_XMC1_2_BL_IN SUB nchpd_hvtdpsr
+ l=0.065U w=0.315U
M8677 VSS XMC4X4_XMC0_2_BLB_IN
+ XMC4X4_XMC0_2_BL_IN SUB nchpd_hvtdpsr
+ l=0.065U w=0.315U
M8678 XMC4X4_XMC1_0_BL_IN XMC4X4_XMC1_0_BLB_IN
+ VDD NWELL pchpu_hvtdpsr l=0.07U
+ w=0.09U
M8679 XMC4X4_XMC1_3_BL_IN XMC4X4_XMC1_3_BLB_IN
+ VDD NWELL pchpu_hvtdpsr l=0.07U
+ w=0.09U
M8680 VDD XMC4X4_XMC1_1_BL_IN
+ XMC4X4_XMC1_1_BLB_IN NWELL pchpu_hvtdpsr
+ l=0.07U w=0.09U
M8681 VDD XMC4X4_XMC1_0_BL_IN
+ XMC4X4_XMC1_0_BLB_IN NWELL pchpu_hvtdpsr
+ l=0.07U w=0.09U
M8682 XMC4X4_XMC1_1_BL_IN XMC4X4_XMC1_1_BLB_IN
+ VDD NWELL pchpu_hvtdpsr l=0.07U
+ w=0.09U
M8683 VDD XMC4X4_XMC1_2_BL_IN
+ XMC4X4_XMC1_2_BLB_IN NWELL pchpu_hvtdpsr
+ l=0.07U w=0.09U
M8684 XMC4X4_XMC1_2_BL_IN XMC4X4_XMC1_2_BLB_IN
+ VDD NWELL pchpu_hvtdpsr l=0.07U
+ w=0.09U
M8685 VDD XMC4X4_XMC1_3_BL_IN
+ XMC4X4_XMC1_3_BLB_IN NWELL pchpu_hvtdpsr
+ l=0.07U w=0.09U
M8686 XMC4X4_XMC2_0_BLB_IN A_WL_0 A_BLB_2 SUB
+ nchpg_hvtdpsr l=0.08U
+ w=0.105U
M8687 XMC4X4_XMC1_0_BLB_IN A_WL_0 A_BLB_1 SUB
+ nchpg_hvtdpsr l=0.08U
+ w=0.105U
M8688 A_BL_1 A_WL_0 XMC4X4_XMC1_0_BL_IN SUB
+ nchpg_hvtdpsr l=0.08U
+ w=0.105U
M8689 A_BL_2 A_WL_0 XMC4X4_XMC2_0_BL_IN SUB
+ nchpg_hvtdpsr l=0.08U
+ w=0.105U
M8690 XMC4X4_XMC2_3_BLB_IN A_WL_3 A_BLB_2 SUB
+ nchpg_hvtdpsr l=0.08U
+ w=0.105U
M8691 XMC4X4_XMC1_3_BLB_IN A_WL_3 A_BLB_1 SUB
+ nchpg_hvtdpsr l=0.08U
+ w=0.105U
M8692 A_BL_2 A_WL_3 XMC4X4_XMC2_3_BL_IN SUB
+ nchpg_hvtdpsr l=0.08U
+ w=0.105U
M8693 A_BL_1 A_WL_3 XMC4X4_XMC1_3_BL_IN SUB
+ nchpg_hvtdpsr l=0.08U
+ w=0.105U
M8694 A_BL_2 A_WL_1 XMC4X4_XMC2_1_BL_IN SUB
+ nchpg_hvtdpsr l=0.08U
+ w=0.105U
M8695 A_BL_1 A_WL_1 XMC4X4_XMC1_1_BL_IN SUB
+ nchpg_hvtdpsr l=0.08U
+ w=0.105U
M8696 XMC4X4_XMC2_1_BLB_IN A_WL_1 A_BLB_2 SUB
+ nchpg_hvtdpsr l=0.08U
+ w=0.105U
M8697 XMC4X4_XMC1_1_BLB_IN A_WL_1 A_BLB_1 SUB
+ nchpg_hvtdpsr l=0.08U
+ w=0.105U
M8698 A_BL_2 A_WL_2 XMC4X4_XMC2_2_BL_IN SUB
+ nchpg_hvtdpsr l=0.08U
+ w=0.105U
M8699 A_BL_1 A_WL_2 XMC4X4_XMC1_2_BL_IN SUB
+ nchpg_hvtdpsr l=0.08U
+ w=0.105U
M8700 XMC4X4_XMC2_2_BLB_IN A_WL_2 A_BLB_2 SUB
+ nchpg_hvtdpsr l=0.08U
+ w=0.105U
M8701 XMC4X4_XMC1_2_BLB_IN A_WL_2 A_BLB_1 SUB
+ nchpg_hvtdpsr l=0.08U
+ w=0.105U
M8702 XMC4X4_XMC2_1_BLB_IN XMC4X4_XMC2_1_BL_IN
+ VSS SUB nchpd_hvtdpsr l=0.065U
+ w=0.315U
M8703 XMC4X4_XMC1_1_BLB_IN XMC4X4_XMC1_1_BL_IN
+ VSS SUB nchpd_hvtdpsr l=0.065U
+ w=0.315U
M8704 XMC4X4_XMC1_0_BLB_IN XMC4X4_XMC1_0_BL_IN
+ VSS SUB nchpd_hvtdpsr l=0.065U
+ w=0.315U
M8705 XMC4X4_XMC2_0_BLB_IN XMC4X4_XMC2_0_BL_IN
+ VSS SUB nchpd_hvtdpsr l=0.065U
+ w=0.315U
M8706 XMC4X4_XMC1_2_BLB_IN XMC4X4_XMC1_2_BL_IN
+ VSS SUB nchpd_hvtdpsr l=0.065U
+ w=0.315U
M8707 XMC4X4_XMC2_2_BLB_IN XMC4X4_XMC2_2_BL_IN
+ VSS SUB nchpd_hvtdpsr l=0.065U
+ w=0.315U
M8708 XMC4X4_XMC2_3_BLB_IN XMC4X4_XMC2_3_BL_IN
+ VSS SUB nchpd_hvtdpsr l=0.065U
+ w=0.315U
M8709 XMC4X4_XMC1_3_BLB_IN XMC4X4_XMC1_3_BL_IN
+ VSS SUB nchpd_hvtdpsr l=0.065U
+ w=0.315U
M8710 XMC4X4_XMC2_0_BL_IN XMC4X4_XMC2_0_BLB_IN
+ VDD NWELL pchpu_hvtdpsr l=0.07U
+ w=0.09U
M8711 XMC4X4_XMC2_3_BL_IN XMC4X4_XMC2_3_BLB_IN
+ VDD NWELL pchpu_hvtdpsr l=0.07U
+ w=0.09U
M8712 VDD XMC4X4_XMC2_1_BL_IN
+ XMC4X4_XMC2_1_BLB_IN NWELL pchpu_hvtdpsr
+ l=0.07U w=0.09U
M8713 VDD XMC4X4_XMC2_0_BL_IN
+ XMC4X4_XMC2_0_BLB_IN NWELL pchpu_hvtdpsr
+ l=0.07U w=0.09U
M8714 XMC4X4_XMC2_1_BL_IN XMC4X4_XMC2_1_BLB_IN
+ VDD NWELL pchpu_hvtdpsr l=0.07U
+ w=0.09U
M8715 VDD XMC4X4_XMC2_2_BL_IN
+ XMC4X4_XMC2_2_BLB_IN NWELL pchpu_hvtdpsr
+ l=0.07U w=0.09U
M8716 XMC4X4_XMC2_2_BL_IN XMC4X4_XMC2_2_BLB_IN
+ VDD NWELL pchpu_hvtdpsr l=0.07U
+ w=0.09U
M8717 VDD XMC4X4_XMC2_3_BL_IN
+ XMC4X4_XMC2_3_BLB_IN NWELL pchpu_hvtdpsr
+ l=0.07U w=0.09U
M8718 VSS XMC4X4_XMC3_0_BLB_IN
+ XMC4X4_XMC3_0_BL_IN SUB nchpd_hvtdpsr
+ l=0.065U w=0.315U
M8719 VSS XMC4X4_XMC2_0_BLB_IN
+ XMC4X4_XMC2_0_BL_IN SUB nchpd_hvtdpsr
+ l=0.065U w=0.315U
M8720 B_BL_2 B_WL_1 XMC4X4_XMC2_1_BL_IN SUB
+ nchpg_hvtdpsr l=0.08U
+ w=0.105U
M8721 XMC4X4_XMC2_1_BLB_IN B_WL_1 B_BLB_2 SUB
+ nchpg_hvtdpsr l=0.08U
+ w=0.105U
M8722 XMC4X4_XMC3_1_BLB_IN B_WL_1 B_BLB_3 SUB
+ nchpg_hvtdpsr l=0.08U
+ w=0.105U
M8723 B_BL_3 B_WL_1 XMC4X4_XMC3_1_BL_IN SUB
+ nchpg_hvtdpsr l=0.08U
+ w=0.105U
M8724 XMC4X4_XMC3_2_BLB_IN B_WL_2 B_BLB_3 SUB
+ nchpg_hvtdpsr l=0.08U
+ w=0.105U
M8725 XMC4X4_XMC2_2_BLB_IN B_WL_2 B_BLB_2 SUB
+ nchpg_hvtdpsr l=0.08U
+ w=0.105U
M8726 B_BL_2 B_WL_2 XMC4X4_XMC2_2_BL_IN SUB
+ nchpg_hvtdpsr l=0.08U
+ w=0.105U
M8727 B_BL_3 B_WL_2 XMC4X4_XMC3_2_BL_IN SUB
+ nchpg_hvtdpsr l=0.08U
+ w=0.105U
M8728 B_BL_3 B_WL_3 XMC4X4_XMC3_3_BL_IN SUB
+ nchpg_hvtdpsr l=0.08U
+ w=0.105U
M8729 B_BL_2 B_WL_3 XMC4X4_XMC2_3_BL_IN SUB
+ nchpg_hvtdpsr l=0.08U
+ w=0.105U
M8730 XMC4X4_XMC2_3_BLB_IN B_WL_3 B_BLB_2 SUB
+ nchpg_hvtdpsr l=0.08U
+ w=0.105U
M8731 XMC4X4_XMC3_3_BLB_IN B_WL_3 B_BLB_3 SUB
+ nchpg_hvtdpsr l=0.08U
+ w=0.105U
M8732 B_BL_3 B_WL_0 XMC4X4_XMC3_0_BL_IN SUB
+ nchpg_hvtdpsr l=0.08U
+ w=0.105U
M8733 XMC4X4_XMC3_0_BLB_IN B_WL_0 B_BLB_3 SUB
+ nchpg_hvtdpsr l=0.08U
+ w=0.105U
M8734 XMC4X4_XMC2_0_BLB_IN B_WL_0 B_BLB_2 SUB
+ nchpg_hvtdpsr l=0.08U
+ w=0.105U
M8735 B_BL_2 B_WL_0 XMC4X4_XMC2_0_BL_IN SUB
+ nchpg_hvtdpsr l=0.08U
+ w=0.105U
M8736 VSS XMC4X4_XMC2_3_BLB_IN
+ XMC4X4_XMC2_3_BL_IN SUB nchpd_hvtdpsr
+ l=0.065U w=0.315U
M8737 VSS XMC4X4_XMC3_3_BLB_IN
+ XMC4X4_XMC3_3_BL_IN SUB nchpd_hvtdpsr
+ l=0.065U w=0.315U
M8738 VSS XMC4X4_XMC3_1_BLB_IN
+ XMC4X4_XMC3_1_BL_IN SUB nchpd_hvtdpsr
+ l=0.065U w=0.315U
M8739 VSS XMC4X4_XMC2_1_BLB_IN
+ XMC4X4_XMC2_1_BL_IN SUB nchpd_hvtdpsr
+ l=0.065U w=0.315U
M8740 VSS XMC4X4_XMC2_2_BLB_IN
+ XMC4X4_XMC2_2_BL_IN SUB nchpd_hvtdpsr
+ l=0.065U w=0.315U
M8741 VSS XMC4X4_XMC3_2_BLB_IN
+ XMC4X4_XMC3_2_BL_IN SUB nchpd_hvtdpsr
+ l=0.065U w=0.315U
M8742 XMC4X4_XMC3_0_BL_IN XMC4X4_XMC3_0_BLB_IN
+ VDD NWELL pchpu_hvtdpsr l=0.07U
+ w=0.09U
M8743 XMC4X4_XMC3_3_BL_IN XMC4X4_XMC3_3_BLB_IN
+ VDD NWELL pchpu_hvtdpsr l=0.07U
+ w=0.09U
M8744 VDD XMC4X4_XMC3_1_BL_IN
+ XMC4X4_XMC3_1_BLB_IN NWELL pchpu_hvtdpsr
+ l=0.07U w=0.09U
M8745 VDD XMC4X4_XMC3_0_BL_IN
+ XMC4X4_XMC3_0_BLB_IN NWELL pchpu_hvtdpsr
+ l=0.07U w=0.09U
M8746 XMC4X4_XMC3_1_BL_IN XMC4X4_XMC3_1_BLB_IN
+ VDD NWELL pchpu_hvtdpsr l=0.07U
+ w=0.09U
M8747 VDD XMC4X4_XMC3_2_BL_IN
+ XMC4X4_XMC3_2_BLB_IN NWELL pchpu_hvtdpsr
+ l=0.07U w=0.09U
M8748 XMC4X4_XMC3_2_BL_IN XMC4X4_XMC3_2_BLB_IN
+ VDD NWELL pchpu_hvtdpsr l=0.07U
+ w=0.09U
M8749 VDD XMC4X4_XMC3_3_BL_IN
+ XMC4X4_XMC3_3_BLB_IN NWELL pchpu_hvtdpsr
+ l=0.07U w=0.09U
M8750 XMC4X4_XMC3_0_BLB_IN A_WL_0 A_BLB_3 SUB
+ nchpg_hvtdpsr l=0.08U
+ w=0.105U
M8751 A_BL_3 A_WL_0 XMC4X4_XMC3_0_BL_IN SUB
+ nchpg_hvtdpsr l=0.08U
+ w=0.105U
M8752 XMC4X4_XMC3_3_BLB_IN A_WL_3 A_BLB_3 SUB
+ nchpg_hvtdpsr l=0.08U
+ w=0.105U
M8753 A_BL_3 A_WL_3 XMC4X4_XMC3_3_BL_IN SUB
+ nchpg_hvtdpsr l=0.08U
+ w=0.105U
M8754 A_BL_3 A_WL_1 XMC4X4_XMC3_1_BL_IN SUB
+ nchpg_hvtdpsr l=0.08U
+ w=0.105U
M8755 XMC4X4_XMC3_1_BLB_IN A_WL_1 A_BLB_3 SUB
+ nchpg_hvtdpsr l=0.08U
+ w=0.105U
M8756 A_BL_3 A_WL_2 XMC4X4_XMC3_2_BL_IN SUB
+ nchpg_hvtdpsr l=0.08U
+ w=0.105U
M8757 XMC4X4_XMC3_2_BLB_IN A_WL_2 A_BLB_3 SUB
+ nchpg_hvtdpsr l=0.08U
+ w=0.105U
M8758 XMC4X4_XMC3_1_BLB_IN XMC4X4_XMC3_1_BL_IN
+ VSS SUB nchpd_hvtdpsr l=0.065U
+ w=0.315U
M8759 XMC4X4_XMC3_0_BLB_IN XMC4X4_XMC3_0_BL_IN
+ VSS SUB nchpd_hvtdpsr l=0.065U
+ w=0.315U
M8760 XMC4X4_XMC3_2_BLB_IN XMC4X4_XMC3_2_BL_IN
+ VSS SUB nchpd_hvtdpsr l=0.065U
+ w=0.315U
M8761 XMC4X4_XMC3_3_BLB_IN XMC4X4_XMC3_3_BL_IN
+ VSS SUB nchpd_hvtdpsr l=0.065U
+ w=0.315U
.ENDS
* MC4X4VT
.SUBCKT SDL400W20S_NMC4X4VT A_WL_3 A_WL_2 A_WL_1 A_WL_0 B_WL_3 B_WL_2
+	 B_WL_1 B_WL_0 NWELL SUB A_BL_3 A_BL_2 A_BL_1 A_BL_0 A_BLB_3
+	 A_BLB_2 A_BLB_1 A_BLB_0 B_BL_3 B_BL_2 B_BL_1 B_BL_0 B_BLB_3
+	 B_BLB_2 B_BLB_1 B_BLB_0 GFA_3 GFA_2 GFA_1 GFA_0 GFB_3 GFB_2
+	 GFB_1 GFB_0
M8762 XMC4X4_XMC0_0_BLB_IN XMC4X4_XMC0_0_BL_IN
+ VSS SUB nchpd_hvtdpsr l=0.065U
+ w=0.315U
M8763 XMC4X4_XMC0_1_BLB_IN A_WL_1 A_BLB_0 SUB
+ nchpg_hvtdpsr l=0.08U
+ w=0.105U
M8764 A_BL_0 A_WL_1 XMC4X4_XMC0_1_BL_IN SUB
+ nchpg_hvtdpsr l=0.08U
+ w=0.105U
M8765 A_BL_0 A_WL_2 XMC4X4_XMC0_2_BL_IN SUB
+ nchpg_hvtdpsr l=0.08U
+ w=0.105U
M8766 XMC4X4_XMC0_2_BLB_IN A_WL_2 A_BLB_0 SUB
+ nchpg_hvtdpsr l=0.08U
+ w=0.105U
M8767 XMC4X4_XMC0_3_BLB_IN A_WL_3 A_BLB_0 SUB
+ nchpg_hvtdpsr l=0.08U
+ w=0.105U
M8768 A_BL_0 A_WL_3 XMC4X4_XMC0_3_BL_IN SUB
+ nchpg_hvtdpsr l=0.08U
+ w=0.105U
M8769 A_BL_0 A_WL_0 XMC4X4_XMC0_0_BL_IN SUB
+ nchpg_hvtdpsr l=0.08U
+ w=0.105U
M8770 XMC4X4_XMC0_0_BLB_IN A_WL_0 A_BLB_0 SUB
+ nchpg_hvtdpsr l=0.08U
+ w=0.105U
M8771 XMC4X4_XMC0_3_BLB_IN XMC4X4_XMC0_3_BL_IN
+ VSS SUB nchpd_hvtdpsr l=0.065U
+ w=0.315U
M8772 XMC4X4_XMC0_1_BLB_IN XMC4X4_XMC0_1_BL_IN
+ VSS SUB nchpd_hvtdpsr l=0.065U
+ w=0.315U
M8773 XMC4X4_XMC0_2_BLB_IN XMC4X4_XMC0_2_BL_IN
+ VSS SUB nchpd_hvtdpsr l=0.065U
+ w=0.315U
M8774 VDD XMC4X4_XMC0_0_BL_IN
+ XMC4X4_XMC0_0_BLB_IN NWELL pchpu_hvtdpsr
+ l=0.07U w=0.09U
M8775 VDD XMC4X4_XMC0_3_BL_IN
+ XMC4X4_XMC0_3_BLB_IN NWELL pchpu_hvtdpsr
+ l=0.07U w=0.09U
M8776 XMC4X4_XMC0_1_BL_IN XMC4X4_XMC0_1_BLB_IN
+ VDD NWELL pchpu_hvtdpsr l=0.07U
+ w=0.09U
M8777 XMC4X4_XMC0_0_BL_IN XMC4X4_XMC0_0_BLB_IN
+ VDD NWELL pchpu_hvtdpsr l=0.07U
+ w=0.09U
M8778 VDD XMC4X4_XMC0_1_BL_IN
+ XMC4X4_XMC0_1_BLB_IN NWELL pchpu_hvtdpsr
+ l=0.07U w=0.09U
M8779 XMC4X4_XMC0_2_BL_IN XMC4X4_XMC0_2_BLB_IN
+ VDD NWELL pchpu_hvtdpsr l=0.07U
+ w=0.09U
M8780 VDD XMC4X4_XMC0_2_BL_IN
+ XMC4X4_XMC0_2_BLB_IN NWELL pchpu_hvtdpsr
+ l=0.07U w=0.09U
M8781 XMC4X4_XMC0_3_BL_IN XMC4X4_XMC0_3_BLB_IN
+ VDD NWELL pchpu_hvtdpsr l=0.07U
+ w=0.09U
M8782 B_BL_1 B_WL_0 XMC4X4_XMC1_0_BL_IN SUB
+ nchpg_hvtdpsr l=0.08U
+ w=0.105U
M8783 B_BL_0 B_WL_0 XMC4X4_XMC0_0_BL_IN SUB
+ nchpg_hvtdpsr l=0.08U
+ w=0.105U
M8784 XMC4X4_XMC0_0_BLB_IN B_WL_0 B_BLB_0 SUB
+ nchpg_hvtdpsr l=0.08U
+ w=0.105U
M8785 XMC4X4_XMC1_0_BLB_IN B_WL_0 B_BLB_1 SUB
+ nchpg_hvtdpsr l=0.08U
+ w=0.105U
M8786 B_BL_1 B_WL_3 XMC4X4_XMC1_3_BL_IN SUB
+ nchpg_hvtdpsr l=0.08U
+ w=0.105U
M8787 B_BL_0 B_WL_3 XMC4X4_XMC0_3_BL_IN SUB
+ nchpg_hvtdpsr l=0.08U
+ w=0.105U
M8788 XMC4X4_XMC0_3_BLB_IN B_WL_3 B_BLB_0 SUB
+ nchpg_hvtdpsr l=0.08U
+ w=0.105U
M8789 XMC4X4_XMC1_3_BLB_IN B_WL_3 B_BLB_1 SUB
+ nchpg_hvtdpsr l=0.08U
+ w=0.105U
M8790 B_BL_1 B_WL_1 XMC4X4_XMC1_1_BL_IN SUB
+ nchpg_hvtdpsr l=0.08U
+ w=0.105U
M8791 XMC4X4_XMC1_1_BLB_IN B_WL_1 B_BLB_1 SUB
+ nchpg_hvtdpsr l=0.08U
+ w=0.105U
M8792 B_BL_0 B_WL_1 XMC4X4_XMC0_1_BL_IN SUB
+ nchpg_hvtdpsr l=0.08U
+ w=0.105U
M8793 XMC4X4_XMC0_1_BLB_IN B_WL_1 B_BLB_0 SUB
+ nchpg_hvtdpsr l=0.08U
+ w=0.105U
M8794 B_BL_1 B_WL_2 XMC4X4_XMC1_2_BL_IN SUB
+ nchpg_hvtdpsr l=0.08U
+ w=0.105U
M8795 XMC4X4_XMC1_2_BLB_IN B_WL_2 B_BLB_1 SUB
+ nchpg_hvtdpsr l=0.08U
+ w=0.105U
M8796 B_BL_0 B_WL_2 XMC4X4_XMC0_2_BL_IN SUB
+ nchpg_hvtdpsr l=0.08U
+ w=0.105U
M8797 XMC4X4_XMC0_2_BLB_IN B_WL_2 B_BLB_0 SUB
+ nchpg_hvtdpsr l=0.08U
+ w=0.105U
M8798 VSS XMC4X4_XMC0_1_BLB_IN
+ XMC4X4_XMC0_1_BL_IN SUB nchpd_hvtdpsr
+ l=0.065U w=0.315U
M8799 VSS XMC4X4_XMC1_1_BLB_IN
+ XMC4X4_XMC1_1_BL_IN SUB nchpd_hvtdpsr
+ l=0.065U w=0.315U
M8800 VSS XMC4X4_XMC0_0_BLB_IN
+ XMC4X4_XMC0_0_BL_IN SUB nchpd_hvtdpsr
+ l=0.065U w=0.315U
M8801 VSS XMC4X4_XMC1_0_BLB_IN
+ XMC4X4_XMC1_0_BL_IN SUB nchpd_hvtdpsr
+ l=0.065U w=0.315U
M8802 VSS XMC4X4_XMC0_2_BLB_IN
+ XMC4X4_XMC0_2_BL_IN SUB nchpd_hvtdpsr
+ l=0.065U w=0.315U
M8803 VSS XMC4X4_XMC1_2_BLB_IN
+ XMC4X4_XMC1_2_BL_IN SUB nchpd_hvtdpsr
+ l=0.065U w=0.315U
M8804 VSS XMC4X4_XMC0_3_BLB_IN
+ XMC4X4_XMC0_3_BL_IN SUB nchpd_hvtdpsr
+ l=0.065U w=0.315U
M8805 VSS XMC4X4_XMC1_3_BLB_IN
+ XMC4X4_XMC1_3_BL_IN SUB nchpd_hvtdpsr
+ l=0.065U w=0.315U
M8806 VDD XMC4X4_XMC1_0_BL_IN
+ XMC4X4_XMC1_0_BLB_IN NWELL pchpu_hvtdpsr
+ l=0.07U w=0.09U
M8807 VDD XMC4X4_XMC1_3_BL_IN
+ XMC4X4_XMC1_3_BLB_IN NWELL pchpu_hvtdpsr
+ l=0.07U w=0.09U
M8808 XMC4X4_XMC1_1_BL_IN XMC4X4_XMC1_1_BLB_IN
+ VDD NWELL pchpu_hvtdpsr l=0.07U
+ w=0.09U
M8809 XMC4X4_XMC1_0_BL_IN XMC4X4_XMC1_0_BLB_IN
+ VDD NWELL pchpu_hvtdpsr l=0.07U
+ w=0.09U
M8810 VDD XMC4X4_XMC1_1_BL_IN
+ XMC4X4_XMC1_1_BLB_IN NWELL pchpu_hvtdpsr
+ l=0.07U w=0.09U
M8811 XMC4X4_XMC1_2_BL_IN XMC4X4_XMC1_2_BLB_IN
+ VDD NWELL pchpu_hvtdpsr l=0.07U
+ w=0.09U
M8812 VDD XMC4X4_XMC1_2_BL_IN
+ XMC4X4_XMC1_2_BLB_IN NWELL pchpu_hvtdpsr
+ l=0.07U w=0.09U
M8813 XMC4X4_XMC1_3_BL_IN XMC4X4_XMC1_3_BLB_IN
+ VDD NWELL pchpu_hvtdpsr l=0.07U
+ w=0.09U
M8814 XMC4X4_XMC1_0_BLB_IN XMC4X4_XMC1_0_BL_IN
+ VSS SUB nchpd_hvtdpsr l=0.065U
+ w=0.315U
M8815 XMC4X4_XMC2_0_BLB_IN XMC4X4_XMC2_0_BL_IN
+ VSS SUB nchpd_hvtdpsr l=0.065U
+ w=0.315U
M8816 XMC4X4_XMC1_1_BLB_IN A_WL_1 A_BLB_1 SUB
+ nchpg_hvtdpsr l=0.08U
+ w=0.105U
M8817 XMC4X4_XMC2_1_BLB_IN A_WL_1 A_BLB_2 SUB
+ nchpg_hvtdpsr l=0.08U
+ w=0.105U
M8818 A_BL_1 A_WL_1 XMC4X4_XMC1_1_BL_IN SUB
+ nchpg_hvtdpsr l=0.08U
+ w=0.105U
M8819 A_BL_2 A_WL_1 XMC4X4_XMC2_1_BL_IN SUB
+ nchpg_hvtdpsr l=0.08U
+ w=0.105U
M8820 A_BL_1 A_WL_2 XMC4X4_XMC1_2_BL_IN SUB
+ nchpg_hvtdpsr l=0.08U
+ w=0.105U
M8821 XMC4X4_XMC1_2_BLB_IN A_WL_2 A_BLB_1 SUB
+ nchpg_hvtdpsr l=0.08U
+ w=0.105U
M8822 A_BL_2 A_WL_2 XMC4X4_XMC2_2_BL_IN SUB
+ nchpg_hvtdpsr l=0.08U
+ w=0.105U
M8823 XMC4X4_XMC2_2_BLB_IN A_WL_2 A_BLB_2 SUB
+ nchpg_hvtdpsr l=0.08U
+ w=0.105U
M8824 XMC4X4_XMC2_3_BLB_IN A_WL_3 A_BLB_2 SUB
+ nchpg_hvtdpsr l=0.08U
+ w=0.105U
M8825 A_BL_2 A_WL_3 XMC4X4_XMC2_3_BL_IN SUB
+ nchpg_hvtdpsr l=0.08U
+ w=0.105U
M8826 XMC4X4_XMC1_3_BLB_IN A_WL_3 A_BLB_1 SUB
+ nchpg_hvtdpsr l=0.08U
+ w=0.105U
M8827 A_BL_1 A_WL_3 XMC4X4_XMC1_3_BL_IN SUB
+ nchpg_hvtdpsr l=0.08U
+ w=0.105U
M8828 A_BL_2 A_WL_0 XMC4X4_XMC2_0_BL_IN SUB
+ nchpg_hvtdpsr l=0.08U
+ w=0.105U
M8829 A_BL_1 A_WL_0 XMC4X4_XMC1_0_BL_IN SUB
+ nchpg_hvtdpsr l=0.08U
+ w=0.105U
M8830 XMC4X4_XMC2_0_BLB_IN A_WL_0 A_BLB_2 SUB
+ nchpg_hvtdpsr l=0.08U
+ w=0.105U
M8831 XMC4X4_XMC1_0_BLB_IN A_WL_0 A_BLB_1 SUB
+ nchpg_hvtdpsr l=0.08U
+ w=0.105U
M8832 XMC4X4_XMC1_3_BLB_IN XMC4X4_XMC1_3_BL_IN
+ VSS SUB nchpd_hvtdpsr l=0.065U
+ w=0.315U
M8833 XMC4X4_XMC2_3_BLB_IN XMC4X4_XMC2_3_BL_IN
+ VSS SUB nchpd_hvtdpsr l=0.065U
+ w=0.315U
M8834 XMC4X4_XMC2_1_BLB_IN XMC4X4_XMC2_1_BL_IN
+ VSS SUB nchpd_hvtdpsr l=0.065U
+ w=0.315U
M8835 XMC4X4_XMC1_1_BLB_IN XMC4X4_XMC1_1_BL_IN
+ VSS SUB nchpd_hvtdpsr l=0.065U
+ w=0.315U
M8836 XMC4X4_XMC2_2_BLB_IN XMC4X4_XMC2_2_BL_IN
+ VSS SUB nchpd_hvtdpsr l=0.065U
+ w=0.315U
M8837 XMC4X4_XMC1_2_BLB_IN XMC4X4_XMC1_2_BL_IN
+ VSS SUB nchpd_hvtdpsr l=0.065U
+ w=0.315U
M8838 VDD XMC4X4_XMC2_0_BL_IN
+ XMC4X4_XMC2_0_BLB_IN NWELL pchpu_hvtdpsr
+ l=0.07U w=0.09U
M8839 VDD XMC4X4_XMC2_3_BL_IN
+ XMC4X4_XMC2_3_BLB_IN NWELL pchpu_hvtdpsr
+ l=0.07U w=0.09U
M8840 XMC4X4_XMC2_1_BL_IN XMC4X4_XMC2_1_BLB_IN
+ VDD NWELL pchpu_hvtdpsr l=0.07U
+ w=0.09U
M8841 XMC4X4_XMC2_0_BL_IN XMC4X4_XMC2_0_BLB_IN
+ VDD NWELL pchpu_hvtdpsr l=0.07U
+ w=0.09U
M8842 VDD XMC4X4_XMC2_1_BL_IN
+ XMC4X4_XMC2_1_BLB_IN NWELL pchpu_hvtdpsr
+ l=0.07U w=0.09U
M8843 XMC4X4_XMC2_2_BL_IN XMC4X4_XMC2_2_BLB_IN
+ VDD NWELL pchpu_hvtdpsr l=0.07U
+ w=0.09U
M8844 VDD XMC4X4_XMC2_2_BL_IN
+ XMC4X4_XMC2_2_BLB_IN NWELL pchpu_hvtdpsr
+ l=0.07U w=0.09U
M8845 XMC4X4_XMC2_3_BL_IN XMC4X4_XMC2_3_BLB_IN
+ VDD NWELL pchpu_hvtdpsr l=0.07U
+ w=0.09U
M8846 B_BL_3 B_WL_0 XMC4X4_XMC3_0_BL_IN SUB
+ nchpg_hvtdpsr l=0.08U
+ w=0.105U
M8847 B_BL_2 B_WL_0 XMC4X4_XMC2_0_BL_IN SUB
+ nchpg_hvtdpsr l=0.08U
+ w=0.105U
M8848 XMC4X4_XMC3_0_BLB_IN B_WL_0 B_BLB_3 SUB
+ nchpg_hvtdpsr l=0.08U
+ w=0.105U
M8849 XMC4X4_XMC2_0_BLB_IN B_WL_0 B_BLB_2 SUB
+ nchpg_hvtdpsr l=0.08U
+ w=0.105U
M8850 B_BL_3 B_WL_3 XMC4X4_XMC3_3_BL_IN SUB
+ nchpg_hvtdpsr l=0.08U
+ w=0.105U
M8851 B_BL_2 B_WL_3 XMC4X4_XMC2_3_BL_IN SUB
+ nchpg_hvtdpsr l=0.08U
+ w=0.105U
M8852 XMC4X4_XMC3_3_BLB_IN B_WL_3 B_BLB_3 SUB
+ nchpg_hvtdpsr l=0.08U
+ w=0.105U
M8853 XMC4X4_XMC2_3_BLB_IN B_WL_3 B_BLB_2 SUB
+ nchpg_hvtdpsr l=0.08U
+ w=0.105U
M8854 B_BL_3 B_WL_1 XMC4X4_XMC3_1_BL_IN SUB
+ nchpg_hvtdpsr l=0.08U
+ w=0.105U
M8855 B_BL_2 B_WL_1 XMC4X4_XMC2_1_BL_IN SUB
+ nchpg_hvtdpsr l=0.08U
+ w=0.105U
M8856 XMC4X4_XMC2_1_BLB_IN B_WL_1 B_BLB_2 SUB
+ nchpg_hvtdpsr l=0.08U
+ w=0.105U
M8857 XMC4X4_XMC3_1_BLB_IN B_WL_1 B_BLB_3 SUB
+ nchpg_hvtdpsr l=0.08U
+ w=0.105U
M8858 B_BL_3 B_WL_2 XMC4X4_XMC3_2_BL_IN SUB
+ nchpg_hvtdpsr l=0.08U
+ w=0.105U
M8859 B_BL_2 B_WL_2 XMC4X4_XMC2_2_BL_IN SUB
+ nchpg_hvtdpsr l=0.08U
+ w=0.105U
M8860 XMC4X4_XMC2_2_BLB_IN B_WL_2 B_BLB_2 SUB
+ nchpg_hvtdpsr l=0.08U
+ w=0.105U
M8861 XMC4X4_XMC3_2_BLB_IN B_WL_2 B_BLB_3 SUB
+ nchpg_hvtdpsr l=0.08U
+ w=0.105U
M8862 VSS XMC4X4_XMC3_1_BLB_IN
+ XMC4X4_XMC3_1_BL_IN SUB nchpd_hvtdpsr
+ l=0.065U w=0.315U
M8863 VSS XMC4X4_XMC2_1_BLB_IN
+ XMC4X4_XMC2_1_BL_IN SUB nchpd_hvtdpsr
+ l=0.065U w=0.315U
M8864 VSS XMC4X4_XMC3_0_BLB_IN
+ XMC4X4_XMC3_0_BL_IN SUB nchpd_hvtdpsr
+ l=0.065U w=0.315U
M8865 VSS XMC4X4_XMC2_0_BLB_IN
+ XMC4X4_XMC2_0_BL_IN SUB nchpd_hvtdpsr
+ l=0.065U w=0.315U
M8866 VSS XMC4X4_XMC3_2_BLB_IN
+ XMC4X4_XMC3_2_BL_IN SUB nchpd_hvtdpsr
+ l=0.065U w=0.315U
M8867 VSS XMC4X4_XMC2_2_BLB_IN
+ XMC4X4_XMC2_2_BL_IN SUB nchpd_hvtdpsr
+ l=0.065U w=0.315U
M8868 VSS XMC4X4_XMC3_3_BLB_IN
+ XMC4X4_XMC3_3_BL_IN SUB nchpd_hvtdpsr
+ l=0.065U w=0.315U
M8869 VSS XMC4X4_XMC2_3_BLB_IN
+ XMC4X4_XMC2_3_BL_IN SUB nchpd_hvtdpsr
+ l=0.065U w=0.315U
M8870 VDD XMC4X4_XMC3_0_BL_IN
+ XMC4X4_XMC3_0_BLB_IN NWELL pchpu_hvtdpsr
+ l=0.07U w=0.09U
M8871 VDD XMC4X4_XMC3_3_BL_IN
+ XMC4X4_XMC3_3_BLB_IN NWELL pchpu_hvtdpsr
+ l=0.07U w=0.09U
M8872 XMC4X4_XMC3_1_BL_IN XMC4X4_XMC3_1_BLB_IN
+ VDD NWELL pchpu_hvtdpsr l=0.07U
+ w=0.09U
M8873 XMC4X4_XMC3_0_BL_IN XMC4X4_XMC3_0_BLB_IN
+ VDD NWELL pchpu_hvtdpsr l=0.07U
+ w=0.09U
M8874 VDD XMC4X4_XMC3_1_BL_IN
+ XMC4X4_XMC3_1_BLB_IN NWELL pchpu_hvtdpsr
+ l=0.07U w=0.09U
M8875 XMC4X4_XMC3_2_BL_IN XMC4X4_XMC3_2_BLB_IN
+ VDD NWELL pchpu_hvtdpsr l=0.07U
+ w=0.09U
M8876 VDD XMC4X4_XMC3_2_BL_IN
+ XMC4X4_XMC3_2_BLB_IN NWELL pchpu_hvtdpsr
+ l=0.07U w=0.09U
M8877 XMC4X4_XMC3_3_BL_IN XMC4X4_XMC3_3_BLB_IN
+ VDD NWELL pchpu_hvtdpsr l=0.07U
+ w=0.09U
M8878 XMC4X4_XMC3_0_BLB_IN XMC4X4_XMC3_0_BL_IN
+ VSS SUB nchpd_hvtdpsr l=0.065U
+ w=0.315U
M8879 XMC4X4_XMC3_1_BLB_IN A_WL_1 A_BLB_3 SUB
+ nchpg_hvtdpsr l=0.08U
+ w=0.105U
M8880 A_BL_3 A_WL_1 XMC4X4_XMC3_1_BL_IN SUB
+ nchpg_hvtdpsr l=0.08U
+ w=0.105U
M8881 A_BL_3 A_WL_2 XMC4X4_XMC3_2_BL_IN SUB
+ nchpg_hvtdpsr l=0.08U
+ w=0.105U
M8882 XMC4X4_XMC3_2_BLB_IN A_WL_2 A_BLB_3 SUB
+ nchpg_hvtdpsr l=0.08U
+ w=0.105U
M8883 XMC4X4_XMC3_3_BLB_IN A_WL_3 A_BLB_3 SUB
+ nchpg_hvtdpsr l=0.08U
+ w=0.105U
M8884 A_BL_3 A_WL_3 XMC4X4_XMC3_3_BL_IN SUB
+ nchpg_hvtdpsr l=0.08U
+ w=0.105U
M8885 A_BL_3 A_WL_0 XMC4X4_XMC3_0_BL_IN SUB
+ nchpg_hvtdpsr l=0.08U
+ w=0.105U
M8886 XMC4X4_XMC3_0_BLB_IN A_WL_0 A_BLB_3 SUB
+ nchpg_hvtdpsr l=0.08U
+ w=0.105U
M8887 XMC4X4_XMC3_3_BLB_IN XMC4X4_XMC3_3_BL_IN
+ VSS SUB nchpd_hvtdpsr l=0.065U
+ w=0.315U
M8888 XMC4X4_XMC3_1_BLB_IN XMC4X4_XMC3_1_BL_IN
+ VSS SUB nchpd_hvtdpsr l=0.065U
+ w=0.315U
M8889 XMC4X4_XMC3_2_BLB_IN XMC4X4_XMC3_2_BL_IN
+ VSS SUB nchpd_hvtdpsr l=0.065U
+ w=0.315U
.ENDS
* MC4X4VTF
.SUBCKT SDL400W20S_NMC4X4VTF A_WL_3 A_WL_2 A_WL_1 A_WL_0 B_WL_3 B_WL_2
+	 B_WL_1 B_WL_0 NWELL SUB A_BL_3 A_BL_2 A_BL_1 A_BL_0 A_BLB_3
+	 A_BLB_2 A_BLB_1 A_BLB_0 B_BL_3 B_BL_2 B_BL_1 B_BL_0 B_BLB_3
+	 B_BLB_2 B_BLB_1 B_BLB_0 GFA_3 GFA_2 GFA_1 GFA_0 GFB_3 GFB_2
+	 GFB_1 GFB_0
M8890 XMC4X4_XMC0_0_BLB_IN A_WL_0 A_BLB_0 SUB
+ nchpg_hvtdpsr l=0.08U
+ w=0.105U
M8891 A_BL_0 A_WL_0 XMC4X4_XMC0_0_BL_IN SUB
+ nchpg_hvtdpsr l=0.08U
+ w=0.105U
M8892 XMC4X4_XMC0_3_BLB_IN A_WL_3 A_BLB_0 SUB
+ nchpg_hvtdpsr l=0.08U
+ w=0.105U
M8893 A_BL_0 A_WL_3 XMC4X4_XMC0_3_BL_IN SUB
+ nchpg_hvtdpsr l=0.08U
+ w=0.105U
M8894 A_BL_0 A_WL_1 XMC4X4_XMC0_1_BL_IN SUB
+ nchpg_hvtdpsr l=0.08U
+ w=0.105U
M8895 XMC4X4_XMC0_1_BLB_IN A_WL_1 A_BLB_0 SUB
+ nchpg_hvtdpsr l=0.08U
+ w=0.105U
M8896 A_BL_0 A_WL_2 XMC4X4_XMC0_2_BL_IN SUB
+ nchpg_hvtdpsr l=0.08U
+ w=0.105U
M8897 XMC4X4_XMC0_2_BLB_IN A_WL_2 A_BLB_0 SUB
+ nchpg_hvtdpsr l=0.08U
+ w=0.105U
M8898 XMC4X4_XMC0_1_BLB_IN XMC4X4_XMC0_1_BL_IN
+ VSS SUB nchpd_hvtdpsr l=0.065U
+ w=0.315U
M8899 XMC4X4_XMC0_0_BLB_IN XMC4X4_XMC0_0_BL_IN
+ VSS SUB nchpd_hvtdpsr l=0.065U
+ w=0.315U
M8900 XMC4X4_XMC0_2_BLB_IN XMC4X4_XMC0_2_BL_IN
+ VSS SUB nchpd_hvtdpsr l=0.065U
+ w=0.315U
M8901 XMC4X4_XMC0_3_BLB_IN XMC4X4_XMC0_3_BL_IN
+ VSS SUB nchpd_hvtdpsr l=0.065U
+ w=0.315U
M8902 XMC4X4_XMC0_0_BL_IN XMC4X4_XMC0_0_BLB_IN
+ VDD NWELL pchpu_hvtdpsr l=0.07U
+ w=0.09U
M8903 XMC4X4_XMC0_3_BL_IN XMC4X4_XMC0_3_BLB_IN
+ VDD NWELL pchpu_hvtdpsr l=0.07U
+ w=0.09U
M8904 VDD XMC4X4_XMC0_1_BL_IN
+ XMC4X4_XMC0_1_BLB_IN NWELL pchpu_hvtdpsr
+ l=0.07U w=0.09U
M8905 VDD XMC4X4_XMC0_0_BL_IN
+ XMC4X4_XMC0_0_BLB_IN NWELL pchpu_hvtdpsr
+ l=0.07U w=0.09U
M8906 XMC4X4_XMC0_1_BL_IN XMC4X4_XMC0_1_BLB_IN
+ VDD NWELL pchpu_hvtdpsr l=0.07U
+ w=0.09U
M8907 VDD XMC4X4_XMC0_2_BL_IN
+ XMC4X4_XMC0_2_BLB_IN NWELL pchpu_hvtdpsr
+ l=0.07U w=0.09U
M8908 XMC4X4_XMC0_2_BL_IN XMC4X4_XMC0_2_BLB_IN
+ VDD NWELL pchpu_hvtdpsr l=0.07U
+ w=0.09U
M8909 VDD XMC4X4_XMC0_3_BL_IN
+ XMC4X4_XMC0_3_BLB_IN NWELL pchpu_hvtdpsr
+ l=0.07U w=0.09U
M8910 VSS XMC4X4_XMC0_0_BLB_IN
+ XMC4X4_XMC0_0_BL_IN SUB nchpd_hvtdpsr
+ l=0.065U w=0.315U
M8911 VSS XMC4X4_XMC1_0_BLB_IN
+ XMC4X4_XMC1_0_BL_IN SUB nchpd_hvtdpsr
+ l=0.065U w=0.315U
M8912 B_BL_0 B_WL_1 XMC4X4_XMC0_1_BL_IN SUB
+ nchpg_hvtdpsr l=0.08U
+ w=0.105U
M8913 B_BL_1 B_WL_1 XMC4X4_XMC1_1_BL_IN SUB
+ nchpg_hvtdpsr l=0.08U
+ w=0.105U
M8914 XMC4X4_XMC1_1_BLB_IN B_WL_1 B_BLB_1 SUB
+ nchpg_hvtdpsr l=0.08U
+ w=0.105U
M8915 XMC4X4_XMC0_1_BLB_IN B_WL_1 B_BLB_0 SUB
+ nchpg_hvtdpsr l=0.08U
+ w=0.105U
M8916 XMC4X4_XMC0_2_BLB_IN B_WL_2 B_BLB_0 SUB
+ nchpg_hvtdpsr l=0.08U
+ w=0.105U
M8917 B_BL_0 B_WL_2 XMC4X4_XMC0_2_BL_IN SUB
+ nchpg_hvtdpsr l=0.08U
+ w=0.105U
M8918 XMC4X4_XMC1_2_BLB_IN B_WL_2 B_BLB_1 SUB
+ nchpg_hvtdpsr l=0.08U
+ w=0.105U
M8919 B_BL_1 B_WL_2 XMC4X4_XMC1_2_BL_IN SUB
+ nchpg_hvtdpsr l=0.08U
+ w=0.105U
M8920 B_BL_1 B_WL_3 XMC4X4_XMC1_3_BL_IN SUB
+ nchpg_hvtdpsr l=0.08U
+ w=0.105U
M8921 XMC4X4_XMC1_3_BLB_IN B_WL_3 B_BLB_1 SUB
+ nchpg_hvtdpsr l=0.08U
+ w=0.105U
M8922 B_BL_0 B_WL_3 XMC4X4_XMC0_3_BL_IN SUB
+ nchpg_hvtdpsr l=0.08U
+ w=0.105U
M8923 XMC4X4_XMC0_3_BLB_IN B_WL_3 B_BLB_0 SUB
+ nchpg_hvtdpsr l=0.08U
+ w=0.105U
M8924 XMC4X4_XMC0_0_BLB_IN B_WL_0 B_BLB_0 SUB
+ nchpg_hvtdpsr l=0.08U
+ w=0.105U
M8925 XMC4X4_XMC1_0_BLB_IN B_WL_0 B_BLB_1 SUB
+ nchpg_hvtdpsr l=0.08U
+ w=0.105U
M8926 B_BL_1 B_WL_0 XMC4X4_XMC1_0_BL_IN SUB
+ nchpg_hvtdpsr l=0.08U
+ w=0.105U
M8927 B_BL_0 B_WL_0 XMC4X4_XMC0_0_BL_IN SUB
+ nchpg_hvtdpsr l=0.08U
+ w=0.105U
M8928 VSS XMC4X4_XMC1_3_BLB_IN
+ XMC4X4_XMC1_3_BL_IN SUB nchpd_hvtdpsr
+ l=0.065U w=0.315U
M8929 VSS XMC4X4_XMC0_3_BLB_IN
+ XMC4X4_XMC0_3_BL_IN SUB nchpd_hvtdpsr
+ l=0.065U w=0.315U
M8930 VSS XMC4X4_XMC0_1_BLB_IN
+ XMC4X4_XMC0_1_BL_IN SUB nchpd_hvtdpsr
+ l=0.065U w=0.315U
M8931 VSS XMC4X4_XMC1_1_BLB_IN
+ XMC4X4_XMC1_1_BL_IN SUB nchpd_hvtdpsr
+ l=0.065U w=0.315U
M8932 VSS XMC4X4_XMC1_2_BLB_IN
+ XMC4X4_XMC1_2_BL_IN SUB nchpd_hvtdpsr
+ l=0.065U w=0.315U
M8933 VSS XMC4X4_XMC0_2_BLB_IN
+ XMC4X4_XMC0_2_BL_IN SUB nchpd_hvtdpsr
+ l=0.065U w=0.315U
M8934 XMC4X4_XMC1_0_BL_IN XMC4X4_XMC1_0_BLB_IN
+ VDD NWELL pchpu_hvtdpsr l=0.07U
+ w=0.09U
M8935 XMC4X4_XMC1_3_BL_IN XMC4X4_XMC1_3_BLB_IN
+ VDD NWELL pchpu_hvtdpsr l=0.07U
+ w=0.09U
M8936 VDD XMC4X4_XMC1_1_BL_IN
+ XMC4X4_XMC1_1_BLB_IN NWELL pchpu_hvtdpsr
+ l=0.07U w=0.09U
M8937 VDD XMC4X4_XMC1_0_BL_IN
+ XMC4X4_XMC1_0_BLB_IN NWELL pchpu_hvtdpsr
+ l=0.07U w=0.09U
M8938 XMC4X4_XMC1_1_BL_IN XMC4X4_XMC1_1_BLB_IN
+ VDD NWELL pchpu_hvtdpsr l=0.07U
+ w=0.09U
M8939 VDD XMC4X4_XMC1_2_BL_IN
+ XMC4X4_XMC1_2_BLB_IN NWELL pchpu_hvtdpsr
+ l=0.07U w=0.09U
M8940 XMC4X4_XMC1_2_BL_IN XMC4X4_XMC1_2_BLB_IN
+ VDD NWELL pchpu_hvtdpsr l=0.07U
+ w=0.09U
M8941 VDD XMC4X4_XMC1_3_BL_IN
+ XMC4X4_XMC1_3_BLB_IN NWELL pchpu_hvtdpsr
+ l=0.07U w=0.09U
M8942 XMC4X4_XMC2_0_BLB_IN A_WL_0 A_BLB_2 SUB
+ nchpg_hvtdpsr l=0.08U
+ w=0.105U
M8943 XMC4X4_XMC1_0_BLB_IN A_WL_0 A_BLB_1 SUB
+ nchpg_hvtdpsr l=0.08U
+ w=0.105U
M8944 A_BL_1 A_WL_0 XMC4X4_XMC1_0_BL_IN SUB
+ nchpg_hvtdpsr l=0.08U
+ w=0.105U
M8945 A_BL_2 A_WL_0 XMC4X4_XMC2_0_BL_IN SUB
+ nchpg_hvtdpsr l=0.08U
+ w=0.105U
M8946 XMC4X4_XMC2_3_BLB_IN A_WL_3 A_BLB_2 SUB
+ nchpg_hvtdpsr l=0.08U
+ w=0.105U
M8947 XMC4X4_XMC1_3_BLB_IN A_WL_3 A_BLB_1 SUB
+ nchpg_hvtdpsr l=0.08U
+ w=0.105U
M8948 A_BL_2 A_WL_3 XMC4X4_XMC2_3_BL_IN SUB
+ nchpg_hvtdpsr l=0.08U
+ w=0.105U
M8949 A_BL_1 A_WL_3 XMC4X4_XMC1_3_BL_IN SUB
+ nchpg_hvtdpsr l=0.08U
+ w=0.105U
M8950 A_BL_2 A_WL_1 XMC4X4_XMC2_1_BL_IN SUB
+ nchpg_hvtdpsr l=0.08U
+ w=0.105U
M8951 A_BL_1 A_WL_1 XMC4X4_XMC1_1_BL_IN SUB
+ nchpg_hvtdpsr l=0.08U
+ w=0.105U
M8952 XMC4X4_XMC2_1_BLB_IN A_WL_1 A_BLB_2 SUB
+ nchpg_hvtdpsr l=0.08U
+ w=0.105U
M8953 XMC4X4_XMC1_1_BLB_IN A_WL_1 A_BLB_1 SUB
+ nchpg_hvtdpsr l=0.08U
+ w=0.105U
M8954 A_BL_2 A_WL_2 XMC4X4_XMC2_2_BL_IN SUB
+ nchpg_hvtdpsr l=0.08U
+ w=0.105U
M8955 A_BL_1 A_WL_2 XMC4X4_XMC1_2_BL_IN SUB
+ nchpg_hvtdpsr l=0.08U
+ w=0.105U
M8956 XMC4X4_XMC2_2_BLB_IN A_WL_2 A_BLB_2 SUB
+ nchpg_hvtdpsr l=0.08U
+ w=0.105U
M8957 XMC4X4_XMC1_2_BLB_IN A_WL_2 A_BLB_1 SUB
+ nchpg_hvtdpsr l=0.08U
+ w=0.105U
M8958 XMC4X4_XMC2_1_BLB_IN XMC4X4_XMC2_1_BL_IN
+ VSS SUB nchpd_hvtdpsr l=0.065U
+ w=0.315U
M8959 XMC4X4_XMC1_1_BLB_IN XMC4X4_XMC1_1_BL_IN
+ VSS SUB nchpd_hvtdpsr l=0.065U
+ w=0.315U
M8960 XMC4X4_XMC1_0_BLB_IN XMC4X4_XMC1_0_BL_IN
+ VSS SUB nchpd_hvtdpsr l=0.065U
+ w=0.315U
M8961 XMC4X4_XMC2_0_BLB_IN XMC4X4_XMC2_0_BL_IN
+ VSS SUB nchpd_hvtdpsr l=0.065U
+ w=0.315U
M8962 XMC4X4_XMC1_2_BLB_IN XMC4X4_XMC1_2_BL_IN
+ VSS SUB nchpd_hvtdpsr l=0.065U
+ w=0.315U
M8963 XMC4X4_XMC2_2_BLB_IN XMC4X4_XMC2_2_BL_IN
+ VSS SUB nchpd_hvtdpsr l=0.065U
+ w=0.315U
M8964 XMC4X4_XMC2_3_BLB_IN XMC4X4_XMC2_3_BL_IN
+ VSS SUB nchpd_hvtdpsr l=0.065U
+ w=0.315U
M8965 XMC4X4_XMC1_3_BLB_IN XMC4X4_XMC1_3_BL_IN
+ VSS SUB nchpd_hvtdpsr l=0.065U
+ w=0.315U
M8966 XMC4X4_XMC2_0_BL_IN XMC4X4_XMC2_0_BLB_IN
+ VDD NWELL pchpu_hvtdpsr l=0.07U
+ w=0.09U
M8967 XMC4X4_XMC2_3_BL_IN XMC4X4_XMC2_3_BLB_IN
+ VDD NWELL pchpu_hvtdpsr l=0.07U
+ w=0.09U
M8968 VDD XMC4X4_XMC2_1_BL_IN
+ XMC4X4_XMC2_1_BLB_IN NWELL pchpu_hvtdpsr
+ l=0.07U w=0.09U
M8969 VDD XMC4X4_XMC2_0_BL_IN
+ XMC4X4_XMC2_0_BLB_IN NWELL pchpu_hvtdpsr
+ l=0.07U w=0.09U
M8970 XMC4X4_XMC2_1_BL_IN XMC4X4_XMC2_1_BLB_IN
+ VDD NWELL pchpu_hvtdpsr l=0.07U
+ w=0.09U
M8971 VDD XMC4X4_XMC2_2_BL_IN
+ XMC4X4_XMC2_2_BLB_IN NWELL pchpu_hvtdpsr
+ l=0.07U w=0.09U
M8972 XMC4X4_XMC2_2_BL_IN XMC4X4_XMC2_2_BLB_IN
+ VDD NWELL pchpu_hvtdpsr l=0.07U
+ w=0.09U
M8973 VDD XMC4X4_XMC2_3_BL_IN
+ XMC4X4_XMC2_3_BLB_IN NWELL pchpu_hvtdpsr
+ l=0.07U w=0.09U
M8974 VSS XMC4X4_XMC3_0_BLB_IN
+ XMC4X4_XMC3_0_BL_IN SUB nchpd_hvtdpsr
+ l=0.065U w=0.315U
M8975 VSS XMC4X4_XMC2_0_BLB_IN
+ XMC4X4_XMC2_0_BL_IN SUB nchpd_hvtdpsr
+ l=0.065U w=0.315U
M8976 B_BL_2 B_WL_1 XMC4X4_XMC2_1_BL_IN SUB
+ nchpg_hvtdpsr l=0.08U
+ w=0.105U
M8977 XMC4X4_XMC2_1_BLB_IN B_WL_1 B_BLB_2 SUB
+ nchpg_hvtdpsr l=0.08U
+ w=0.105U
M8978 XMC4X4_XMC3_1_BLB_IN B_WL_1 B_BLB_3 SUB
+ nchpg_hvtdpsr l=0.08U
+ w=0.105U
M8979 B_BL_3 B_WL_1 XMC4X4_XMC3_1_BL_IN SUB
+ nchpg_hvtdpsr l=0.08U
+ w=0.105U
M8980 XMC4X4_XMC3_2_BLB_IN B_WL_2 B_BLB_3 SUB
+ nchpg_hvtdpsr l=0.08U
+ w=0.105U
M8981 XMC4X4_XMC2_2_BLB_IN B_WL_2 B_BLB_2 SUB
+ nchpg_hvtdpsr l=0.08U
+ w=0.105U
M8982 B_BL_2 B_WL_2 XMC4X4_XMC2_2_BL_IN SUB
+ nchpg_hvtdpsr l=0.08U
+ w=0.105U
M8983 B_BL_3 B_WL_2 XMC4X4_XMC3_2_BL_IN SUB
+ nchpg_hvtdpsr l=0.08U
+ w=0.105U
M8984 B_BL_3 B_WL_3 XMC4X4_XMC3_3_BL_IN SUB
+ nchpg_hvtdpsr l=0.08U
+ w=0.105U
M8985 B_BL_2 B_WL_3 XMC4X4_XMC2_3_BL_IN SUB
+ nchpg_hvtdpsr l=0.08U
+ w=0.105U
M8986 XMC4X4_XMC2_3_BLB_IN B_WL_3 B_BLB_2 SUB
+ nchpg_hvtdpsr l=0.08U
+ w=0.105U
M8987 XMC4X4_XMC3_3_BLB_IN B_WL_3 B_BLB_3 SUB
+ nchpg_hvtdpsr l=0.08U
+ w=0.105U
M8988 B_BL_3 B_WL_0 XMC4X4_XMC3_0_BL_IN SUB
+ nchpg_hvtdpsr l=0.08U
+ w=0.105U
M8989 XMC4X4_XMC3_0_BLB_IN B_WL_0 B_BLB_3 SUB
+ nchpg_hvtdpsr l=0.08U
+ w=0.105U
M8990 XMC4X4_XMC2_0_BLB_IN B_WL_0 B_BLB_2 SUB
+ nchpg_hvtdpsr l=0.08U
+ w=0.105U
M8991 B_BL_2 B_WL_0 XMC4X4_XMC2_0_BL_IN SUB
+ nchpg_hvtdpsr l=0.08U
+ w=0.105U
M8992 VSS XMC4X4_XMC2_3_BLB_IN
+ XMC4X4_XMC2_3_BL_IN SUB nchpd_hvtdpsr
+ l=0.065U w=0.315U
M8993 VSS XMC4X4_XMC3_3_BLB_IN
+ XMC4X4_XMC3_3_BL_IN SUB nchpd_hvtdpsr
+ l=0.065U w=0.315U
M8994 VSS XMC4X4_XMC3_1_BLB_IN
+ XMC4X4_XMC3_1_BL_IN SUB nchpd_hvtdpsr
+ l=0.065U w=0.315U
M8995 VSS XMC4X4_XMC2_1_BLB_IN
+ XMC4X4_XMC2_1_BL_IN SUB nchpd_hvtdpsr
+ l=0.065U w=0.315U
M8996 VSS XMC4X4_XMC2_2_BLB_IN
+ XMC4X4_XMC2_2_BL_IN SUB nchpd_hvtdpsr
+ l=0.065U w=0.315U
M8997 VSS XMC4X4_XMC3_2_BLB_IN
+ XMC4X4_XMC3_2_BL_IN SUB nchpd_hvtdpsr
+ l=0.065U w=0.315U
M8998 XMC4X4_XMC3_0_BL_IN XMC4X4_XMC3_0_BLB_IN
+ VDD NWELL pchpu_hvtdpsr l=0.07U
+ w=0.09U
M8999 XMC4X4_XMC3_3_BL_IN XMC4X4_XMC3_3_BLB_IN
+ VDD NWELL pchpu_hvtdpsr l=0.07U
+ w=0.09U
M9000 VDD XMC4X4_XMC3_1_BL_IN
+ XMC4X4_XMC3_1_BLB_IN NWELL pchpu_hvtdpsr
+ l=0.07U w=0.09U
M9001 VDD XMC4X4_XMC3_0_BL_IN
+ XMC4X4_XMC3_0_BLB_IN NWELL pchpu_hvtdpsr
+ l=0.07U w=0.09U
M9002 XMC4X4_XMC3_1_BL_IN XMC4X4_XMC3_1_BLB_IN
+ VDD NWELL pchpu_hvtdpsr l=0.07U
+ w=0.09U
M9003 VDD XMC4X4_XMC3_2_BL_IN
+ XMC4X4_XMC3_2_BLB_IN NWELL pchpu_hvtdpsr
+ l=0.07U w=0.09U
M9004 XMC4X4_XMC3_2_BL_IN XMC4X4_XMC3_2_BLB_IN
+ VDD NWELL pchpu_hvtdpsr l=0.07U
+ w=0.09U
M9005 VDD XMC4X4_XMC3_3_BL_IN
+ XMC4X4_XMC3_3_BLB_IN NWELL pchpu_hvtdpsr
+ l=0.07U w=0.09U
M9006 XMC4X4_XMC3_0_BLB_IN A_WL_0 A_BLB_3 SUB
+ nchpg_hvtdpsr l=0.08U
+ w=0.105U
M9007 A_BL_3 A_WL_0 XMC4X4_XMC3_0_BL_IN SUB
+ nchpg_hvtdpsr l=0.08U
+ w=0.105U
M9008 XMC4X4_XMC3_3_BLB_IN A_WL_3 A_BLB_3 SUB
+ nchpg_hvtdpsr l=0.08U
+ w=0.105U
M9009 A_BL_3 A_WL_3 XMC4X4_XMC3_3_BL_IN SUB
+ nchpg_hvtdpsr l=0.08U
+ w=0.105U
M9010 A_BL_3 A_WL_1 XMC4X4_XMC3_1_BL_IN SUB
+ nchpg_hvtdpsr l=0.08U
+ w=0.105U
M9011 XMC4X4_XMC3_1_BLB_IN A_WL_1 A_BLB_3 SUB
+ nchpg_hvtdpsr l=0.08U
+ w=0.105U
M9012 A_BL_3 A_WL_2 XMC4X4_XMC3_2_BL_IN SUB
+ nchpg_hvtdpsr l=0.08U
+ w=0.105U
M9013 XMC4X4_XMC3_2_BLB_IN A_WL_2 A_BLB_3 SUB
+ nchpg_hvtdpsr l=0.08U
+ w=0.105U
M9014 XMC4X4_XMC3_1_BLB_IN XMC4X4_XMC3_1_BL_IN
+ VSS SUB nchpd_hvtdpsr l=0.065U
+ w=0.315U
M9015 XMC4X4_XMC3_0_BLB_IN XMC4X4_XMC3_0_BL_IN
+ VSS SUB nchpd_hvtdpsr l=0.065U
+ w=0.315U
M9016 XMC4X4_XMC3_2_BLB_IN XMC4X4_XMC3_2_BL_IN
+ VSS SUB nchpd_hvtdpsr l=0.065U
+ w=0.315U
M9017 XMC4X4_XMC3_3_BLB_IN XMC4X4_XMC3_3_BL_IN
+ VSS SUB nchpd_hvtdpsr l=0.065U
+ w=0.315U
.ENDS
* WLDV2P
.SUBCKT SDL400W20S_NWLDV2P A_XLA0 A_XLA1 A_XLA2 A_XLA3 A_XLB A_XLC B_XLA0
+	 B_XLA1 B_XLA2 B_XLA3 B_XLB B_XLC A_WL0 A_WL1 A_WL2 A_WL3
+	 B_WL0 B_WL1 B_WL2 B_WL3
M9018 A_WL0 XWLDVA_WLC0 VSS VSS nch_hvt
+ l=0.06U
+	 w=1.335U
M9019 A_WL0 XWLDVA_WLC0 VSS VSS nch_hvt
+ l=0.06U
+ w=1.335U
M9020 A_WL0 XWLDVA_WLC0 VSS VSS nch_hvt
+ l=0.06U
+ w=1.33U
M9021 A_WL2 XWLDVA_WLC2 VSS VSS nch_hvt
+ l=0.06U
+	 w=1.335U
M9022 A_WL2 XWLDVA_WLC2 VSS VSS nch_hvt
+ l=0.06U
+ w=1.335U
M9023 A_WL2 XWLDVA_WLC2 VSS VSS nch_hvt
+ l=0.06U
+ w=1.33U
M9024 VDD A_XLC XWLDVA_WLC0 VDD pch
+ l=0.06U
+ w=0.41U
M9025 VDD A_XLB XWLDVA_WLC0 VDD pch
+ l=0.06U
+ w=0.41U
M9026 VDD A_XLA0 XWLDVA_WLC0 VDD pch
+ l=0.06U
+ w=0.41U
M9027 VDD XWLDVA_WLC0 A_WL0 VDD pch_hvt
+ l=0.06U
+ w=5U
M9028 VDD XWLDVA_WLC0 A_WL0 VDD pch_hvt
+ l=0.06U
+ w=5U
M9029 VDD XWLDVA_WLC0 A_WL0 VDD pch_hvt
+ l=0.06U
+ w=5U
M9030 VDD A_XLC XWLDVA_WLC2 VDD pch
+ l=0.06U
+ w=0.41U
M9031 VDD A_XLB XWLDVA_WLC2 VDD pch
+ l=0.06U
+ w=0.41U
M9032 VDD A_XLA2 XWLDVA_WLC2 VDD pch
+ l=0.06U
+ w=0.41U
M9033 VDD XWLDVA_WLC2 A_WL2 VDD pch_hvt
+ l=0.06U
+ w=5U
M9034 VDD XWLDVA_WLC2 A_WL2 VDD pch_hvt
+ l=0.06U
+ w=5U
M9035 VDD XWLDVA_WLC2 A_WL2 VDD pch_hvt
+ l=0.06U
+ w=5U
M9036 VSS A_XLC XWLDVA_Z2_0 VSS nch
+ l=0.06U
+ w=0.81U
M9037 XWLDVA_Z2_0 A_XLC VSS VSS nch
+ l=0.06U
+	 w=0.81U
M9038 XWLDVA_Z2_1 A_XLC VSS VSS nch
+ l=0.06U
+ w=0.81U
M9039 XWLDVA_Z2_1 A_XLB XWLDVA_Z1 VSS nch
+ l=0.06U
+	 w=0.81U
M9040 XWLDVA_Z1 A_XLB XWLDVA_Z2_0 VSS nch
+ l=0.06U
+	 w=0.81U
M9041 VSS A_XLC XWLDVA_Z2_1 VSS nch
+ l=0.06U
+	 w=0.81U
M9042 XWLDVA_WLC1 A_XLA1 XWLDVA_Z1 VSS nch
+ l=0.06U
+ w=0.61U
M9043 XWLDVA_WLC1 A_XLA1 XWLDVA_Z1 VSS nch
+ l=0.06U
+ w=0.61U
M9044 XWLDVA_WLC3 A_XLA3 XWLDVA_Z1 VSS nch
+ l=0.06U
+ w=0.61U
M9045 XWLDVA_WLC3 A_XLA3 XWLDVA_Z1 VSS nch
+ l=0.06U
+ w=0.61U
M9046 XWLDVA_WLC2 A_XLA2 XWLDVA_Z1 VSS nch
+ l=0.06U
+ w=0.61U
M9047 XWLDVA_WLC2 A_XLA2 XWLDVA_Z1 VSS nch
+ l=0.06U
+ w=0.61U
M9048 XWLDVA_WLC0 A_XLA0 XWLDVA_Z1 VSS nch
+ l=0.06U
+ w=0.61U
M9049 XWLDVA_WLC0 A_XLA0 XWLDVA_Z1 VSS nch
+ l=0.06U
+ w=0.61U
M9050 VDD A_XLC XWLDVA_WLC1 VDD pch
+ l=0.06U
+ w=0.41U
M9051 VDD A_XLB XWLDVA_WLC1 VDD pch
+ l=0.06U
+ w=0.41U
M9052 VDD A_XLA1 XWLDVA_WLC1 VDD pch
+ l=0.06U
+ w=0.41U
M9053 VDD XWLDVA_WLC1 A_WL1 VDD pch_hvt
+ l=0.06U
+ w=5U
M9054 VDD XWLDVA_WLC1 A_WL1 VDD pch_hvt
+ l=0.06U
+ w=5U
M9055 VDD XWLDVA_WLC1 A_WL1 VDD pch_hvt
+ l=0.06U
+ w=5U
M9056 VDD A_XLC XWLDVA_WLC3 VDD pch
+ l=0.06U
+ w=0.41U
M9057 VDD A_XLB XWLDVA_WLC3 VDD pch
+ l=0.06U
+ w=0.41U
M9058 VDD A_XLA3 XWLDVA_WLC3 VDD pch
+ l=0.06U
+ w=0.41U
M9059 VDD XWLDVA_WLC3 A_WL3 VDD pch_hvt
+ l=0.06U
+ w=5U
M9060 VDD XWLDVA_WLC3 A_WL3 VDD pch_hvt
+ l=0.06U
+ w=5U
M9061 VDD XWLDVA_WLC3 A_WL3 VDD pch_hvt
+ l=0.06U
+ w=5U
M9062 A_WL1 XWLDVA_WLC1 VSS VSS nch_hvt
+ l=0.06U
+	 w=1.335U
M9063 A_WL1 XWLDVA_WLC1 VSS VSS nch_hvt
+ l=0.06U
+ w=1.335U
M9064 A_WL1 XWLDVA_WLC1 VSS VSS nch_hvt
+ l=0.06U
+ w=1.33U
M9065 B_WL1 XWLDVB_WLC1 VSS VSS nch_hvt
+ l=0.06U
+	 w=1.335U
M9066 B_WL1 XWLDVB_WLC1 VSS VSS nch_hvt
+ l=0.06U
+ w=1.335U
M9067 B_WL1 XWLDVB_WLC1 VSS VSS nch_hvt
+ l=0.06U
+ w=1.33U
M9068 A_WL3 XWLDVA_WLC3 VSS VSS nch_hvt
+ l=0.06U
+	 w=1.335U
M9069 A_WL3 XWLDVA_WLC3 VSS VSS nch_hvt
+ l=0.06U
+ w=1.335U
M9070 A_WL3 XWLDVA_WLC3 VSS VSS nch_hvt
+ l=0.06U
+ w=1.33U
M9071 B_WL3 XWLDVB_WLC3 VSS VSS nch_hvt
+ l=0.06U
+	 w=1.335U
M9072 B_WL3 XWLDVB_WLC3 VSS VSS nch_hvt
+ l=0.06U
+ w=1.335U
M9073 B_WL3 XWLDVB_WLC3 VSS VSS nch_hvt
+ l=0.06U
+ w=1.33U
M9074 VDD B_XLC XWLDVB_WLC1 VDD pch
+ l=0.06U
+ w=0.41U
M9075 VDD B_XLB XWLDVB_WLC1 VDD pch
+ l=0.06U
+ w=0.41U
M9076 VDD B_XLA1 XWLDVB_WLC1 VDD pch
+ l=0.06U
+ w=0.41U
M9077 VDD XWLDVB_WLC1 B_WL1 VDD pch_hvt
+ l=0.06U
+ w=5U
M9078 VDD XWLDVB_WLC1 B_WL1 VDD pch_hvt
+ l=0.06U
+ w=5U
M9079 VDD XWLDVB_WLC1 B_WL1 VDD pch_hvt
+ l=0.06U
+ w=5U
M9080 VDD B_XLC XWLDVB_WLC3 VDD pch
+ l=0.06U
+ w=0.41U
M9081 VDD B_XLB XWLDVB_WLC3 VDD pch
+ l=0.06U
+ w=0.41U
M9082 VDD B_XLA3 XWLDVB_WLC3 VDD pch
+ l=0.06U
+ w=0.41U
M9083 VDD XWLDVB_WLC3 B_WL3 VDD pch_hvt
+ l=0.06U
+ w=5U
M9084 VDD XWLDVB_WLC3 B_WL3 VDD pch_hvt
+ l=0.06U
+ w=5U
M9085 VDD XWLDVB_WLC3 B_WL3 VDD pch_hvt
+ l=0.06U
+ w=5U
M9086 VSS B_XLC XWLDVB_Z2_0 VSS nch
+ l=0.06U
+ w=0.81U
M9087 XWLDVB_Z2_0 B_XLC VSS VSS nch
+ l=0.06U
+	 w=0.81U
M9088 XWLDVB_Z2_1 B_XLC VSS VSS nch
+ l=0.06U
+ w=0.81U
M9089 XWLDVB_Z2_1 B_XLB XWLDVB_Z1 VSS nch
+ l=0.06U
+	 w=0.81U
M9090 XWLDVB_Z1 B_XLB XWLDVB_Z2_0 VSS nch
+ l=0.06U
+	 w=0.81U
M9091 VSS B_XLC XWLDVB_Z2_1 VSS nch
+ l=0.06U
+	 w=0.81U
M9092 XWLDVB_WLC1 B_XLA1 XWLDVB_Z1 VSS nch
+ l=0.06U
+ w=0.61U
M9093 XWLDVB_WLC1 B_XLA1 XWLDVB_Z1 VSS nch
+ l=0.06U
+ w=0.61U
M9094 XWLDVB_WLC3 B_XLA3 XWLDVB_Z1 VSS nch
+ l=0.06U
+ w=0.61U
M9095 XWLDVB_WLC3 B_XLA3 XWLDVB_Z1 VSS nch
+ l=0.06U
+ w=0.61U
M9096 XWLDVB_WLC2 B_XLA2 XWLDVB_Z1 VSS nch
+ l=0.06U
+ w=0.61U
M9097 XWLDVB_WLC2 B_XLA2 XWLDVB_Z1 VSS nch
+ l=0.06U
+ w=0.61U
M9098 XWLDVB_WLC0 B_XLA0 XWLDVB_Z1 VSS nch
+ l=0.06U
+ w=0.61U
M9099 XWLDVB_WLC0 B_XLA0 XWLDVB_Z1 VSS nch
+ l=0.06U
+ w=0.61U
M9100 VDD B_XLC XWLDVB_WLC0 VDD pch
+ l=0.06U
+ w=0.41U
M9101 VDD B_XLB XWLDVB_WLC0 VDD pch
+ l=0.06U
+ w=0.41U
M9102 VDD B_XLA0 XWLDVB_WLC0 VDD pch
+ l=0.06U
+ w=0.41U
M9103 VDD XWLDVB_WLC0 B_WL0 VDD pch_hvt
+ l=0.06U
+ w=5U
M9104 VDD XWLDVB_WLC0 B_WL0 VDD pch_hvt
+ l=0.06U
+ w=5U
M9105 VDD XWLDVB_WLC0 B_WL0 VDD pch_hvt
+ l=0.06U
+ w=5U
M9106 VDD B_XLC XWLDVB_WLC2 VDD pch
+ l=0.06U
+ w=0.41U
M9107 VDD B_XLB XWLDVB_WLC2 VDD pch
+ l=0.06U
+ w=0.41U
M9108 VDD B_XLA2 XWLDVB_WLC2 VDD pch
+ l=0.06U
+ w=0.41U
M9109 VDD XWLDVB_WLC2 B_WL2 VDD pch_hvt
+ l=0.06U
+ w=5U
M9110 VDD XWLDVB_WLC2 B_WL2 VDD pch_hvt
+ l=0.06U
+ w=5U
M9111 VDD XWLDVB_WLC2 B_WL2 VDD pch_hvt
+ l=0.06U
+ w=5U
M9112 B_WL0 XWLDVB_WLC0 VSS VSS nch_hvt
+ l=0.06U
+	 w=1.335U
M9113 B_WL0 XWLDVB_WLC0 VSS VSS nch_hvt
+ l=0.06U
+ w=1.335U
M9114 B_WL0 XWLDVB_WLC0 VSS VSS nch_hvt
+ l=0.06U
+ w=1.33U
M9115 B_WL2 XWLDVB_WLC2 VSS VSS nch_hvt
+ l=0.06U
+	 w=1.335U
M9116 B_WL2 XWLDVB_WLC2 VSS VSS nch_hvt
+ l=0.06U
+ w=1.335U
M9117 B_WL2 XWLDVB_WLC2 VSS VSS nch_hvt
+ l=0.06U
+ w=1.33U
.ENDS
* MC
.SUBCKT SDL400W20S_NMC A_WL B_WL NWELL SUB A_BL A_BLB B_BL B_BLB GFA GFB
M9118 BLB_IN A_WL A_BLB SUB nchpg_hvtdpsr
+ l=0.08U w=0.105U
M9119 A_BL A_WL BL_IN SUB nchpg_hvtdpsr
+ l=0.08U w=0.105U
M9120 BLB_IN BL_IN VSS SUB nchpd_hvtdpsr
+ l=0.065U w=0.315U
M9121 VDD BL_IN BLB_IN NWELL pchpu_hvtdpsr
+ l=0.07U w=0.09U
M9122 BL_IN BLB_IN VDD NWELL pchpu_hvtdpsr
+ l=0.07U w=0.09U
M9123 B_BL B_WL BL_IN SUB nchpg_hvtdpsr
+ l=0.08U w=0.105U
M9124 BLB_IN B_WL B_BLB SUB nchpg_hvtdpsr
+ l=0.08U w=0.105U
M9125 VSS BLB_IN BL_IN SUB nchpd_hvtdpsr
+ l=0.065U w=0.315U
.ENDS
* DXCELL
.SUBCKT SDL400W20S_NDXCELL A_WL A_WLS B_WL B_WLS
M9126 VDD VSS XMC4X4_XMC3_3_BLB_IN VSS
+ nchpg_hvtdpsr l=0.08U
+ w=0.105U
M9127 XMC4X4_XMC3_3_BL_IN VSS VDD VSS
+ nchpg_hvtdpsr l=0.08U
+ w=0.105U
M9128 VDD A_WL XMC4X4_XMC3_2_BLB_IN VSS
+ nchpg_hvtdpsr l=0.08U
+ w=0.105U
M9129 XMC4X4_XMC3_2_BL_IN A_WL VDD VSS
+ nchpg_hvtdpsr l=0.08U
+ w=0.105U
M9130 XMC4X4_XMC3_1_BLB_IN VSS VDD VSS
+ nchpg_hvtdpsr l=0.08U
+ w=0.105U
M9131 VDD VSS XMC4X4_XMC3_1_BL_IN VSS
+ nchpg_hvtdpsr l=0.08U
+ w=0.105U
M9132 XMC4X4_XMC0_0_BL_IN VSS VDD VSS
+ nchpg_hvtdpsr l=0.08U
+ w=0.105U
M9133 VDD VSS XMC4X4_XMC0_0_BLB_IN VSS
+ nchpg_hvtdpsr l=0.08U
+ w=0.105U
M9134 VSS XMC4X4_XMC0_0_BL_IN
+ XMC4X4_XMC0_0_BLB_IN VSS nchpd_hvtdpsr
+ l=0.065U w=0.315U
M9135 XMC4X4_XMC3_3_BL_IN XMC4X4_XMC3_3_BLB_IN
+ VSS VSS nchpd_hvtdpsr l=0.065U
+ w=0.315U
M9136 VSS XMC4X4_XMC3_1_BLB_IN
+ XMC4X4_XMC3_1_BL_IN VSS nchpd_hvtdpsr
+ l=0.065U w=0.315U
M9137 VSS XMC4X4_XMC3_2_BL_IN
+ XMC4X4_XMC3_2_BLB_IN VSS nchpd_hvtdpsr
+ l=0.065U w=0.315U
M9138 XMC4X4_XMC0_0_BLB_IN XMC4X4_XMC0_0_BL_IN
+ VDD VDD pchpu_hvtdpsr l=0.07U
+ w=0.09U
M9139 XMC4X4_XMC3_3_BLB_IN XMC4X4_XMC3_3_BL_IN
+ VDD VDD pchpu_hvtdpsr l=0.07U
+ w=0.09U
M9140 VDD XMC4X4_XMC3_2_BLB_IN
+ XMC4X4_XMC3_2_BL_IN VDD pchpu_hvtdpsr
+ l=0.07U w=0.09U
M9141 VDD XMC4X4_XMC3_3_BLB_IN
+ XMC4X4_XMC3_3_BL_IN VDD pchpu_hvtdpsr
+ l=0.07U w=0.09U
M9142 XMC4X4_XMC3_1_BL_IN XMC4X4_XMC3_1_BLB_IN
+ VDD VDD pchpu_hvtdpsr l=0.07U
+ w=0.09U
M9143 VDD XMC4X4_XMC3_1_BL_IN
+ XMC4X4_XMC3_1_BLB_IN VDD pchpu_hvtdpsr
+ l=0.07U w=0.09U
M9144 XMC4X4_XMC3_2_BLB_IN XMC4X4_XMC3_2_BL_IN
+ VDD VDD pchpu_hvtdpsr l=0.07U
+ w=0.09U
M9145 VDD XMC4X4_XMC0_0_BLB_IN
+ XMC4X4_XMC0_0_BL_IN VDD pchpu_hvtdpsr
+ l=0.07U w=0.09U
M9146 VDD VSS XMC4X4_XMC2_3_BLB_IN VSS
+ nchpg_hvtdpsr l=0.08U
+ w=0.105U
M9147 XMC4X4_XMC0_0_BL_IN VSS VDD VSS
+ nchpg_hvtdpsr l=0.08U
+ w=0.105U
M9148 XMC4X4_XMC2_3_BL_IN VSS VDD VSS
+ nchpg_hvtdpsr l=0.08U
+ w=0.105U
M9149 VDD VSS XMC4X4_XMC0_0_BLB_IN VSS
+ nchpg_hvtdpsr l=0.08U
+ w=0.105U
M9150 XMC4X4_XMC2_1_BLB_IN VSS VDD VSS
+ nchpg_hvtdpsr l=0.08U
+ w=0.105U
M9151 VDD VSS XMC4X4_XMC2_1_BL_IN VSS
+ nchpg_hvtdpsr l=0.08U
+ w=0.105U
M9152 VDD VSS XMC4X4_XMC3_3_BLB_IN VSS
+ nchpg_hvtdpsr l=0.08U
+ w=0.105U
M9153 XMC4X4_XMC3_3_BL_IN VSS VDD VSS
+ nchpg_hvtdpsr l=0.08U
+ w=0.105U
M9154 XMC4X4_XMC3_1_BLB_IN VSS VDD VSS
+ nchpg_hvtdpsr l=0.08U
+ w=0.105U
M9155 VDD VSS XMC4X4_XMC2_0_BL_IN VSS
+ nchpg_hvtdpsr l=0.08U
+ w=0.105U
M9156 XMC4X4_XMC2_0_BLB_IN VSS VDD VSS
+ nchpg_hvtdpsr l=0.08U
+ w=0.105U
M9157 VDD VSS XMC4X4_XMC3_1_BL_IN VSS
+ nchpg_hvtdpsr l=0.08U
+ w=0.105U
M9158 VDD B_WL XMC4X4_XMC3_2_BLB_IN VSS
+ nchpg_hvtdpsr l=0.08U
+ w=0.105U
M9159 VDD B_WL XMC4X4_XMC2_2_BLB_IN VSS
+ nchpg_hvtdpsr l=0.08U
+ w=0.105U
M9160 XMC4X4_XMC2_2_BL_IN B_WL VDD VSS
+ nchpg_hvtdpsr l=0.08U
+ w=0.105U
M9161 XMC4X4_XMC3_2_BL_IN B_WL VDD VSS
+ nchpg_hvtdpsr l=0.08U
+ w=0.105U
M9162 VSS XMC4X4_XMC3_3_BL_IN
+ XMC4X4_XMC3_3_BLB_IN VSS nchpd_hvtdpsr
+ l=0.065U w=0.315U
M9163 XMC4X4_XMC2_1_BLB_IN XMC4X4_XMC2_1_BL_IN
+ VSS VSS nchpd_hvtdpsr l=0.065U
+ w=0.315U
M9164 XMC4X4_XMC3_2_BL_IN XMC4X4_XMC3_2_BLB_IN
+ VSS VSS nchpd_hvtdpsr l=0.065U
+ w=0.315U
M9165 XMC4X4_XMC2_2_BL_IN XMC4X4_XMC2_2_BLB_IN
+ VSS VSS nchpd_hvtdpsr l=0.065U
+ w=0.315U
M9166 XMC4X4_XMC3_1_BLB_IN XMC4X4_XMC3_1_BL_IN
+ VSS VSS nchpd_hvtdpsr l=0.065U
+ w=0.315U
M9167 VSS XMC4X4_XMC2_0_BLB_IN
+ XMC4X4_XMC2_0_BL_IN VSS nchpd_hvtdpsr
+ l=0.065U w=0.315U
M9168 VSS XMC4X4_XMC2_3_BL_IN
+ XMC4X4_XMC2_3_BLB_IN VSS nchpd_hvtdpsr
+ l=0.065U w=0.315U
M9169 XMC4X4_XMC0_0_BL_IN XMC4X4_XMC0_0_BLB_IN
+ VSS VSS nchpd_hvtdpsr l=0.065U
+ w=0.315U
M9170 VDD XMC4X4_XMC2_3_BLB_IN
+ XMC4X4_XMC2_3_BL_IN VDD pchpu_hvtdpsr
+ l=0.07U w=0.09U
M9171 VDD XMC4X4_XMC2_1_BL_IN
+ XMC4X4_XMC2_1_BLB_IN VDD pchpu_hvtdpsr
+ l=0.07U w=0.09U
M9172 VDD XMC4X4_XMC2_2_BLB_IN
+ XMC4X4_XMC2_2_BL_IN VDD pchpu_hvtdpsr
+ l=0.07U w=0.09U
M9173 XMC4X4_XMC2_1_BL_IN XMC4X4_XMC2_1_BLB_IN
+ VDD VDD pchpu_hvtdpsr l=0.07U
+ w=0.09U
M9174 VDD XMC4X4_XMC2_0_BL_IN
+ XMC4X4_XMC2_0_BLB_IN VDD pchpu_hvtdpsr
+ l=0.07U w=0.09U
M9175 XMC4X4_XMC2_0_BL_IN XMC4X4_XMC2_0_BLB_IN
+ VDD VDD pchpu_hvtdpsr l=0.07U
+ w=0.09U
M9176 XMC4X4_XMC2_2_BLB_IN XMC4X4_XMC2_2_BL_IN
+ VDD VDD pchpu_hvtdpsr l=0.07U
+ w=0.09U
M9177 XMC4X4_XMC2_3_BLB_IN XMC4X4_XMC2_3_BL_IN
+ VDD VDD pchpu_hvtdpsr l=0.07U
+ w=0.09U
M9178 XMC4X4_XMC2_1_BLB_IN VSS VDD VSS
+ nchpg_hvtdpsr l=0.08U
+ w=0.105U
M9179 VDD VSS XMC4X4_XMC2_1_BL_IN VSS
+ nchpg_hvtdpsr l=0.08U
+ w=0.105U
M9180 XMC4X4_XMC1_3_BLB_IN VSS VDD VSS
+ nchpg_hvtdpsr l=0.08U
+ w=0.105U
M9181 VDD VSS XMC4X4_XMC1_3_BL_IN VSS
+ nchpg_hvtdpsr l=0.08U
+ w=0.105U
M9182 VDD A_WL XMC4X4_XMC1_2_BLB_IN VSS
+ nchpg_hvtdpsr l=0.08U
+ w=0.105U
M9183 XMC4X4_XMC1_2_BL_IN A_WL VDD VSS
+ nchpg_hvtdpsr l=0.08U
+ w=0.105U
M9184 VDD A_WL XMC4X4_XMC2_2_BLB_IN VSS
+ nchpg_hvtdpsr l=0.08U
+ w=0.105U
M9185 XMC4X4_XMC2_2_BL_IN A_WL VDD VSS
+ nchpg_hvtdpsr l=0.08U
+ w=0.105U
M9186 XMC4X4_XMC1_1_BLB_IN VSS VDD VSS
+ nchpg_hvtdpsr l=0.08U
+ w=0.105U
M9187 VDD VSS XMC4X4_XMC2_0_BL_IN VSS
+ nchpg_hvtdpsr l=0.08U
+ w=0.105U
M9188 VDD VSS XMC4X4_XMC1_1_BL_IN VSS
+ nchpg_hvtdpsr l=0.08U
+ w=0.105U
M9189 XMC4X4_XMC2_0_BLB_IN VSS VDD VSS
+ nchpg_hvtdpsr l=0.08U
+ w=0.105U
M9190 XMC4X4_XMC1_0_BLB_IN VSS VDD VSS
+ nchpg_hvtdpsr l=0.08U
+ w=0.105U
M9191 VDD VSS XMC4X4_XMC2_3_BLB_IN VSS
+ nchpg_hvtdpsr l=0.08U
+ w=0.105U
M9192 VDD VSS XMC4X4_XMC1_0_BL_IN VSS
+ nchpg_hvtdpsr l=0.08U
+ w=0.105U
M9193 XMC4X4_XMC2_3_BL_IN VSS VDD VSS
+ nchpg_hvtdpsr l=0.08U
+ w=0.105U
M9194 VSS XMC4X4_XMC1_0_BLB_IN
+ XMC4X4_XMC1_0_BL_IN VSS nchpd_hvtdpsr
+ l=0.065U w=0.315U
M9195 XMC4X4_XMC2_3_BL_IN XMC4X4_XMC2_3_BLB_IN
+ VSS VSS nchpd_hvtdpsr l=0.065U
+ w=0.315U
M9196 VSS XMC4X4_XMC1_3_BLB_IN
+ XMC4X4_XMC1_3_BL_IN VSS nchpd_hvtdpsr
+ l=0.065U w=0.315U
M9197 VSS XMC4X4_XMC2_1_BLB_IN
+ XMC4X4_XMC2_1_BL_IN VSS nchpd_hvtdpsr
+ l=0.065U w=0.315U
M9198 VSS XMC4X4_XMC1_1_BLB_IN
+ XMC4X4_XMC1_1_BL_IN VSS nchpd_hvtdpsr
+ l=0.065U w=0.315U
M9199 XMC4X4_XMC2_0_BLB_IN XMC4X4_XMC2_0_BL_IN
+ VSS VSS nchpd_hvtdpsr l=0.065U
+ w=0.315U
M9200 VSS XMC4X4_XMC2_2_BL_IN
+ XMC4X4_XMC2_2_BLB_IN VSS nchpd_hvtdpsr
+ l=0.065U w=0.315U
M9201 VSS XMC4X4_XMC1_2_BL_IN
+ XMC4X4_XMC1_2_BLB_IN VSS nchpd_hvtdpsr
+ l=0.065U w=0.315U
M9202 XMC4X4_XMC1_0_BL_IN XMC4X4_XMC1_0_BLB_IN
+ VDD VDD pchpu_hvtdpsr l=0.07U
+ w=0.09U
M9203 VDD XMC4X4_XMC1_3_BL_IN
+ XMC4X4_XMC1_3_BLB_IN VDD pchpu_hvtdpsr
+ l=0.07U w=0.09U
M9204 VDD XMC4X4_XMC1_2_BLB_IN
+ XMC4X4_XMC1_2_BL_IN VDD pchpu_hvtdpsr
+ l=0.07U w=0.09U
M9205 XMC4X4_XMC1_3_BL_IN XMC4X4_XMC1_3_BLB_IN
+ VDD VDD pchpu_hvtdpsr l=0.07U
+ w=0.09U
M9206 XMC4X4_XMC1_1_BL_IN XMC4X4_XMC1_1_BLB_IN
+ VDD VDD pchpu_hvtdpsr l=0.07U
+ w=0.09U
M9207 VDD XMC4X4_XMC1_1_BL_IN
+ XMC4X4_XMC1_1_BLB_IN VDD pchpu_hvtdpsr
+ l=0.07U w=0.09U
M9208 XMC4X4_XMC1_2_BLB_IN XMC4X4_XMC1_2_BL_IN
+ VDD VDD pchpu_hvtdpsr l=0.07U
+ w=0.09U
M9209 VDD XMC4X4_XMC1_0_BL_IN
+ XMC4X4_XMC1_0_BLB_IN VDD pchpu_hvtdpsr
+ l=0.07U w=0.09U
M9210 XMC4X4_XMC0_3_BLB_IN VSS VDD VSS
+ nchpg_hvtdpsr l=0.08U
+ w=0.105U
M9211 XMC4X4_XMC1_0_BLB_IN VSS VDD VSS
+ nchpg_hvtdpsr l=0.08U
+ w=0.105U
M9212 VDD VSS XMC4X4_XMC1_0_BL_IN VSS
+ nchpg_hvtdpsr l=0.08U
+ w=0.105U
M9213 VDD VSS XMC4X4_XMC0_3_BL_IN VSS
+ nchpg_hvtdpsr l=0.08U
+ w=0.105U
M9214 VDD VSS XMC4X4_XMC3_0_BL_IN VSS
+ nchpg_hvtdpsr l=0.08U
+ w=0.105U
M9215 XMC4X4_XMC1_3_BLB_IN VSS VDD VSS
+ nchpg_hvtdpsr l=0.08U
+ w=0.105U
M9216 VDD VSS XMC4X4_XMC1_3_BL_IN VSS
+ nchpg_hvtdpsr l=0.08U
+ w=0.105U
M9217 XMC4X4_XMC3_0_BLB_IN VSS VDD VSS
+ nchpg_hvtdpsr l=0.08U
+ w=0.105U
M9218 XMC4X4_XMC1_1_BLB_IN VSS VDD VSS
+ nchpg_hvtdpsr l=0.08U
+ w=0.105U
M9219 VDD VSS XMC4X4_XMC1_1_BL_IN VSS
+ nchpg_hvtdpsr l=0.08U
+ w=0.105U
M9220 XMC4X4_XMC0_1_BLB_IN VSS VDD VSS
+ nchpg_hvtdpsr l=0.08U
+ w=0.105U
M9221 VDD VSS XMC4X4_XMC0_1_BL_IN VSS
+ nchpg_hvtdpsr l=0.08U
+ w=0.105U
M9222 XMC4X4_XMC0_2_BLB_IN B_WL VDD VSS
+ nchpg_hvtdpsr l=0.08U
+ w=0.105U
M9223 VDD B_WL XMC4X4_XMC0_2_BL_IN VSS
+ nchpg_hvtdpsr l=0.08U
+ w=0.105U
M9224 VDD B_WL XMC4X4_XMC1_2_BLB_IN VSS
+ nchpg_hvtdpsr l=0.08U
+ w=0.105U
M9225 XMC4X4_XMC1_2_BL_IN B_WL VDD VSS
+ nchpg_hvtdpsr l=0.08U
+ w=0.105U
M9226 VSS XMC4X4_XMC3_0_BLB_IN
+ XMC4X4_XMC3_0_BL_IN VSS nchpd_hvtdpsr
+ l=0.065U w=0.315U
M9227 XMC4X4_XMC1_3_BLB_IN XMC4X4_XMC1_3_BL_IN
+ VSS VSS nchpd_hvtdpsr l=0.065U
+ w=0.315U
M9228 XMC4X4_XMC0_2_BLB_IN XMC4X4_XMC0_2_BL_IN
+ VSS VSS nchpd_hvtdpsr l=0.065U
+ w=0.315U
M9229 XMC4X4_XMC1_2_BL_IN XMC4X4_XMC1_2_BLB_IN
+ VSS VSS nchpd_hvtdpsr l=0.065U
+ w=0.315U
M9230 VSS XMC4X4_XMC0_1_BLB_IN
+ XMC4X4_XMC0_1_BL_IN VSS nchpd_hvtdpsr
+ l=0.065U w=0.315U
M9231 XMC4X4_XMC1_1_BLB_IN XMC4X4_XMC1_1_BL_IN
+ VSS VSS nchpd_hvtdpsr l=0.065U
+ w=0.315U
M9232 XMC4X4_XMC1_0_BLB_IN XMC4X4_XMC1_0_BL_IN
+ VSS VSS nchpd_hvtdpsr l=0.065U
+ w=0.315U
M9233 XMC4X4_XMC0_3_BLB_IN XMC4X4_XMC0_3_BL_IN
+ VSS VSS nchpd_hvtdpsr l=0.065U
+ w=0.315U
M9234 XMC4X4_XMC0_3_BL_IN XMC4X4_XMC0_3_BLB_IN
+ VDD VDD pchpu_hvtdpsr l=0.07U
+ w=0.09U
M9235 XMC4X4_XMC3_0_BL_IN XMC4X4_XMC3_0_BLB_IN
+ VDD VDD pchpu_hvtdpsr l=0.07U
+ w=0.09U
M9236 VDD XMC4X4_XMC0_2_BL_IN
+ XMC4X4_XMC0_2_BLB_IN VDD pchpu_hvtdpsr
+ l=0.07U w=0.09U
M9237 VDD XMC4X4_XMC3_0_BL_IN
+ XMC4X4_XMC3_0_BLB_IN VDD pchpu_hvtdpsr
+ l=0.07U w=0.09U
M9238 VDD XMC4X4_XMC0_1_BL_IN
+ XMC4X4_XMC0_1_BLB_IN VDD pchpu_hvtdpsr
+ l=0.07U w=0.09U
M9239 XMC4X4_XMC0_1_BL_IN XMC4X4_XMC0_1_BLB_IN
+ VDD VDD pchpu_hvtdpsr l=0.07U
+ w=0.09U
M9240 XMC4X4_XMC0_2_BL_IN XMC4X4_XMC0_2_BLB_IN
+ VDD VDD pchpu_hvtdpsr l=0.07U
+ w=0.09U
M9241 VDD XMC4X4_XMC0_3_BL_IN
+ XMC4X4_XMC0_3_BLB_IN VDD pchpu_hvtdpsr
+ l=0.07U w=0.09U
M9242 VDD VSS XMC4X4_XMC3_0_BL_IN VSS
+ nchpg_hvtdpsr l=0.08U
+ w=0.105U
M9243 XMC4X4_XMC3_0_BLB_IN VSS VDD VSS
+ nchpg_hvtdpsr l=0.08U
+ w=0.105U
M9244 VDD A_WL XMC4X4_XMC0_2_BL_IN VSS
+ nchpg_hvtdpsr l=0.08U
+ w=0.105U
M9245 XMC4X4_XMC0_2_BLB_IN A_WL VDD VSS
+ nchpg_hvtdpsr l=0.08U
+ w=0.105U
M9246 VDD VSS XMC4X4_XMC0_1_BL_IN VSS
+ nchpg_hvtdpsr l=0.08U
+ w=0.105U
M9247 XMC4X4_XMC0_1_BLB_IN VSS VDD VSS
+ nchpg_hvtdpsr l=0.08U
+ w=0.105U
M9248 XMC4X4_XMC0_3_BLB_IN VSS VDD VSS
+ nchpg_hvtdpsr l=0.08U
+ w=0.105U
M9249 VDD VSS XMC4X4_XMC0_3_BL_IN VSS
+ nchpg_hvtdpsr l=0.08U
+ w=0.105U
M9250 VSS XMC4X4_XMC0_3_BLB_IN
+ XMC4X4_XMC0_3_BL_IN VSS nchpd_hvtdpsr
+ l=0.065U w=0.315U
M9251 XMC4X4_XMC3_0_BLB_IN XMC4X4_XMC3_0_BL_IN
+ VSS VSS nchpd_hvtdpsr l=0.065U
+ w=0.315U
M9252 XMC4X4_XMC0_1_BLB_IN XMC4X4_XMC0_1_BL_IN
+ VSS VSS nchpd_hvtdpsr l=0.065U
+ w=0.315U
M9253 VSS XMC4X4_XMC0_2_BLB_IN
+ XMC4X4_XMC0_2_BL_IN VSS nchpd_hvtdpsr
+ l=0.065U w=0.315U
.ENDS
* DYCELL
.SUBCKT SDL400W20S_NDYCELL A_BL A_BLB B_BL B_BLB GFA_3 GFA_2 GFA_1 GFA_0
+	 GFB_3 GFB_2 GFB_1 GFB_0
M9254 XMC4X4_XMC0_3_BLB_IN VSS VDD VSS
+ nchpg_hvtdpsr l=0.08U
+ w=0.105U
M9255 VDD VSS XMC4X4_XMC0_3_BL_IN VSS
+ nchpg_hvtdpsr l=0.08U
+ w=0.105U
M9256 VDD VSS XMC4X4_XMC0_1_BL_IN VSS
+ nchpg_hvtdpsr l=0.08U
+ w=0.105U
M9257 XMC4X4_XMC0_1_BLB_IN VSS VDD VSS
+ nchpg_hvtdpsr l=0.08U
+ w=0.105U
M9258 XMC4X4_XMC3_3_BLB_IN VSS VDD VSS
+ nchpg_hvtdpsr l=0.08U
+ w=0.105U
M9259 VDD VSS XMC4X4_XMC3_3_BL_IN VSS
+ nchpg_hvtdpsr l=0.08U
+ w=0.105U
M9260 XMC4X4_XMC3_2_BLB_IN VSS VDD VSS
+ nchpg_hvtdpsr l=0.08U
+ w=0.105U
M9261 VDD VSS XMC4X4_XMC3_2_BL_IN VSS
+ nchpg_hvtdpsr l=0.08U
+ w=0.105U
M9262 VSS XMC4X4_XMC3_2_BLB_IN
+ XMC4X4_XMC3_2_BL_IN VSS nchpd_hvtdpsr
+ l=0.065U w=0.315U
M9263 VSS XMC4X4_XMC0_3_BLB_IN
+ XMC4X4_XMC0_3_BL_IN VSS nchpd_hvtdpsr
+ l=0.065U w=0.315U
M9264 VSS XMC4X4_XMC3_3_BLB_IN
+ XMC4X4_XMC3_3_BL_IN VSS nchpd_hvtdpsr
+ l=0.065U w=0.315U
M9265 VSS XMC4X4_XMC0_1_BLB_IN
+ XMC4X4_XMC0_1_BL_IN VSS nchpd_hvtdpsr
+ l=0.065U w=0.315U
M9266 XMC4X4_XMC3_2_BL_IN XMC4X4_XMC3_2_BLB_IN
+ VDD VDD pchpu_hvtdpsr l=0.07U
+ w=0.09U
M9267 VDD XMC4X4_XMC0_3_BL_IN
+ XMC4X4_XMC0_3_BLB_IN VDD pchpu_hvtdpsr
+ l=0.07U w=0.09U
M9268 VDD XMC4X4_XMC0_1_BL_IN
+ XMC4X4_XMC0_1_BLB_IN VDD pchpu_hvtdpsr
+ l=0.07U w=0.09U
M9269 XMC4X4_XMC0_3_BL_IN XMC4X4_XMC0_3_BLB_IN
+ VDD VDD pchpu_hvtdpsr l=0.07U
+ w=0.09U
M9270 XMC4X4_XMC3_3_BL_IN XMC4X4_XMC3_3_BLB_IN
+ VDD VDD pchpu_hvtdpsr l=0.07U
+ w=0.09U
M9271 VDD XMC4X4_XMC3_3_BL_IN
+ XMC4X4_XMC3_3_BLB_IN VDD pchpu_hvtdpsr
+ l=0.07U w=0.09U
M9272 XMC4X4_XMC0_1_BL_IN XMC4X4_XMC0_1_BLB_IN
+ VDD VDD pchpu_hvtdpsr l=0.07U
+ w=0.09U
M9273 VDD XMC4X4_XMC3_2_BL_IN
+ XMC4X4_XMC3_2_BLB_IN VDD pchpu_hvtdpsr
+ l=0.07U w=0.09U
M9274 VDD VSS XMC4X4_XMC1_0_BL_IN VSS
+ nchpg_hvtdpsr l=0.08U
+ w=0.105U
M9275 XMC4X4_XMC3_2_BLB_IN VSS VDD VSS
+ nchpg_hvtdpsr l=0.08U
+ w=0.105U
M9276 XMC4X4_XMC1_0_BLB_IN VSS VDD VSS
+ nchpg_hvtdpsr l=0.08U
+ w=0.105U
M9277 VDD VSS XMC4X4_XMC3_2_BL_IN VSS
+ nchpg_hvtdpsr l=0.08U
+ w=0.105U
M9278 VDD VSS XMC4X4_XMC1_1_BL_IN VSS
+ nchpg_hvtdpsr l=0.08U
+ w=0.105U
M9279 XMC4X4_XMC1_1_BLB_IN VSS VDD VSS
+ nchpg_hvtdpsr l=0.08U
+ w=0.105U
M9280 XMC4X4_XMC0_3_BLB_IN VSS VDD VSS
+ nchpg_hvtdpsr l=0.08U
+ w=0.105U
M9281 VDD VSS XMC4X4_XMC0_3_BL_IN VSS
+ nchpg_hvtdpsr l=0.08U
+ w=0.105U
M9282 XMC4X4_XMC3_3_BLB_IN VSS VDD VSS
+ nchpg_hvtdpsr l=0.08U
+ w=0.105U
M9283 VDD VSS XMC4X4_XMC1_3_BL_IN VSS
+ nchpg_hvtdpsr l=0.08U
+ w=0.105U
M9284 XMC4X4_XMC1_3_BLB_IN VSS VDD VSS
+ nchpg_hvtdpsr l=0.08U
+ w=0.105U
M9285 VDD VSS XMC4X4_XMC3_3_BL_IN VSS
+ nchpg_hvtdpsr l=0.08U
+ w=0.105U
M9286 VDD VSS XMC4X4_XMC0_1_BL_IN VSS
+ nchpg_hvtdpsr l=0.08U
+ w=0.105U
M9287 XMC4X4_XMC1_2_BLB_IN VSS VDD VSS
+ nchpg_hvtdpsr l=0.08U
+ w=0.105U
M9288 VDD VSS XMC4X4_XMC1_2_BL_IN VSS
+ nchpg_hvtdpsr l=0.08U
+ w=0.105U
M9289 XMC4X4_XMC0_1_BLB_IN VSS VDD VSS
+ nchpg_hvtdpsr l=0.08U
+ w=0.105U
M9290 XMC4X4_XMC0_3_BLB_IN XMC4X4_XMC0_3_BL_IN
+ VSS VSS nchpd_hvtdpsr l=0.065U
+ w=0.315U
M9291 VSS XMC4X4_XMC1_1_BLB_IN
+ XMC4X4_XMC1_1_BL_IN VSS nchpd_hvtdpsr
+ l=0.065U w=0.315U
M9292 XMC4X4_XMC0_1_BLB_IN XMC4X4_XMC0_1_BL_IN
+ VSS VSS nchpd_hvtdpsr l=0.065U
+ w=0.315U
M9293 VSS XMC4X4_XMC1_2_BLB_IN
+ XMC4X4_XMC1_2_BL_IN VSS nchpd_hvtdpsr
+ l=0.065U w=0.315U
M9294 XMC4X4_XMC3_3_BLB_IN XMC4X4_XMC3_3_BL_IN
+ VSS VSS nchpd_hvtdpsr l=0.065U
+ w=0.315U
M9295 VSS XMC4X4_XMC1_3_BLB_IN
+ XMC4X4_XMC1_3_BL_IN VSS nchpd_hvtdpsr
+ l=0.065U w=0.315U
M9296 VSS XMC4X4_XMC1_0_BLB_IN
+ XMC4X4_XMC1_0_BL_IN VSS nchpd_hvtdpsr
+ l=0.065U w=0.315U
M9297 XMC4X4_XMC3_2_BLB_IN XMC4X4_XMC3_2_BL_IN
+ VSS VSS nchpd_hvtdpsr l=0.065U
+ w=0.315U
M9298 VDD XMC4X4_XMC1_0_BL_IN
+ XMC4X4_XMC1_0_BLB_IN VDD pchpu_hvtdpsr
+ l=0.07U w=0.09U
M9299 XMC4X4_XMC1_1_BL_IN XMC4X4_XMC1_1_BLB_IN
+ VDD VDD pchpu_hvtdpsr l=0.07U
+ w=0.09U
M9300 XMC4X4_XMC1_2_BL_IN XMC4X4_XMC1_2_BLB_IN
+ VDD VDD pchpu_hvtdpsr l=0.07U
+ w=0.09U
M9301 VDD XMC4X4_XMC1_1_BL_IN
+ XMC4X4_XMC1_1_BLB_IN VDD pchpu_hvtdpsr
+ l=0.07U w=0.09U
M9302 VDD XMC4X4_XMC1_3_BL_IN
+ XMC4X4_XMC1_3_BLB_IN VDD pchpu_hvtdpsr
+ l=0.07U w=0.09U
M9303 XMC4X4_XMC1_3_BL_IN XMC4X4_XMC1_3_BLB_IN
+ VDD VDD pchpu_hvtdpsr l=0.07U
+ w=0.09U
M9304 VDD XMC4X4_XMC1_2_BL_IN
+ XMC4X4_XMC1_2_BLB_IN VDD pchpu_hvtdpsr
+ l=0.07U w=0.09U
M9305 XMC4X4_XMC1_0_BL_IN XMC4X4_XMC1_0_BLB_IN
+ VDD VDD pchpu_hvtdpsr l=0.07U
+ w=0.09U
M9306 A_BL VSS XMC4X4_XMC1_1_BL_IN VSS
+ nchpg_hvtdpsr l=0.08U
+ w=0.105U
M9307 XMC4X4_XMC1_1_BLB_IN VSS A_BLB VSS
+ nchpg_hvtdpsr l=0.08U
+ w=0.105U
M9308 B_BL VSS XMC4X4_XMC2_3_BL_IN VSS
+ nchpg_hvtdpsr l=0.08U
+ w=0.105U
M9309 XMC4X4_XMC2_3_BLB_IN VSS B_BLB VSS
+ nchpg_hvtdpsr l=0.08U
+ w=0.105U
M9310 XMC4X4_XMC2_2_BLB_IN VSS B_BLB VSS
+ nchpg_hvtdpsr l=0.08U
+ w=0.105U
M9311 B_BL VSS XMC4X4_XMC2_2_BL_IN VSS
+ nchpg_hvtdpsr l=0.08U
+ w=0.105U
M9312 XMC4X4_XMC1_2_BLB_IN VSS A_BLB VSS
+ nchpg_hvtdpsr l=0.08U
+ w=0.105U
M9313 A_BL VSS XMC4X4_XMC1_2_BL_IN VSS
+ nchpg_hvtdpsr l=0.08U
+ w=0.105U
M9314 B_BL VSS XMC4X4_XMC2_0_BL_IN VSS
+ nchpg_hvtdpsr l=0.08U
+ w=0.105U
M9315 A_BL VSS XMC4X4_XMC1_3_BL_IN VSS
+ nchpg_hvtdpsr l=0.08U
+ w=0.105U
M9316 XMC4X4_XMC2_0_BLB_IN VSS B_BLB VSS
+ nchpg_hvtdpsr l=0.08U
+ w=0.105U
M9317 XMC4X4_XMC1_3_BLB_IN VSS A_BLB VSS
+ nchpg_hvtdpsr l=0.08U
+ w=0.105U
M9318 B_BL VSS XMC4X4_XMC2_1_BL_IN VSS
+ nchpg_hvtdpsr l=0.08U
+ w=0.105U
M9319 A_BL VSS XMC4X4_XMC1_0_BL_IN VSS
+ nchpg_hvtdpsr l=0.08U
+ w=0.105U
M9320 XMC4X4_XMC2_1_BLB_IN VSS B_BLB VSS
+ nchpg_hvtdpsr l=0.08U
+ w=0.105U
M9321 XMC4X4_XMC1_0_BLB_IN VSS A_BLB VSS
+ nchpg_hvtdpsr l=0.08U
+ w=0.105U
M9322 XMC4X4_XMC2_1_BLB_IN XMC4X4_XMC2_1_BL_IN
+ VSS VSS nchpd_hvtdpsr l=0.065U
+ w=0.315U
M9323 XMC4X4_XMC1_0_BLB_IN XMC4X4_XMC1_0_BL_IN
+ VSS VSS nchpd_hvtdpsr l=0.065U
+ w=0.315U
M9324 XMC4X4_XMC2_3_BLB_IN XMC4X4_XMC2_3_BL_IN
+ VSS VSS nchpd_hvtdpsr l=0.065U
+ w=0.315U
M9325 XMC4X4_XMC1_1_BLB_IN XMC4X4_XMC1_1_BL_IN
+ VSS VSS nchpd_hvtdpsr l=0.065U
+ w=0.315U
M9326 XMC4X4_XMC2_0_BLB_IN XMC4X4_XMC2_0_BL_IN
+ VSS VSS nchpd_hvtdpsr l=0.065U
+ w=0.315U
M9327 XMC4X4_XMC1_3_BLB_IN XMC4X4_XMC1_3_BL_IN
+ VSS VSS nchpd_hvtdpsr l=0.065U
+ w=0.315U
M9328 XMC4X4_XMC1_2_BLB_IN XMC4X4_XMC1_2_BL_IN
+ VSS VSS nchpd_hvtdpsr l=0.065U
+ w=0.315U
M9329 XMC4X4_XMC2_2_BLB_IN XMC4X4_XMC2_2_BL_IN
+ VSS VSS nchpd_hvtdpsr l=0.065U
+ w=0.315U
M9330 VDD XMC4X4_XMC2_1_BL_IN
+ XMC4X4_XMC2_1_BLB_IN VDD pchpu_hvtdpsr
+ l=0.07U w=0.09U
M9331 XMC4X4_XMC2_3_BL_IN XMC4X4_XMC2_3_BLB_IN
+ VDD VDD pchpu_hvtdpsr l=0.07U
+ w=0.09U
M9332 XMC4X4_XMC2_2_BL_IN XMC4X4_XMC2_2_BLB_IN
+ VDD VDD pchpu_hvtdpsr l=0.07U
+ w=0.09U
M9333 VDD XMC4X4_XMC2_3_BL_IN
+ XMC4X4_XMC2_3_BLB_IN VDD pchpu_hvtdpsr
+ l=0.07U w=0.09U
M9334 VDD XMC4X4_XMC2_0_BL_IN
+ XMC4X4_XMC2_0_BLB_IN VDD pchpu_hvtdpsr
+ l=0.07U w=0.09U
M9335 XMC4X4_XMC2_0_BL_IN XMC4X4_XMC2_0_BLB_IN
+ VDD VDD pchpu_hvtdpsr l=0.07U
+ w=0.09U
M9336 VDD XMC4X4_XMC2_2_BL_IN
+ XMC4X4_XMC2_2_BLB_IN VDD pchpu_hvtdpsr
+ l=0.07U w=0.09U
M9337 XMC4X4_XMC2_1_BL_IN XMC4X4_XMC2_1_BLB_IN
+ VDD VDD pchpu_hvtdpsr l=0.07U
+ w=0.09U
M9338 XMC4X4_XMC0_2_BLB_IN VSS VDD VSS
+ nchpg_hvtdpsr l=0.08U
+ w=0.105U
M9339 VDD VSS XMC4X4_XMC2_1_BL_IN VSS
+ nchpg_hvtdpsr l=0.08U
+ w=0.105U
M9340 XMC4X4_XMC2_1_BLB_IN VSS VDD VSS
+ nchpg_hvtdpsr l=0.08U
+ w=0.105U
M9341 VDD VSS XMC4X4_XMC0_2_BL_IN VSS
+ nchpg_hvtdpsr l=0.08U
+ w=0.105U
M9342 VDD VSS XMC4X4_XMC3_1_BLB_IN VSS
+ nchpg_hvtdpsr l=0.08U
+ w=0.105U
M9343 VDD VSS XMC4X4_XMC2_3_BL_IN VSS
+ nchpg_hvtdpsr l=0.08U
+ w=0.105U
M9344 XMC4X4_XMC2_3_BLB_IN VSS VDD VSS
+ nchpg_hvtdpsr l=0.08U
+ w=0.105U
M9345 XMC4X4_XMC3_1_BL_IN VSS VDD VSS
+ nchpg_hvtdpsr l=0.08U
+ w=0.105U
M9346 VDD VSS XMC4X4_XMC2_0_BL_IN VSS
+ nchpg_hvtdpsr l=0.08U
+ w=0.105U
M9347 XMC4X4_XMC2_0_BLB_IN VSS VDD VSS
+ nchpg_hvtdpsr l=0.08U
+ w=0.105U
M9348 XMC4X4_XMC0_0_BLB_IN VSS VDD VSS
+ nchpg_hvtdpsr l=0.08U
+ w=0.105U
M9349 VDD VSS XMC4X4_XMC0_0_BL_IN VSS
+ nchpg_hvtdpsr l=0.08U
+ w=0.105U
M9350 VDD VSS XMC4X4_XMC3_0_BL_IN VSS
+ nchpg_hvtdpsr l=0.08U
+ w=0.105U
M9351 XMC4X4_XMC3_0_BLB_IN VSS VDD VSS
+ nchpg_hvtdpsr l=0.08U
+ w=0.105U
M9352 XMC4X4_XMC2_2_BLB_IN VSS VDD VSS
+ nchpg_hvtdpsr l=0.08U
+ w=0.105U
M9353 VDD VSS XMC4X4_XMC2_2_BL_IN VSS
+ nchpg_hvtdpsr l=0.08U
+ w=0.105U
M9354 VSS XMC4X4_XMC3_1_BL_IN
+ XMC4X4_XMC3_1_BLB_IN VSS nchpd_hvtdpsr
+ l=0.065U w=0.315U
M9355 VSS XMC4X4_XMC2_3_BLB_IN
+ XMC4X4_XMC2_3_BL_IN VSS nchpd_hvtdpsr
+ l=0.065U w=0.315U
M9356 VSS XMC4X4_XMC3_0_BLB_IN
+ XMC4X4_XMC3_0_BL_IN VSS nchpd_hvtdpsr
+ l=0.065U w=0.315U
M9357 VSS XMC4X4_XMC2_2_BLB_IN
+ XMC4X4_XMC2_2_BL_IN VSS nchpd_hvtdpsr
+ l=0.065U w=0.315U
M9358 VSS XMC4X4_XMC0_0_BLB_IN
+ XMC4X4_XMC0_0_BL_IN VSS nchpd_hvtdpsr
+ l=0.065U w=0.315U
M9359 VSS XMC4X4_XMC2_0_BLB_IN
+ XMC4X4_XMC2_0_BL_IN VSS nchpd_hvtdpsr
+ l=0.065U w=0.315U
M9360 VSS XMC4X4_XMC2_1_BLB_IN
+ XMC4X4_XMC2_1_BL_IN VSS nchpd_hvtdpsr
+ l=0.065U w=0.315U
M9361 XMC4X4_XMC0_2_BLB_IN XMC4X4_XMC0_2_BL_IN
+ VSS VSS nchpd_hvtdpsr l=0.065U
+ w=0.315U
M9362 XMC4X4_XMC0_2_BL_IN XMC4X4_XMC0_2_BLB_IN
+ VDD VDD pchpu_hvtdpsr l=0.07U
+ w=0.09U
M9363 XMC4X4_XMC3_1_BLB_IN XMC4X4_XMC3_1_BL_IN
+ VDD VDD pchpu_hvtdpsr l=0.07U
+ w=0.09U
M9364 XMC4X4_XMC3_0_BL_IN XMC4X4_XMC3_0_BLB_IN
+ VDD VDD pchpu_hvtdpsr l=0.07U
+ w=0.09U
M9365 VDD XMC4X4_XMC3_1_BLB_IN
+ XMC4X4_XMC3_1_BL_IN VDD pchpu_hvtdpsr
+ l=0.07U w=0.09U
M9366 VDD XMC4X4_XMC0_0_BL_IN
+ XMC4X4_XMC0_0_BLB_IN VDD pchpu_hvtdpsr
+ l=0.07U w=0.09U
M9367 XMC4X4_XMC0_0_BL_IN XMC4X4_XMC0_0_BLB_IN
+ VDD VDD pchpu_hvtdpsr l=0.07U
+ w=0.09U
M9368 VDD XMC4X4_XMC3_0_BL_IN
+ XMC4X4_XMC3_0_BLB_IN VDD pchpu_hvtdpsr
+ l=0.07U w=0.09U
M9369 VDD XMC4X4_XMC0_2_BL_IN
+ XMC4X4_XMC0_2_BLB_IN VDD pchpu_hvtdpsr
+ l=0.07U w=0.09U
M9370 VDD VSS XMC4X4_XMC3_1_BLB_IN VSS
+ nchpg_hvtdpsr l=0.08U
+ w=0.105U
M9371 XMC4X4_XMC3_1_BL_IN VSS VDD VSS
+ nchpg_hvtdpsr l=0.08U
+ w=0.105U
M9372 XMC4X4_XMC3_0_BLB_IN VSS VDD VSS
+ nchpg_hvtdpsr l=0.08U
+ w=0.105U
M9373 VDD VSS XMC4X4_XMC3_0_BL_IN VSS
+ nchpg_hvtdpsr l=0.08U
+ w=0.105U
M9374 VDD VSS XMC4X4_XMC0_0_BL_IN VSS
+ nchpg_hvtdpsr l=0.08U
+ w=0.105U
M9375 XMC4X4_XMC0_0_BLB_IN VSS VDD VSS
+ nchpg_hvtdpsr l=0.08U
+ w=0.105U
M9376 XMC4X4_XMC0_2_BLB_IN VSS VDD VSS
+ nchpg_hvtdpsr l=0.08U
+ w=0.105U
M9377 VDD VSS XMC4X4_XMC0_2_BL_IN VSS
+ nchpg_hvtdpsr l=0.08U
+ w=0.105U
M9378 VSS XMC4X4_XMC0_2_BLB_IN
+ XMC4X4_XMC0_2_BL_IN VSS nchpd_hvtdpsr
+ l=0.065U w=0.315U
M9379 XMC4X4_XMC3_1_BL_IN XMC4X4_XMC3_1_BLB_IN
+ VSS VSS nchpd_hvtdpsr l=0.065U
+ w=0.315U
M9380 XMC4X4_XMC0_0_BLB_IN XMC4X4_XMC0_0_BL_IN
+ VSS VSS nchpd_hvtdpsr l=0.065U
+ w=0.315U
M9381 XMC4X4_XMC3_0_BLB_IN XMC4X4_XMC3_0_BL_IN
+ VSS VSS nchpd_hvtdpsr l=0.065U
+ w=0.315U
.ENDS
* DGWLDV0
.SUBCKT SDL400W20S_NDGWLDV0 A_GCDEC_3 A_GCDEC_2 A_GCDEC_1 A_GCDEC_0 A_RD
+	 A_VS_1 A_VS_0 A_WRT A_XA_7 A_XA_6 A_XA_5 A_XA_4 A_XA_3 A_XA_2
+	 A_XA_1 A_XA_0 A_XB_3 A_XB_2 A_XB_1 A_XB_0 A_XC_7 A_XC_6
+	 A_XC_5 A_XC_4 A_XC_3 A_XC_2 A_XC_1 A_XC_0 A_Y_7 A_Y_6 A_Y_5
+	 A_Y_4 A_Y_3 A_Y_2 A_Y_1 A_Y_0 A_Z_7 A_Z_6 A_Z_5 A_Z_4 A_Z_3
+	 A_Z_2 A_Z_1 A_Z_0 B_GCDEC_3 B_GCDEC_2 B_GCDEC_1 B_GCDEC_0
+	 B_RD B_VS_1 B_VS_0 B_WRT B_XA_7 B_XA_6 B_XA_5 B_XA_4 B_XA_3
+	 B_XA_2 B_XA_1 B_XA_0 B_XB_3 B_XB_2 B_XB_1 B_XB_0 B_XC_7
+	 B_XC_6 B_XC_5 B_XC_4 B_XC_3 B_XC_2 B_XC_1 B_XC_0 B_Y_7 B_Y_6
+	 B_Y_5 B_Y_4 B_Y_3 B_Y_2 B_Y_1 B_Y_0 B_Z_7 B_Z_6 B_Z_5 B_Z_4
+	 B_Z_3 B_Z_2 B_Z_1 B_Z_0
M9382 NC VSS VSS VSS nch_hvt
+ l=0.06U
+ w=0.15U
.ENDS
* DWLDV0
.SUBCKT SDL400W20S_NDWLDV0 XLA_7 XLA_6 XLA_5 XLA_4 XLA_3 XLA_2 XLA_1 XLA_0
+	 XLB_3 XLB_2 XLB_1 XLB_0 XLC_7 XLC_6 XLC_5 XLC_4 XLC_3 XLC_2
+	 XLC_1 XLC_0
M9383 NC VSS VSS VSS nch_hvt
+ l=0.06U
+ w=0.15U
.ENDS
* AIN1
.SUBCKT SDL400W20S_NAIN1 PIN
DD0 VSS PIN ndio AREA=0.1295P PJ=1.44U
.ENDS

**** End of leaf cells

.SUBCKT SDL400W20S_NMCROW A_WL[0] A_WL[1] A_WL[2] A_WL[3] B_WL[0] B_WL[1]
+ B_WL[2] B_WL[3] A_BL[0] A_BL[1] A_BL[2] A_BL[3] A_BLB[0] A_BLB[1] A_BLB[2]
+ A_BLB[3] GFA[0] GFA[1] GFA[2] GFA[3] B_BL[0] B_BL[1] B_BL[2] B_BL[3] B_BLB[0]
+ B_BLB[1] B_BLB[2] B_BLB[3] GFB[0] GFB[1] GFB[2] GFB[3]
XMC4X4G A_WL[3] A_WL[2] A_WL[1] A_WL[0] A_WL[3] A_WL[2] A_WL[1] A_WL[0]
+ B_WL[3] B_WL[2] B_WL[1] B_WL[0] B_WL[3] B_WL[2] B_WL[1] B_WL[0] VDD VSS
+ A_BL[3] A_BL[2] A_BL[1] A_BL[0] A_BLB[3] A_BLB[2] A_BLB[1] A_BLB[0] B_BL[3]
+ B_BL[2] B_BL[1] B_BL[0] B_BLB[3] B_BLB[2] B_BLB[1] B_BLB[0] GFA[3] GFA[2]
+ GFA[1] GFA[0] GFB[3] GFB[2] GFB[1] GFB[0] SDL400W20S_NMC4X4G
.ENDS

.SUBCKT SDL400W20S_NBITSLC A_WL[0] A_WL[1] A_WL[2] A_WL[3] A_WL[4] A_WL[5]
+ A_WL[6] A_WL[7] A_WL[8] A_WL[9] A_WL[10] A_WL[11] A_WL[12] A_WL[13] A_WL[14]
+ A_WL[15] A_WL[16] A_WL[17] A_WL[18] A_WL[19] A_WL[20] A_WL[21] A_WL[22]
+ A_WL[23] A_WL[24] A_WL[25] A_WL[26] A_WL[27] A_WL[28] A_WL[29] A_WL[30]
+ A_WL[31] A_WL[32] A_WL[33] A_WL[34] A_WL[35] A_WL[36] A_WL[37] A_WL[38]
+ A_WL[39] A_WL[40] A_WL[41] A_WL[42] A_WL[43] A_WL[44] A_WL[45] A_WL[46]
+ A_WL[47] A_WL[48] A_WL[49] A_WL[50] A_WL[51] A_WL[52] A_WL[53] A_WL[54]
+ A_WL[55] A_WL[56] A_WL[57] A_WL[58] A_WL[59] A_WL[60] A_WL[61] A_WL[62]
+ A_WL[63] A_WL[64] A_WL[65] A_WL[66] A_WL[67] A_WL[68] A_WL[69] A_WL[70]
+ A_WL[71] A_WL[72] A_WL[73] A_WL[74] A_WL[75] A_WL[76] A_WL[77] A_WL[78]
+ A_WL[79] A_WL[80] A_WL[81] A_WL[82] A_WL[83] A_WL[84] A_WL[85] A_WL[86]
+ A_WL[87] A_WL[88] A_WL[89] A_WL[90] A_WL[91] A_WL[92] A_WL[93] A_WL[94]
+ A_WL[95] A_WL[96] A_WL[97] A_WL[98] A_WL[99] A_WL[100] A_WL[101] A_WL[102]
+ A_WL[103] A_WL[104] A_WL[105] A_WL[106] A_WL[107] A_WL[108] A_WL[109]
+ A_WL[110] A_WL[111] A_WL[112] A_WL[113] A_WL[114] A_WL[115] A_WL[116]
+ A_WL[117] A_WL[118] A_WL[119] A_WL[120] A_WL[121] A_WL[122] A_WL[123]
+ A_WL[124] A_WL[125] A_WL[126] A_WL[127] A_WL[128] A_WL[129] A_WL[130]
+ A_WL[131] A_WL[132] A_WL[133] A_WL[134] A_WL[135] A_WL[136] A_WL[137]
+ A_WL[138] A_WL[139] A_WL[140] A_WL[141] A_WL[142] A_WL[143] A_WL[144]
+ A_WL[145] A_WL[146] A_WL[147] A_WL[148] A_WL[149] A_WL[150] A_WL[151]
+ A_WL[152] A_WL[153] A_WL[154] A_WL[155] A_WL[156] A_WL[157] A_WL[158]
+ A_WL[159] A_WL[160] A_WL[161] A_WL[162] A_WL[163] A_WL[164] A_WL[165]
+ A_WL[166] A_WL[167] A_WL[168] A_WL[169] A_WL[170] A_WL[171] A_WL[172]
+ A_WL[173] A_WL[174] A_WL[175] A_WL[176] A_WL[177] A_WL[178] A_WL[179]
+ A_WL[180] A_WL[181] A_WL[182] A_WL[183] A_WL[184] A_WL[185] A_WL[186]
+ A_WL[187] A_WL[188] A_WL[189] A_WL[190] A_WL[191] A_WL[192] A_WL[193]
+ A_WL[194] A_WL[195] A_WL[196] A_WL[197] A_WL[198] A_WL[199] A_WL[200]
+ A_WL[201] A_WL[202] A_WL[203] A_WL[204] A_WL[205] A_WL[206] A_WL[207]
+ A_WL[208] A_WL[209] A_WL[210] A_WL[211] A_WL[212] A_WL[213] A_WL[214]
+ A_WL[215] A_WL[216] A_WL[217] A_WL[218] A_WL[219] A_WL[220] A_WL[221]
+ A_WL[222] A_WL[223] A_WL[224] A_WL[225] A_WL[226] A_WL[227] A_WL[228]
+ A_WL[229] A_WL[230] A_WL[231] A_WL[232] A_WL[233] A_WL[234] A_WL[235]
+ A_WL[236] A_WL[237] A_WL[238] A_WL[239] A_WL[240] A_WL[241] A_WL[242]
+ A_WL[243] A_WL[244] A_WL[245] A_WL[246] A_WL[247] A_WL[248] A_WL[249]
+ A_WL[250] A_WL[251] A_WL[252] A_WL[253] A_WL[254] A_WL[255] B_WL[0] B_WL[1]
+ B_WL[2] B_WL[3] B_WL[4] B_WL[5] B_WL[6] B_WL[7] B_WL[8] B_WL[9] B_WL[10]
+ B_WL[11] B_WL[12] B_WL[13] B_WL[14] B_WL[15] B_WL[16] B_WL[17] B_WL[18]
+ B_WL[19] B_WL[20] B_WL[21] B_WL[22] B_WL[23] B_WL[24] B_WL[25] B_WL[26]
+ B_WL[27] B_WL[28] B_WL[29] B_WL[30] B_WL[31] B_WL[32] B_WL[33] B_WL[34]
+ B_WL[35] B_WL[36] B_WL[37] B_WL[38] B_WL[39] B_WL[40] B_WL[41] B_WL[42]
+ B_WL[43] B_WL[44] B_WL[45] B_WL[46] B_WL[47] B_WL[48] B_WL[49] B_WL[50]
+ B_WL[51] B_WL[52] B_WL[53] B_WL[54] B_WL[55] B_WL[56] B_WL[57] B_WL[58]
+ B_WL[59] B_WL[60] B_WL[61] B_WL[62] B_WL[63] B_WL[64] B_WL[65] B_WL[66]
+ B_WL[67] B_WL[68] B_WL[69] B_WL[70] B_WL[71] B_WL[72] B_WL[73] B_WL[74]
+ B_WL[75] B_WL[76] B_WL[77] B_WL[78] B_WL[79] B_WL[80] B_WL[81] B_WL[82]
+ B_WL[83] B_WL[84] B_WL[85] B_WL[86] B_WL[87] B_WL[88] B_WL[89] B_WL[90]
+ B_WL[91] B_WL[92] B_WL[93] B_WL[94] B_WL[95] B_WL[96] B_WL[97] B_WL[98]
+ B_WL[99] B_WL[100] B_WL[101] B_WL[102] B_WL[103] B_WL[104] B_WL[105]
+ B_WL[106] B_WL[107] B_WL[108] B_WL[109] B_WL[110] B_WL[111] B_WL[112]
+ B_WL[113] B_WL[114] B_WL[115] B_WL[116] B_WL[117] B_WL[118] B_WL[119]
+ B_WL[120] B_WL[121] B_WL[122] B_WL[123] B_WL[124] B_WL[125] B_WL[126]
+ B_WL[127] B_WL[128] B_WL[129] B_WL[130] B_WL[131] B_WL[132] B_WL[133]
+ B_WL[134] B_WL[135] B_WL[136] B_WL[137] B_WL[138] B_WL[139] B_WL[140]
+ B_WL[141] B_WL[142] B_WL[143] B_WL[144] B_WL[145] B_WL[146] B_WL[147]
+ B_WL[148] B_WL[149] B_WL[150] B_WL[151] B_WL[152] B_WL[153] B_WL[154]
+ B_WL[155] B_WL[156] B_WL[157] B_WL[158] B_WL[159] B_WL[160] B_WL[161]
+ B_WL[162] B_WL[163] B_WL[164] B_WL[165] B_WL[166] B_WL[167] B_WL[168]
+ B_WL[169] B_WL[170] B_WL[171] B_WL[172] B_WL[173] B_WL[174] B_WL[175]
+ B_WL[176] B_WL[177] B_WL[178] B_WL[179] B_WL[180] B_WL[181] B_WL[182]
+ B_WL[183] B_WL[184] B_WL[185] B_WL[186] B_WL[187] B_WL[188] B_WL[189]
+ B_WL[190] B_WL[191] B_WL[192] B_WL[193] B_WL[194] B_WL[195] B_WL[196]
+ B_WL[197] B_WL[198] B_WL[199] B_WL[200] B_WL[201] B_WL[202] B_WL[203]
+ B_WL[204] B_WL[205] B_WL[206] B_WL[207] B_WL[208] B_WL[209] B_WL[210]
+ B_WL[211] B_WL[212] B_WL[213] B_WL[214] B_WL[215] B_WL[216] B_WL[217]
+ B_WL[218] B_WL[219] B_WL[220] B_WL[221] B_WL[222] B_WL[223] B_WL[224]
+ B_WL[225] B_WL[226] B_WL[227] B_WL[228] B_WL[229] B_WL[230] B_WL[231]
+ B_WL[232] B_WL[233] B_WL[234] B_WL[235] B_WL[236] B_WL[237] B_WL[238]
+ B_WL[239] B_WL[240] B_WL[241] B_WL[242] B_WL[243] B_WL[244] B_WL[245]
+ B_WL[246] B_WL[247] B_WL[248] B_WL[249] B_WL[250] B_WL[251] B_WL[252]
+ B_WL[253] B_WL[254] B_WL[255] A_RDL[0] A_SMPRS_0[3] A_SMPRS_0[2] A_SMPRS_0[1]
+ A_SMPRS_0[0] A_SOE[0] A_WRTL[0] A_YSEL_0[7] A_YSEL_0[6] A_YSEL_0[5]
+ A_YSEL_0[4] A_YSEL_0[3] A_YSEL_0[2] A_YSEL_0[1] A_YSEL_0[0] B_RDL[0]
+ B_SMPRS_0[3] B_SMPRS_0[2] B_SMPRS_0[1] B_SMPRS_0[0] B_SOE[0] B_WRTL[0]
+ B_YSEL_0[7] B_YSEL_0[6] B_YSEL_0[5] B_YSEL_0[4] B_YSEL_0[3] B_YSEL_0[2]
+ B_YSEL_0[1] B_YSEL_0[0] AWTI BWEBA BWEBMA A_CKD DA A_DLRS DMA A_WENB[3]
+ A_WENB[2] A_WENB[1] A_WENB[0] BISTC BISTT BWEBB BWEBMB B_CKD DB B_DLRS DMB
+ B_WENB[3] B_WENB[2] B_WENB[1] B_WENB[0] QA QB
XBIT41 AWTI BWEBA BWEBMA A_CKD DA A_DLRS DMA A_WENB[3] A_WENB[2] A_WENB[1]
+ A_WENB[0] BISTC BISTT BWEBB BWEBMB B_CKD DB B_DLRS DMB B_WENB[3] B_WENB[2]
+ B_WENB[1] B_WENB[0] A_GWDC[0] A_GWDT[0] QA B_GWDC[0] B_GWDT[0] QB A_GRDC[0]
+ A_GRDT[0] B_GRDC[0] B_GRDT[0] SDL400W20S_BIT41
XCLC4A00 A_GWDC[0] A_GWDT[0] B_GWDC[0] B_GWDT[0] A_RDL[0] A_SMPRS_0[3]
+ A_SMPRS_0[2] A_SMPRS_0[1] A_SMPRS_0[0] A_SMPRS_0[0] A_SOE[0] A_WRTL[0]
+ A_YSEL_0[7] A_YSEL_0[6] A_YSEL_0[5] A_YSEL_0[4] A_YSEL_0[3] A_YSEL_0[2]
+ A_YSEL_0[1] A_YSEL_0[0] A_GRDC[0] A_GRDT[0] A_BL_0[3] A_BL_0[2] A_BL_0[1]
+ A_BL_0[0] A_BLB_0[3] A_BLB_0[2] A_BLB_0[1] A_BLB_0[0] B_GRDC[0] B_GRDT[0]
+  SDL400W20S_CLC4A
XCLC4B00 A_GWDC[0] A_GWDT[0] B_GWDC[0] B_GWDT[0] B_RDL[0] B_SMPRS_0[3]
+ B_SMPRS_0[2] B_SMPRS_0[1] B_SMPRS_0[0] B_SMPRS_0[0] B_SOE[0] B_WRTL[0]
+ B_YSEL_0[7] B_YSEL_0[6] B_YSEL_0[5] B_YSEL_0[4] B_YSEL_0[3] B_YSEL_0[2]
+ B_YSEL_0[1] B_YSEL_0[0] A_GRDC[0] A_GRDT[0] B_BL_0[3] B_BL_0[2] B_BL_0[1]
+ B_BL_0[0] B_BLB_0[3] B_BLB_0[2] B_BLB_0[1] B_BLB_0[0] B_GRDC[0] B_GRDT[0]
+  SDL400W20S_CLC4B
XMCROW000 A_WL[0] A_WL[1] A_WL[2] A_WL[3] B_WL[0] B_WL[1] B_WL[2] B_WL[3]
+ A_BL_0[0] A_BL_0[1] A_BL_0[2] A_BL_0[3] A_BLB_0[0] A_BLB_0[1] A_BLB_0[2]
+ A_BLB_0[3] A_GWDC[0] A_GWDT[0] A_GRDC[0] A_GRDT[0] B_BL_0[0] B_BL_0[1]
+ B_BL_0[2] B_BL_0[3] B_BLB_0[0] B_BLB_0[1] B_BLB_0[2] B_BLB_0[3] B_GWDC[0]
+ B_GWDT[0] B_GRDC[0] B_GRDT[0] SDL400W20S_NMCROW
XMCROW004 A_WL[4] A_WL[5] A_WL[6] A_WL[7] B_WL[4] B_WL[5] B_WL[6] B_WL[7]
+ A_BL_0[0] A_BL_0[1] A_BL_0[2] A_BL_0[3] A_BLB_0[0] A_BLB_0[1] A_BLB_0[2]
+ A_BLB_0[3] A_GWDC[0] A_GWDT[0] A_GRDC[0] A_GRDT[0] B_BL_0[0] B_BL_0[1]
+ B_BL_0[2] B_BL_0[3] B_BLB_0[0] B_BLB_0[1] B_BLB_0[2] B_BLB_0[3] B_GWDC[0]
+ B_GWDT[0] B_GRDC[0] B_GRDT[0] SDL400W20S_NMCROW
XMCROW008 A_WL[8] A_WL[9] A_WL[10] A_WL[11] B_WL[8] B_WL[9] B_WL[10] B_WL[11]
+ A_BL_0[0] A_BL_0[1] A_BL_0[2] A_BL_0[3] A_BLB_0[0] A_BLB_0[1] A_BLB_0[2]
+ A_BLB_0[3] A_GWDC[0] A_GWDT[0] A_GRDC[0] A_GRDT[0] B_BL_0[0] B_BL_0[1]
+ B_BL_0[2] B_BL_0[3] B_BLB_0[0] B_BLB_0[1] B_BLB_0[2] B_BLB_0[3] B_GWDC[0]
+ B_GWDT[0] B_GRDC[0] B_GRDT[0] SDL400W20S_NMCROW
XMCROW0012 A_WL[12] A_WL[13] A_WL[14] A_WL[15] B_WL[12] B_WL[13] B_WL[14]
+ B_WL[15] A_BL_0[0] A_BL_0[1] A_BL_0[2] A_BL_0[3] A_BLB_0[0] A_BLB_0[1]
+ A_BLB_0[2] A_BLB_0[3] A_GWDC[0] A_GWDT[0] A_GRDC[0] A_GRDT[0] B_BL_0[0]
+ B_BL_0[1] B_BL_0[2] B_BL_0[3] B_BLB_0[0] B_BLB_0[1] B_BLB_0[2] B_BLB_0[3]
+ B_GWDC[0] B_GWDT[0] B_GRDC[0] B_GRDT[0] SDL400W20S_NMCROW
XMCROW0016 A_WL[16] A_WL[17] A_WL[18] A_WL[19] B_WL[16] B_WL[17] B_WL[18]
+ B_WL[19] A_BL_0[0] A_BL_0[1] A_BL_0[2] A_BL_0[3] A_BLB_0[0] A_BLB_0[1]
+ A_BLB_0[2] A_BLB_0[3] A_GWDC[0] A_GWDT[0] A_GRDC[0] A_GRDT[0] B_BL_0[0]
+ B_BL_0[1] B_BL_0[2] B_BL_0[3] B_BLB_0[0] B_BLB_0[1] B_BLB_0[2] B_BLB_0[3]
+ B_GWDC[0] B_GWDT[0] B_GRDC[0] B_GRDT[0] SDL400W20S_NMCROW
XMCROW0020 A_WL[20] A_WL[21] A_WL[22] A_WL[23] B_WL[20] B_WL[21] B_WL[22]
+ B_WL[23] A_BL_0[0] A_BL_0[1] A_BL_0[2] A_BL_0[3] A_BLB_0[0] A_BLB_0[1]
+ A_BLB_0[2] A_BLB_0[3] A_GWDC[0] A_GWDT[0] A_GRDC[0] A_GRDT[0] B_BL_0[0]
+ B_BL_0[1] B_BL_0[2] B_BL_0[3] B_BLB_0[0] B_BLB_0[1] B_BLB_0[2] B_BLB_0[3]
+ B_GWDC[0] B_GWDT[0] B_GRDC[0] B_GRDT[0] SDL400W20S_NMCROW
XMCROW0024 A_WL[24] A_WL[25] A_WL[26] A_WL[27] B_WL[24] B_WL[25] B_WL[26]
+ B_WL[27] A_BL_0[0] A_BL_0[1] A_BL_0[2] A_BL_0[3] A_BLB_0[0] A_BLB_0[1]
+ A_BLB_0[2] A_BLB_0[3] A_GWDC[0] A_GWDT[0] A_GRDC[0] A_GRDT[0] B_BL_0[0]
+ B_BL_0[1] B_BL_0[2] B_BL_0[3] B_BLB_0[0] B_BLB_0[1] B_BLB_0[2] B_BLB_0[3]
+ B_GWDC[0] B_GWDT[0] B_GRDC[0] B_GRDT[0] SDL400W20S_NMCROW
XMCROW0028 A_WL[28] A_WL[29] A_WL[30] A_WL[31] B_WL[28] B_WL[29] B_WL[30]
+ B_WL[31] A_BL_0[0] A_BL_0[1] A_BL_0[2] A_BL_0[3] A_BLB_0[0] A_BLB_0[1]
+ A_BLB_0[2] A_BLB_0[3] A_GWDC[0] A_GWDT[0] A_GRDC[0] A_GRDT[0] B_BL_0[0]
+ B_BL_0[1] B_BL_0[2] B_BL_0[3] B_BLB_0[0] B_BLB_0[1] B_BLB_0[2] B_BLB_0[3]
+ B_GWDC[0] B_GWDT[0] B_GRDC[0] B_GRDT[0] SDL400W20S_NMCROW
XMCROW0032 A_WL[32] A_WL[33] A_WL[34] A_WL[35] B_WL[32] B_WL[33] B_WL[34]
+ B_WL[35] A_BL_0[0] A_BL_0[1] A_BL_0[2] A_BL_0[3] A_BLB_0[0] A_BLB_0[1]
+ A_BLB_0[2] A_BLB_0[3] A_GWDC[0] A_GWDT[0] A_GRDC[0] A_GRDT[0] B_BL_0[0]
+ B_BL_0[1] B_BL_0[2] B_BL_0[3] B_BLB_0[0] B_BLB_0[1] B_BLB_0[2] B_BLB_0[3]
+ B_GWDC[0] B_GWDT[0] B_GRDC[0] B_GRDT[0] SDL400W20S_NMCROW
XMCROW0036 A_WL[36] A_WL[37] A_WL[38] A_WL[39] B_WL[36] B_WL[37] B_WL[38]
+ B_WL[39] A_BL_0[0] A_BL_0[1] A_BL_0[2] A_BL_0[3] A_BLB_0[0] A_BLB_0[1]
+ A_BLB_0[2] A_BLB_0[3] A_GWDC[0] A_GWDT[0] A_GRDC[0] A_GRDT[0] B_BL_0[0]
+ B_BL_0[1] B_BL_0[2] B_BL_0[3] B_BLB_0[0] B_BLB_0[1] B_BLB_0[2] B_BLB_0[3]
+ B_GWDC[0] B_GWDT[0] B_GRDC[0] B_GRDT[0] SDL400W20S_NMCROW
XMCROW0040 A_WL[40] A_WL[41] A_WL[42] A_WL[43] B_WL[40] B_WL[41] B_WL[42]
+ B_WL[43] A_BL_0[0] A_BL_0[1] A_BL_0[2] A_BL_0[3] A_BLB_0[0] A_BLB_0[1]
+ A_BLB_0[2] A_BLB_0[3] A_GWDC[0] A_GWDT[0] A_GRDC[0] A_GRDT[0] B_BL_0[0]
+ B_BL_0[1] B_BL_0[2] B_BL_0[3] B_BLB_0[0] B_BLB_0[1] B_BLB_0[2] B_BLB_0[3]
+ B_GWDC[0] B_GWDT[0] B_GRDC[0] B_GRDT[0] SDL400W20S_NMCROW
XMCROW0044 A_WL[44] A_WL[45] A_WL[46] A_WL[47] B_WL[44] B_WL[45] B_WL[46]
+ B_WL[47] A_BL_0[0] A_BL_0[1] A_BL_0[2] A_BL_0[3] A_BLB_0[0] A_BLB_0[1]
+ A_BLB_0[2] A_BLB_0[3] A_GWDC[0] A_GWDT[0] A_GRDC[0] A_GRDT[0] B_BL_0[0]
+ B_BL_0[1] B_BL_0[2] B_BL_0[3] B_BLB_0[0] B_BLB_0[1] B_BLB_0[2] B_BLB_0[3]
+ B_GWDC[0] B_GWDT[0] B_GRDC[0] B_GRDT[0] SDL400W20S_NMCROW
XMCROW0048 A_WL[48] A_WL[49] A_WL[50] A_WL[51] B_WL[48] B_WL[49] B_WL[50]
+ B_WL[51] A_BL_0[0] A_BL_0[1] A_BL_0[2] A_BL_0[3] A_BLB_0[0] A_BLB_0[1]
+ A_BLB_0[2] A_BLB_0[3] A_GWDC[0] A_GWDT[0] A_GRDC[0] A_GRDT[0] B_BL_0[0]
+ B_BL_0[1] B_BL_0[2] B_BL_0[3] B_BLB_0[0] B_BLB_0[1] B_BLB_0[2] B_BLB_0[3]
+ B_GWDC[0] B_GWDT[0] B_GRDC[0] B_GRDT[0] SDL400W20S_NMCROW
XMCROW0052 A_WL[52] A_WL[53] A_WL[54] A_WL[55] B_WL[52] B_WL[53] B_WL[54]
+ B_WL[55] A_BL_0[0] A_BL_0[1] A_BL_0[2] A_BL_0[3] A_BLB_0[0] A_BLB_0[1]
+ A_BLB_0[2] A_BLB_0[3] A_GWDC[0] A_GWDT[0] A_GRDC[0] A_GRDT[0] B_BL_0[0]
+ B_BL_0[1] B_BL_0[2] B_BL_0[3] B_BLB_0[0] B_BLB_0[1] B_BLB_0[2] B_BLB_0[3]
+ B_GWDC[0] B_GWDT[0] B_GRDC[0] B_GRDT[0] SDL400W20S_NMCROW
XMCROW0056 A_WL[56] A_WL[57] A_WL[58] A_WL[59] B_WL[56] B_WL[57] B_WL[58]
+ B_WL[59] A_BL_0[0] A_BL_0[1] A_BL_0[2] A_BL_0[3] A_BLB_0[0] A_BLB_0[1]
+ A_BLB_0[2] A_BLB_0[3] A_GWDC[0] A_GWDT[0] A_GRDC[0] A_GRDT[0] B_BL_0[0]
+ B_BL_0[1] B_BL_0[2] B_BL_0[3] B_BLB_0[0] B_BLB_0[1] B_BLB_0[2] B_BLB_0[3]
+ B_GWDC[0] B_GWDT[0] B_GRDC[0] B_GRDT[0] SDL400W20S_NMCROW
XMCROW0060 A_WL[60] A_WL[61] A_WL[62] A_WL[63] B_WL[60] B_WL[61] B_WL[62]
+ B_WL[63] A_BL_0[0] A_BL_0[1] A_BL_0[2] A_BL_0[3] A_BLB_0[0] A_BLB_0[1]
+ A_BLB_0[2] A_BLB_0[3] A_GWDC[0] A_GWDT[0] A_GRDC[0] A_GRDT[0] B_BL_0[0]
+ B_BL_0[1] B_BL_0[2] B_BL_0[3] B_BLB_0[0] B_BLB_0[1] B_BLB_0[2] B_BLB_0[3]
+ B_GWDC[0] B_GWDT[0] B_GRDC[0] B_GRDT[0] SDL400W20S_NMCROW
XMCROW0064 A_WL[64] A_WL[65] A_WL[66] A_WL[67] B_WL[64] B_WL[65] B_WL[66]
+ B_WL[67] A_BL_0[0] A_BL_0[1] A_BL_0[2] A_BL_0[3] A_BLB_0[0] A_BLB_0[1]
+ A_BLB_0[2] A_BLB_0[3] A_GWDC[0] A_GWDT[0] A_GRDC[0] A_GRDT[0] B_BL_0[0]
+ B_BL_0[1] B_BL_0[2] B_BL_0[3] B_BLB_0[0] B_BLB_0[1] B_BLB_0[2] B_BLB_0[3]
+ B_GWDC[0] B_GWDT[0] B_GRDC[0] B_GRDT[0] SDL400W20S_NMCROW
XMCROW0068 A_WL[68] A_WL[69] A_WL[70] A_WL[71] B_WL[68] B_WL[69] B_WL[70]
+ B_WL[71] A_BL_0[0] A_BL_0[1] A_BL_0[2] A_BL_0[3] A_BLB_0[0] A_BLB_0[1]
+ A_BLB_0[2] A_BLB_0[3] A_GWDC[0] A_GWDT[0] A_GRDC[0] A_GRDT[0] B_BL_0[0]
+ B_BL_0[1] B_BL_0[2] B_BL_0[3] B_BLB_0[0] B_BLB_0[1] B_BLB_0[2] B_BLB_0[3]
+ B_GWDC[0] B_GWDT[0] B_GRDC[0] B_GRDT[0] SDL400W20S_NMCROW
XMCROW0072 A_WL[72] A_WL[73] A_WL[74] A_WL[75] B_WL[72] B_WL[73] B_WL[74]
+ B_WL[75] A_BL_0[0] A_BL_0[1] A_BL_0[2] A_BL_0[3] A_BLB_0[0] A_BLB_0[1]
+ A_BLB_0[2] A_BLB_0[3] A_GWDC[0] A_GWDT[0] A_GRDC[0] A_GRDT[0] B_BL_0[0]
+ B_BL_0[1] B_BL_0[2] B_BL_0[3] B_BLB_0[0] B_BLB_0[1] B_BLB_0[2] B_BLB_0[3]
+ B_GWDC[0] B_GWDT[0] B_GRDC[0] B_GRDT[0] SDL400W20S_NMCROW
XMCROW0076 A_WL[76] A_WL[77] A_WL[78] A_WL[79] B_WL[76] B_WL[77] B_WL[78]
+ B_WL[79] A_BL_0[0] A_BL_0[1] A_BL_0[2] A_BL_0[3] A_BLB_0[0] A_BLB_0[1]
+ A_BLB_0[2] A_BLB_0[3] A_GWDC[0] A_GWDT[0] A_GRDC[0] A_GRDT[0] B_BL_0[0]
+ B_BL_0[1] B_BL_0[2] B_BL_0[3] B_BLB_0[0] B_BLB_0[1] B_BLB_0[2] B_BLB_0[3]
+ B_GWDC[0] B_GWDT[0] B_GRDC[0] B_GRDT[0] SDL400W20S_NMCROW
XMCROW0080 A_WL[80] A_WL[81] A_WL[82] A_WL[83] B_WL[80] B_WL[81] B_WL[82]
+ B_WL[83] A_BL_0[0] A_BL_0[1] A_BL_0[2] A_BL_0[3] A_BLB_0[0] A_BLB_0[1]
+ A_BLB_0[2] A_BLB_0[3] A_GWDC[0] A_GWDT[0] A_GRDC[0] A_GRDT[0] B_BL_0[0]
+ B_BL_0[1] B_BL_0[2] B_BL_0[3] B_BLB_0[0] B_BLB_0[1] B_BLB_0[2] B_BLB_0[3]
+ B_GWDC[0] B_GWDT[0] B_GRDC[0] B_GRDT[0] SDL400W20S_NMCROW
XMCROW0084 A_WL[84] A_WL[85] A_WL[86] A_WL[87] B_WL[84] B_WL[85] B_WL[86]
+ B_WL[87] A_BL_0[0] A_BL_0[1] A_BL_0[2] A_BL_0[3] A_BLB_0[0] A_BLB_0[1]
+ A_BLB_0[2] A_BLB_0[3] A_GWDC[0] A_GWDT[0] A_GRDC[0] A_GRDT[0] B_BL_0[0]
+ B_BL_0[1] B_BL_0[2] B_BL_0[3] B_BLB_0[0] B_BLB_0[1] B_BLB_0[2] B_BLB_0[3]
+ B_GWDC[0] B_GWDT[0] B_GRDC[0] B_GRDT[0] SDL400W20S_NMCROW
XMCROW0088 A_WL[88] A_WL[89] A_WL[90] A_WL[91] B_WL[88] B_WL[89] B_WL[90]
+ B_WL[91] A_BL_0[0] A_BL_0[1] A_BL_0[2] A_BL_0[3] A_BLB_0[0] A_BLB_0[1]
+ A_BLB_0[2] A_BLB_0[3] A_GWDC[0] A_GWDT[0] A_GRDC[0] A_GRDT[0] B_BL_0[0]
+ B_BL_0[1] B_BL_0[2] B_BL_0[3] B_BLB_0[0] B_BLB_0[1] B_BLB_0[2] B_BLB_0[3]
+ B_GWDC[0] B_GWDT[0] B_GRDC[0] B_GRDT[0] SDL400W20S_NMCROW
XMCROW0092 A_WL[92] A_WL[93] A_WL[94] A_WL[95] B_WL[92] B_WL[93] B_WL[94]
+ B_WL[95] A_BL_0[0] A_BL_0[1] A_BL_0[2] A_BL_0[3] A_BLB_0[0] A_BLB_0[1]
+ A_BLB_0[2] A_BLB_0[3] A_GWDC[0] A_GWDT[0] A_GRDC[0] A_GRDT[0] B_BL_0[0]
+ B_BL_0[1] B_BL_0[2] B_BL_0[3] B_BLB_0[0] B_BLB_0[1] B_BLB_0[2] B_BLB_0[3]
+ B_GWDC[0] B_GWDT[0] B_GRDC[0] B_GRDT[0] SDL400W20S_NMCROW
XMCROW0096 A_WL[96] A_WL[97] A_WL[98] A_WL[99] B_WL[96] B_WL[97] B_WL[98]
+ B_WL[99] A_BL_0[0] A_BL_0[1] A_BL_0[2] A_BL_0[3] A_BLB_0[0] A_BLB_0[1]
+ A_BLB_0[2] A_BLB_0[3] A_GWDC[0] A_GWDT[0] A_GRDC[0] A_GRDT[0] B_BL_0[0]
+ B_BL_0[1] B_BL_0[2] B_BL_0[3] B_BLB_0[0] B_BLB_0[1] B_BLB_0[2] B_BLB_0[3]
+ B_GWDC[0] B_GWDT[0] B_GRDC[0] B_GRDT[0] SDL400W20S_NMCROW
XMCROW00100 A_WL[100] A_WL[101] A_WL[102] A_WL[103] B_WL[100] B_WL[101]
+ B_WL[102] B_WL[103] A_BL_0[0] A_BL_0[1] A_BL_0[2] A_BL_0[3] A_BLB_0[0]
+ A_BLB_0[1] A_BLB_0[2] A_BLB_0[3] A_GWDC[0] A_GWDT[0] A_GRDC[0] A_GRDT[0]
+ B_BL_0[0] B_BL_0[1] B_BL_0[2] B_BL_0[3] B_BLB_0[0] B_BLB_0[1] B_BLB_0[2]
+ B_BLB_0[3] B_GWDC[0] B_GWDT[0] B_GRDC[0] B_GRDT[0] SDL400W20S_NMCROW
XMCROW00104 A_WL[104] A_WL[105] A_WL[106] A_WL[107] B_WL[104] B_WL[105]
+ B_WL[106] B_WL[107] A_BL_0[0] A_BL_0[1] A_BL_0[2] A_BL_0[3] A_BLB_0[0]
+ A_BLB_0[1] A_BLB_0[2] A_BLB_0[3] A_GWDC[0] A_GWDT[0] A_GRDC[0] A_GRDT[0]
+ B_BL_0[0] B_BL_0[1] B_BL_0[2] B_BL_0[3] B_BLB_0[0] B_BLB_0[1] B_BLB_0[2]
+ B_BLB_0[3] B_GWDC[0] B_GWDT[0] B_GRDC[0] B_GRDT[0] SDL400W20S_NMCROW
XMCROW00108 A_WL[108] A_WL[109] A_WL[110] A_WL[111] B_WL[108] B_WL[109]
+ B_WL[110] B_WL[111] A_BL_0[0] A_BL_0[1] A_BL_0[2] A_BL_0[3] A_BLB_0[0]
+ A_BLB_0[1] A_BLB_0[2] A_BLB_0[3] A_GWDC[0] A_GWDT[0] A_GRDC[0] A_GRDT[0]
+ B_BL_0[0] B_BL_0[1] B_BL_0[2] B_BL_0[3] B_BLB_0[0] B_BLB_0[1] B_BLB_0[2]
+ B_BLB_0[3] B_GWDC[0] B_GWDT[0] B_GRDC[0] B_GRDT[0] SDL400W20S_NMCROW
XMCROW00112 A_WL[112] A_WL[113] A_WL[114] A_WL[115] B_WL[112] B_WL[113]
+ B_WL[114] B_WL[115] A_BL_0[0] A_BL_0[1] A_BL_0[2] A_BL_0[3] A_BLB_0[0]
+ A_BLB_0[1] A_BLB_0[2] A_BLB_0[3] A_GWDC[0] A_GWDT[0] A_GRDC[0] A_GRDT[0]
+ B_BL_0[0] B_BL_0[1] B_BL_0[2] B_BL_0[3] B_BLB_0[0] B_BLB_0[1] B_BLB_0[2]
+ B_BLB_0[3] B_GWDC[0] B_GWDT[0] B_GRDC[0] B_GRDT[0] SDL400W20S_NMCROW
XMCROW00116 A_WL[116] A_WL[117] A_WL[118] A_WL[119] B_WL[116] B_WL[117]
+ B_WL[118] B_WL[119] A_BL_0[0] A_BL_0[1] A_BL_0[2] A_BL_0[3] A_BLB_0[0]
+ A_BLB_0[1] A_BLB_0[2] A_BLB_0[3] A_GWDC[0] A_GWDT[0] A_GRDC[0] A_GRDT[0]
+ B_BL_0[0] B_BL_0[1] B_BL_0[2] B_BL_0[3] B_BLB_0[0] B_BLB_0[1] B_BLB_0[2]
+ B_BLB_0[3] B_GWDC[0] B_GWDT[0] B_GRDC[0] B_GRDT[0] SDL400W20S_NMCROW
XMCROW00120 A_WL[120] A_WL[121] A_WL[122] A_WL[123] B_WL[120] B_WL[121]
+ B_WL[122] B_WL[123] A_BL_0[0] A_BL_0[1] A_BL_0[2] A_BL_0[3] A_BLB_0[0]
+ A_BLB_0[1] A_BLB_0[2] A_BLB_0[3] A_GWDC[0] A_GWDT[0] A_GRDC[0] A_GRDT[0]
+ B_BL_0[0] B_BL_0[1] B_BL_0[2] B_BL_0[3] B_BLB_0[0] B_BLB_0[1] B_BLB_0[2]
+ B_BLB_0[3] B_GWDC[0] B_GWDT[0] B_GRDC[0] B_GRDT[0] SDL400W20S_NMCROW
XMCROW00124 A_WL[124] A_WL[125] A_WL[126] A_WL[127] B_WL[124] B_WL[125]
+ B_WL[126] B_WL[127] A_BL_0[0] A_BL_0[1] A_BL_0[2] A_BL_0[3] A_BLB_0[0]
+ A_BLB_0[1] A_BLB_0[2] A_BLB_0[3] A_GWDC[0] A_GWDT[0] A_GRDC[0] A_GRDT[0]
+ B_BL_0[0] B_BL_0[1] B_BL_0[2] B_BL_0[3] B_BLB_0[0] B_BLB_0[1] B_BLB_0[2]
+ B_BLB_0[3] B_GWDC[0] B_GWDT[0] B_GRDC[0] B_GRDT[0] SDL400W20S_NMCROW
XMCROW00128 A_WL[128] A_WL[129] A_WL[130] A_WL[131] B_WL[128] B_WL[129]
+ B_WL[130] B_WL[131] A_BL_0[0] A_BL_0[1] A_BL_0[2] A_BL_0[3] A_BLB_0[0]
+ A_BLB_0[1] A_BLB_0[2] A_BLB_0[3] A_GWDC[0] A_GWDT[0] A_GRDC[0] A_GRDT[0]
+ B_BL_0[0] B_BL_0[1] B_BL_0[2] B_BL_0[3] B_BLB_0[0] B_BLB_0[1] B_BLB_0[2]
+ B_BLB_0[3] B_GWDC[0] B_GWDT[0] B_GRDC[0] B_GRDT[0] SDL400W20S_NMCROW
XMCROW00132 A_WL[132] A_WL[133] A_WL[134] A_WL[135] B_WL[132] B_WL[133]
+ B_WL[134] B_WL[135] A_BL_0[0] A_BL_0[1] A_BL_0[2] A_BL_0[3] A_BLB_0[0]
+ A_BLB_0[1] A_BLB_0[2] A_BLB_0[3] A_GWDC[0] A_GWDT[0] A_GRDC[0] A_GRDT[0]
+ B_BL_0[0] B_BL_0[1] B_BL_0[2] B_BL_0[3] B_BLB_0[0] B_BLB_0[1] B_BLB_0[2]
+ B_BLB_0[3] B_GWDC[0] B_GWDT[0] B_GRDC[0] B_GRDT[0] SDL400W20S_NMCROW
XMCROW00136 A_WL[136] A_WL[137] A_WL[138] A_WL[139] B_WL[136] B_WL[137]
+ B_WL[138] B_WL[139] A_BL_0[0] A_BL_0[1] A_BL_0[2] A_BL_0[3] A_BLB_0[0]
+ A_BLB_0[1] A_BLB_0[2] A_BLB_0[3] A_GWDC[0] A_GWDT[0] A_GRDC[0] A_GRDT[0]
+ B_BL_0[0] B_BL_0[1] B_BL_0[2] B_BL_0[3] B_BLB_0[0] B_BLB_0[1] B_BLB_0[2]
+ B_BLB_0[3] B_GWDC[0] B_GWDT[0] B_GRDC[0] B_GRDT[0] SDL400W20S_NMCROW
XMCROW00140 A_WL[140] A_WL[141] A_WL[142] A_WL[143] B_WL[140] B_WL[141]
+ B_WL[142] B_WL[143] A_BL_0[0] A_BL_0[1] A_BL_0[2] A_BL_0[3] A_BLB_0[0]
+ A_BLB_0[1] A_BLB_0[2] A_BLB_0[3] A_GWDC[0] A_GWDT[0] A_GRDC[0] A_GRDT[0]
+ B_BL_0[0] B_BL_0[1] B_BL_0[2] B_BL_0[3] B_BLB_0[0] B_BLB_0[1] B_BLB_0[2]
+ B_BLB_0[3] B_GWDC[0] B_GWDT[0] B_GRDC[0] B_GRDT[0] SDL400W20S_NMCROW
XMCROW00144 A_WL[144] A_WL[145] A_WL[146] A_WL[147] B_WL[144] B_WL[145]
+ B_WL[146] B_WL[147] A_BL_0[0] A_BL_0[1] A_BL_0[2] A_BL_0[3] A_BLB_0[0]
+ A_BLB_0[1] A_BLB_0[2] A_BLB_0[3] A_GWDC[0] A_GWDT[0] A_GRDC[0] A_GRDT[0]
+ B_BL_0[0] B_BL_0[1] B_BL_0[2] B_BL_0[3] B_BLB_0[0] B_BLB_0[1] B_BLB_0[2]
+ B_BLB_0[3] B_GWDC[0] B_GWDT[0] B_GRDC[0] B_GRDT[0] SDL400W20S_NMCROW
XMCROW00148 A_WL[148] A_WL[149] A_WL[150] A_WL[151] B_WL[148] B_WL[149]
+ B_WL[150] B_WL[151] A_BL_0[0] A_BL_0[1] A_BL_0[2] A_BL_0[3] A_BLB_0[0]
+ A_BLB_0[1] A_BLB_0[2] A_BLB_0[3] A_GWDC[0] A_GWDT[0] A_GRDC[0] A_GRDT[0]
+ B_BL_0[0] B_BL_0[1] B_BL_0[2] B_BL_0[3] B_BLB_0[0] B_BLB_0[1] B_BLB_0[2]
+ B_BLB_0[3] B_GWDC[0] B_GWDT[0] B_GRDC[0] B_GRDT[0] SDL400W20S_NMCROW
XMCROW00152 A_WL[152] A_WL[153] A_WL[154] A_WL[155] B_WL[152] B_WL[153]
+ B_WL[154] B_WL[155] A_BL_0[0] A_BL_0[1] A_BL_0[2] A_BL_0[3] A_BLB_0[0]
+ A_BLB_0[1] A_BLB_0[2] A_BLB_0[3] A_GWDC[0] A_GWDT[0] A_GRDC[0] A_GRDT[0]
+ B_BL_0[0] B_BL_0[1] B_BL_0[2] B_BL_0[3] B_BLB_0[0] B_BLB_0[1] B_BLB_0[2]
+ B_BLB_0[3] B_GWDC[0] B_GWDT[0] B_GRDC[0] B_GRDT[0] SDL400W20S_NMCROW
XMCROW00156 A_WL[156] A_WL[157] A_WL[158] A_WL[159] B_WL[156] B_WL[157]
+ B_WL[158] B_WL[159] A_BL_0[0] A_BL_0[1] A_BL_0[2] A_BL_0[3] A_BLB_0[0]
+ A_BLB_0[1] A_BLB_0[2] A_BLB_0[3] A_GWDC[0] A_GWDT[0] A_GRDC[0] A_GRDT[0]
+ B_BL_0[0] B_BL_0[1] B_BL_0[2] B_BL_0[3] B_BLB_0[0] B_BLB_0[1] B_BLB_0[2]
+ B_BLB_0[3] B_GWDC[0] B_GWDT[0] B_GRDC[0] B_GRDT[0] SDL400W20S_NMCROW
XMCROW00160 A_WL[160] A_WL[161] A_WL[162] A_WL[163] B_WL[160] B_WL[161]
+ B_WL[162] B_WL[163] A_BL_0[0] A_BL_0[1] A_BL_0[2] A_BL_0[3] A_BLB_0[0]
+ A_BLB_0[1] A_BLB_0[2] A_BLB_0[3] A_GWDC[0] A_GWDT[0] A_GRDC[0] A_GRDT[0]
+ B_BL_0[0] B_BL_0[1] B_BL_0[2] B_BL_0[3] B_BLB_0[0] B_BLB_0[1] B_BLB_0[2]
+ B_BLB_0[3] B_GWDC[0] B_GWDT[0] B_GRDC[0] B_GRDT[0] SDL400W20S_NMCROW
XMCROW00164 A_WL[164] A_WL[165] A_WL[166] A_WL[167] B_WL[164] B_WL[165]
+ B_WL[166] B_WL[167] A_BL_0[0] A_BL_0[1] A_BL_0[2] A_BL_0[3] A_BLB_0[0]
+ A_BLB_0[1] A_BLB_0[2] A_BLB_0[3] A_GWDC[0] A_GWDT[0] A_GRDC[0] A_GRDT[0]
+ B_BL_0[0] B_BL_0[1] B_BL_0[2] B_BL_0[3] B_BLB_0[0] B_BLB_0[1] B_BLB_0[2]
+ B_BLB_0[3] B_GWDC[0] B_GWDT[0] B_GRDC[0] B_GRDT[0] SDL400W20S_NMCROW
XMCROW00168 A_WL[168] A_WL[169] A_WL[170] A_WL[171] B_WL[168] B_WL[169]
+ B_WL[170] B_WL[171] A_BL_0[0] A_BL_0[1] A_BL_0[2] A_BL_0[3] A_BLB_0[0]
+ A_BLB_0[1] A_BLB_0[2] A_BLB_0[3] A_GWDC[0] A_GWDT[0] A_GRDC[0] A_GRDT[0]
+ B_BL_0[0] B_BL_0[1] B_BL_0[2] B_BL_0[3] B_BLB_0[0] B_BLB_0[1] B_BLB_0[2]
+ B_BLB_0[3] B_GWDC[0] B_GWDT[0] B_GRDC[0] B_GRDT[0] SDL400W20S_NMCROW
XMCROW00172 A_WL[172] A_WL[173] A_WL[174] A_WL[175] B_WL[172] B_WL[173]
+ B_WL[174] B_WL[175] A_BL_0[0] A_BL_0[1] A_BL_0[2] A_BL_0[3] A_BLB_0[0]
+ A_BLB_0[1] A_BLB_0[2] A_BLB_0[3] A_GWDC[0] A_GWDT[0] A_GRDC[0] A_GRDT[0]
+ B_BL_0[0] B_BL_0[1] B_BL_0[2] B_BL_0[3] B_BLB_0[0] B_BLB_0[1] B_BLB_0[2]
+ B_BLB_0[3] B_GWDC[0] B_GWDT[0] B_GRDC[0] B_GRDT[0] SDL400W20S_NMCROW
XMCROW00176 A_WL[176] A_WL[177] A_WL[178] A_WL[179] B_WL[176] B_WL[177]
+ B_WL[178] B_WL[179] A_BL_0[0] A_BL_0[1] A_BL_0[2] A_BL_0[3] A_BLB_0[0]
+ A_BLB_0[1] A_BLB_0[2] A_BLB_0[3] A_GWDC[0] A_GWDT[0] A_GRDC[0] A_GRDT[0]
+ B_BL_0[0] B_BL_0[1] B_BL_0[2] B_BL_0[3] B_BLB_0[0] B_BLB_0[1] B_BLB_0[2]
+ B_BLB_0[3] B_GWDC[0] B_GWDT[0] B_GRDC[0] B_GRDT[0] SDL400W20S_NMCROW
XMCROW00180 A_WL[180] A_WL[181] A_WL[182] A_WL[183] B_WL[180] B_WL[181]
+ B_WL[182] B_WL[183] A_BL_0[0] A_BL_0[1] A_BL_0[2] A_BL_0[3] A_BLB_0[0]
+ A_BLB_0[1] A_BLB_0[2] A_BLB_0[3] A_GWDC[0] A_GWDT[0] A_GRDC[0] A_GRDT[0]
+ B_BL_0[0] B_BL_0[1] B_BL_0[2] B_BL_0[3] B_BLB_0[0] B_BLB_0[1] B_BLB_0[2]
+ B_BLB_0[3] B_GWDC[0] B_GWDT[0] B_GRDC[0] B_GRDT[0] SDL400W20S_NMCROW
XMCROW00184 A_WL[184] A_WL[185] A_WL[186] A_WL[187] B_WL[184] B_WL[185]
+ B_WL[186] B_WL[187] A_BL_0[0] A_BL_0[1] A_BL_0[2] A_BL_0[3] A_BLB_0[0]
+ A_BLB_0[1] A_BLB_0[2] A_BLB_0[3] A_GWDC[0] A_GWDT[0] A_GRDC[0] A_GRDT[0]
+ B_BL_0[0] B_BL_0[1] B_BL_0[2] B_BL_0[3] B_BLB_0[0] B_BLB_0[1] B_BLB_0[2]
+ B_BLB_0[3] B_GWDC[0] B_GWDT[0] B_GRDC[0] B_GRDT[0] SDL400W20S_NMCROW
XMCROW00188 A_WL[188] A_WL[189] A_WL[190] A_WL[191] B_WL[188] B_WL[189]
+ B_WL[190] B_WL[191] A_BL_0[0] A_BL_0[1] A_BL_0[2] A_BL_0[3] A_BLB_0[0]
+ A_BLB_0[1] A_BLB_0[2] A_BLB_0[3] A_GWDC[0] A_GWDT[0] A_GRDC[0] A_GRDT[0]
+ B_BL_0[0] B_BL_0[1] B_BL_0[2] B_BL_0[3] B_BLB_0[0] B_BLB_0[1] B_BLB_0[2]
+ B_BLB_0[3] B_GWDC[0] B_GWDT[0] B_GRDC[0] B_GRDT[0] SDL400W20S_NMCROW
XMCROW00192 A_WL[192] A_WL[193] A_WL[194] A_WL[195] B_WL[192] B_WL[193]
+ B_WL[194] B_WL[195] A_BL_0[0] A_BL_0[1] A_BL_0[2] A_BL_0[3] A_BLB_0[0]
+ A_BLB_0[1] A_BLB_0[2] A_BLB_0[3] A_GWDC[0] A_GWDT[0] A_GRDC[0] A_GRDT[0]
+ B_BL_0[0] B_BL_0[1] B_BL_0[2] B_BL_0[3] B_BLB_0[0] B_BLB_0[1] B_BLB_0[2]
+ B_BLB_0[3] B_GWDC[0] B_GWDT[0] B_GRDC[0] B_GRDT[0] SDL400W20S_NMCROW
XMCROW00196 A_WL[196] A_WL[197] A_WL[198] A_WL[199] B_WL[196] B_WL[197]
+ B_WL[198] B_WL[199] A_BL_0[0] A_BL_0[1] A_BL_0[2] A_BL_0[3] A_BLB_0[0]
+ A_BLB_0[1] A_BLB_0[2] A_BLB_0[3] A_GWDC[0] A_GWDT[0] A_GRDC[0] A_GRDT[0]
+ B_BL_0[0] B_BL_0[1] B_BL_0[2] B_BL_0[3] B_BLB_0[0] B_BLB_0[1] B_BLB_0[2]
+ B_BLB_0[3] B_GWDC[0] B_GWDT[0] B_GRDC[0] B_GRDT[0] SDL400W20S_NMCROW
XMCROW00200 A_WL[200] A_WL[201] A_WL[202] A_WL[203] B_WL[200] B_WL[201]
+ B_WL[202] B_WL[203] A_BL_0[0] A_BL_0[1] A_BL_0[2] A_BL_0[3] A_BLB_0[0]
+ A_BLB_0[1] A_BLB_0[2] A_BLB_0[3] A_GWDC[0] A_GWDT[0] A_GRDC[0] A_GRDT[0]
+ B_BL_0[0] B_BL_0[1] B_BL_0[2] B_BL_0[3] B_BLB_0[0] B_BLB_0[1] B_BLB_0[2]
+ B_BLB_0[3] B_GWDC[0] B_GWDT[0] B_GRDC[0] B_GRDT[0] SDL400W20S_NMCROW
XMCROW00204 A_WL[204] A_WL[205] A_WL[206] A_WL[207] B_WL[204] B_WL[205]
+ B_WL[206] B_WL[207] A_BL_0[0] A_BL_0[1] A_BL_0[2] A_BL_0[3] A_BLB_0[0]
+ A_BLB_0[1] A_BLB_0[2] A_BLB_0[3] A_GWDC[0] A_GWDT[0] A_GRDC[0] A_GRDT[0]
+ B_BL_0[0] B_BL_0[1] B_BL_0[2] B_BL_0[3] B_BLB_0[0] B_BLB_0[1] B_BLB_0[2]
+ B_BLB_0[3] B_GWDC[0] B_GWDT[0] B_GRDC[0] B_GRDT[0] SDL400W20S_NMCROW
XMCROW00208 A_WL[208] A_WL[209] A_WL[210] A_WL[211] B_WL[208] B_WL[209]
+ B_WL[210] B_WL[211] A_BL_0[0] A_BL_0[1] A_BL_0[2] A_BL_0[3] A_BLB_0[0]
+ A_BLB_0[1] A_BLB_0[2] A_BLB_0[3] A_GWDC[0] A_GWDT[0] A_GRDC[0] A_GRDT[0]
+ B_BL_0[0] B_BL_0[1] B_BL_0[2] B_BL_0[3] B_BLB_0[0] B_BLB_0[1] B_BLB_0[2]
+ B_BLB_0[3] B_GWDC[0] B_GWDT[0] B_GRDC[0] B_GRDT[0] SDL400W20S_NMCROW
XMCROW00212 A_WL[212] A_WL[213] A_WL[214] A_WL[215] B_WL[212] B_WL[213]
+ B_WL[214] B_WL[215] A_BL_0[0] A_BL_0[1] A_BL_0[2] A_BL_0[3] A_BLB_0[0]
+ A_BLB_0[1] A_BLB_0[2] A_BLB_0[3] A_GWDC[0] A_GWDT[0] A_GRDC[0] A_GRDT[0]
+ B_BL_0[0] B_BL_0[1] B_BL_0[2] B_BL_0[3] B_BLB_0[0] B_BLB_0[1] B_BLB_0[2]
+ B_BLB_0[3] B_GWDC[0] B_GWDT[0] B_GRDC[0] B_GRDT[0] SDL400W20S_NMCROW
XMCROW00216 A_WL[216] A_WL[217] A_WL[218] A_WL[219] B_WL[216] B_WL[217]
+ B_WL[218] B_WL[219] A_BL_0[0] A_BL_0[1] A_BL_0[2] A_BL_0[3] A_BLB_0[0]
+ A_BLB_0[1] A_BLB_0[2] A_BLB_0[3] A_GWDC[0] A_GWDT[0] A_GRDC[0] A_GRDT[0]
+ B_BL_0[0] B_BL_0[1] B_BL_0[2] B_BL_0[3] B_BLB_0[0] B_BLB_0[1] B_BLB_0[2]
+ B_BLB_0[3] B_GWDC[0] B_GWDT[0] B_GRDC[0] B_GRDT[0] SDL400W20S_NMCROW
XMCROW00220 A_WL[220] A_WL[221] A_WL[222] A_WL[223] B_WL[220] B_WL[221]
+ B_WL[222] B_WL[223] A_BL_0[0] A_BL_0[1] A_BL_0[2] A_BL_0[3] A_BLB_0[0]
+ A_BLB_0[1] A_BLB_0[2] A_BLB_0[3] A_GWDC[0] A_GWDT[0] A_GRDC[0] A_GRDT[0]
+ B_BL_0[0] B_BL_0[1] B_BL_0[2] B_BL_0[3] B_BLB_0[0] B_BLB_0[1] B_BLB_0[2]
+ B_BLB_0[3] B_GWDC[0] B_GWDT[0] B_GRDC[0] B_GRDT[0] SDL400W20S_NMCROW
XMCROW00224 A_WL[224] A_WL[225] A_WL[226] A_WL[227] B_WL[224] B_WL[225]
+ B_WL[226] B_WL[227] A_BL_0[0] A_BL_0[1] A_BL_0[2] A_BL_0[3] A_BLB_0[0]
+ A_BLB_0[1] A_BLB_0[2] A_BLB_0[3] A_GWDC[0] A_GWDT[0] A_GRDC[0] A_GRDT[0]
+ B_BL_0[0] B_BL_0[1] B_BL_0[2] B_BL_0[3] B_BLB_0[0] B_BLB_0[1] B_BLB_0[2]
+ B_BLB_0[3] B_GWDC[0] B_GWDT[0] B_GRDC[0] B_GRDT[0] SDL400W20S_NMCROW
XMCROW00228 A_WL[228] A_WL[229] A_WL[230] A_WL[231] B_WL[228] B_WL[229]
+ B_WL[230] B_WL[231] A_BL_0[0] A_BL_0[1] A_BL_0[2] A_BL_0[3] A_BLB_0[0]
+ A_BLB_0[1] A_BLB_0[2] A_BLB_0[3] A_GWDC[0] A_GWDT[0] A_GRDC[0] A_GRDT[0]
+ B_BL_0[0] B_BL_0[1] B_BL_0[2] B_BL_0[3] B_BLB_0[0] B_BLB_0[1] B_BLB_0[2]
+ B_BLB_0[3] B_GWDC[0] B_GWDT[0] B_GRDC[0] B_GRDT[0] SDL400W20S_NMCROW
XMCROW00232 A_WL[232] A_WL[233] A_WL[234] A_WL[235] B_WL[232] B_WL[233]
+ B_WL[234] B_WL[235] A_BL_0[0] A_BL_0[1] A_BL_0[2] A_BL_0[3] A_BLB_0[0]
+ A_BLB_0[1] A_BLB_0[2] A_BLB_0[3] A_GWDC[0] A_GWDT[0] A_GRDC[0] A_GRDT[0]
+ B_BL_0[0] B_BL_0[1] B_BL_0[2] B_BL_0[3] B_BLB_0[0] B_BLB_0[1] B_BLB_0[2]
+ B_BLB_0[3] B_GWDC[0] B_GWDT[0] B_GRDC[0] B_GRDT[0] SDL400W20S_NMCROW
XMCROW00236 A_WL[236] A_WL[237] A_WL[238] A_WL[239] B_WL[236] B_WL[237]
+ B_WL[238] B_WL[239] A_BL_0[0] A_BL_0[1] A_BL_0[2] A_BL_0[3] A_BLB_0[0]
+ A_BLB_0[1] A_BLB_0[2] A_BLB_0[3] A_GWDC[0] A_GWDT[0] A_GRDC[0] A_GRDT[0]
+ B_BL_0[0] B_BL_0[1] B_BL_0[2] B_BL_0[3] B_BLB_0[0] B_BLB_0[1] B_BLB_0[2]
+ B_BLB_0[3] B_GWDC[0] B_GWDT[0] B_GRDC[0] B_GRDT[0] SDL400W20S_NMCROW
XMCROW00240 A_WL[240] A_WL[241] A_WL[242] A_WL[243] B_WL[240] B_WL[241]
+ B_WL[242] B_WL[243] A_BL_0[0] A_BL_0[1] A_BL_0[2] A_BL_0[3] A_BLB_0[0]
+ A_BLB_0[1] A_BLB_0[2] A_BLB_0[3] A_GWDC[0] A_GWDT[0] A_GRDC[0] A_GRDT[0]
+ B_BL_0[0] B_BL_0[1] B_BL_0[2] B_BL_0[3] B_BLB_0[0] B_BLB_0[1] B_BLB_0[2]
+ B_BLB_0[3] B_GWDC[0] B_GWDT[0] B_GRDC[0] B_GRDT[0] SDL400W20S_NMCROW
XMCROW00244 A_WL[244] A_WL[245] A_WL[246] A_WL[247] B_WL[244] B_WL[245]
+ B_WL[246] B_WL[247] A_BL_0[0] A_BL_0[1] A_BL_0[2] A_BL_0[3] A_BLB_0[0]
+ A_BLB_0[1] A_BLB_0[2] A_BLB_0[3] A_GWDC[0] A_GWDT[0] A_GRDC[0] A_GRDT[0]
+ B_BL_0[0] B_BL_0[1] B_BL_0[2] B_BL_0[3] B_BLB_0[0] B_BLB_0[1] B_BLB_0[2]
+ B_BLB_0[3] B_GWDC[0] B_GWDT[0] B_GRDC[0] B_GRDT[0] SDL400W20S_NMCROW
XMCROW00248 A_WL[248] A_WL[249] A_WL[250] A_WL[251] B_WL[248] B_WL[249]
+ B_WL[250] B_WL[251] A_BL_0[0] A_BL_0[1] A_BL_0[2] A_BL_0[3] A_BLB_0[0]
+ A_BLB_0[1] A_BLB_0[2] A_BLB_0[3] A_GWDC[0] A_GWDT[0] A_GRDC[0] A_GRDT[0]
+ B_BL_0[0] B_BL_0[1] B_BL_0[2] B_BL_0[3] B_BLB_0[0] B_BLB_0[1] B_BLB_0[2]
+ B_BLB_0[3] B_GWDC[0] B_GWDT[0] B_GRDC[0] B_GRDT[0] SDL400W20S_NMCROW
XMCROW00252 A_WL[252] A_WL[253] A_WL[254] A_WL[255] B_WL[252] B_WL[253]
+ B_WL[254] B_WL[255] A_BL_0[0] A_BL_0[1] A_BL_0[2] A_BL_0[3] A_BLB_0[0]
+ A_BLB_0[1] A_BLB_0[2] A_BLB_0[3] A_GWDC[0] A_GWDT[0] A_GRDC[0] A_GRDT[0]
+ B_BL_0[0] B_BL_0[1] B_BL_0[2] B_BL_0[3] B_BLB_0[0] B_BLB_0[1] B_BLB_0[2]
+ B_BLB_0[3] B_GWDC[0] B_GWDT[0] B_GRDC[0] B_GRDT[0] SDL400W20S_NMCROW
.ENDS

.SUBCKT SDL400W20S_NWSLC A_WL[0] A_WL[1] A_WL[2] A_WL[3] A_WL[4] A_WL[5]
+ A_WL[6] A_WL[7] A_WL[8] A_WL[9] A_WL[10] A_WL[11] A_WL[12] A_WL[13] A_WL[14]
+ A_WL[15] A_WL[16] A_WL[17] A_WL[18] A_WL[19] A_WL[20] A_WL[21] A_WL[22]
+ A_WL[23] A_WL[24] A_WL[25] A_WL[26] A_WL[27] A_WL[28] A_WL[29] A_WL[30]
+ A_WL[31] A_WL[32] A_WL[33] A_WL[34] A_WL[35] A_WL[36] A_WL[37] A_WL[38]
+ A_WL[39] A_WL[40] A_WL[41] A_WL[42] A_WL[43] A_WL[44] A_WL[45] A_WL[46]
+ A_WL[47] A_WL[48] A_WL[49] A_WL[50] A_WL[51] A_WL[52] A_WL[53] A_WL[54]
+ A_WL[55] A_WL[56] A_WL[57] A_WL[58] A_WL[59] A_WL[60] A_WL[61] A_WL[62]
+ A_WL[63] A_WL[64] A_WL[65] A_WL[66] A_WL[67] A_WL[68] A_WL[69] A_WL[70]
+ A_WL[71] A_WL[72] A_WL[73] A_WL[74] A_WL[75] A_WL[76] A_WL[77] A_WL[78]
+ A_WL[79] A_WL[80] A_WL[81] A_WL[82] A_WL[83] A_WL[84] A_WL[85] A_WL[86]
+ A_WL[87] A_WL[88] A_WL[89] A_WL[90] A_WL[91] A_WL[92] A_WL[93] A_WL[94]
+ A_WL[95] A_WL[96] A_WL[97] A_WL[98] A_WL[99] A_WL[100] A_WL[101] A_WL[102]
+ A_WL[103] A_WL[104] A_WL[105] A_WL[106] A_WL[107] A_WL[108] A_WL[109]
+ A_WL[110] A_WL[111] A_WL[112] A_WL[113] A_WL[114] A_WL[115] A_WL[116]
+ A_WL[117] A_WL[118] A_WL[119] A_WL[120] A_WL[121] A_WL[122] A_WL[123]
+ A_WL[124] A_WL[125] A_WL[126] A_WL[127] A_WL[128] A_WL[129] A_WL[130]
+ A_WL[131] A_WL[132] A_WL[133] A_WL[134] A_WL[135] A_WL[136] A_WL[137]
+ A_WL[138] A_WL[139] A_WL[140] A_WL[141] A_WL[142] A_WL[143] A_WL[144]
+ A_WL[145] A_WL[146] A_WL[147] A_WL[148] A_WL[149] A_WL[150] A_WL[151]
+ A_WL[152] A_WL[153] A_WL[154] A_WL[155] A_WL[156] A_WL[157] A_WL[158]
+ A_WL[159] A_WL[160] A_WL[161] A_WL[162] A_WL[163] A_WL[164] A_WL[165]
+ A_WL[166] A_WL[167] A_WL[168] A_WL[169] A_WL[170] A_WL[171] A_WL[172]
+ A_WL[173] A_WL[174] A_WL[175] A_WL[176] A_WL[177] A_WL[178] A_WL[179]
+ A_WL[180] A_WL[181] A_WL[182] A_WL[183] A_WL[184] A_WL[185] A_WL[186]
+ A_WL[187] A_WL[188] A_WL[189] A_WL[190] A_WL[191] A_WL[192] A_WL[193]
+ A_WL[194] A_WL[195] A_WL[196] A_WL[197] A_WL[198] A_WL[199] A_WL[200]
+ A_WL[201] A_WL[202] A_WL[203] A_WL[204] A_WL[205] A_WL[206] A_WL[207]
+ A_WL[208] A_WL[209] A_WL[210] A_WL[211] A_WL[212] A_WL[213] A_WL[214]
+ A_WL[215] A_WL[216] A_WL[217] A_WL[218] A_WL[219] A_WL[220] A_WL[221]
+ A_WL[222] A_WL[223] A_WL[224] A_WL[225] A_WL[226] A_WL[227] A_WL[228]
+ A_WL[229] A_WL[230] A_WL[231] A_WL[232] A_WL[233] A_WL[234] A_WL[235]
+ A_WL[236] A_WL[237] A_WL[238] A_WL[239] A_WL[240] A_WL[241] A_WL[242]
+ A_WL[243] A_WL[244] A_WL[245] A_WL[246] A_WL[247] A_WL[248] A_WL[249]
+ A_WL[250] A_WL[251] A_WL[252] A_WL[253] A_WL[254] A_WL[255] B_WL[0] B_WL[1]
+ B_WL[2] B_WL[3] B_WL[4] B_WL[5] B_WL[6] B_WL[7] B_WL[8] B_WL[9] B_WL[10]
+ B_WL[11] B_WL[12] B_WL[13] B_WL[14] B_WL[15] B_WL[16] B_WL[17] B_WL[18]
+ B_WL[19] B_WL[20] B_WL[21] B_WL[22] B_WL[23] B_WL[24] B_WL[25] B_WL[26]
+ B_WL[27] B_WL[28] B_WL[29] B_WL[30] B_WL[31] B_WL[32] B_WL[33] B_WL[34]
+ B_WL[35] B_WL[36] B_WL[37] B_WL[38] B_WL[39] B_WL[40] B_WL[41] B_WL[42]
+ B_WL[43] B_WL[44] B_WL[45] B_WL[46] B_WL[47] B_WL[48] B_WL[49] B_WL[50]
+ B_WL[51] B_WL[52] B_WL[53] B_WL[54] B_WL[55] B_WL[56] B_WL[57] B_WL[58]
+ B_WL[59] B_WL[60] B_WL[61] B_WL[62] B_WL[63] B_WL[64] B_WL[65] B_WL[66]
+ B_WL[67] B_WL[68] B_WL[69] B_WL[70] B_WL[71] B_WL[72] B_WL[73] B_WL[74]
+ B_WL[75] B_WL[76] B_WL[77] B_WL[78] B_WL[79] B_WL[80] B_WL[81] B_WL[82]
+ B_WL[83] B_WL[84] B_WL[85] B_WL[86] B_WL[87] B_WL[88] B_WL[89] B_WL[90]
+ B_WL[91] B_WL[92] B_WL[93] B_WL[94] B_WL[95] B_WL[96] B_WL[97] B_WL[98]
+ B_WL[99] B_WL[100] B_WL[101] B_WL[102] B_WL[103] B_WL[104] B_WL[105]
+ B_WL[106] B_WL[107] B_WL[108] B_WL[109] B_WL[110] B_WL[111] B_WL[112]
+ B_WL[113] B_WL[114] B_WL[115] B_WL[116] B_WL[117] B_WL[118] B_WL[119]
+ B_WL[120] B_WL[121] B_WL[122] B_WL[123] B_WL[124] B_WL[125] B_WL[126]
+ B_WL[127] B_WL[128] B_WL[129] B_WL[130] B_WL[131] B_WL[132] B_WL[133]
+ B_WL[134] B_WL[135] B_WL[136] B_WL[137] B_WL[138] B_WL[139] B_WL[140]
+ B_WL[141] B_WL[142] B_WL[143] B_WL[144] B_WL[145] B_WL[146] B_WL[147]
+ B_WL[148] B_WL[149] B_WL[150] B_WL[151] B_WL[152] B_WL[153] B_WL[154]
+ B_WL[155] B_WL[156] B_WL[157] B_WL[158] B_WL[159] B_WL[160] B_WL[161]
+ B_WL[162] B_WL[163] B_WL[164] B_WL[165] B_WL[166] B_WL[167] B_WL[168]
+ B_WL[169] B_WL[170] B_WL[171] B_WL[172] B_WL[173] B_WL[174] B_WL[175]
+ B_WL[176] B_WL[177] B_WL[178] B_WL[179] B_WL[180] B_WL[181] B_WL[182]
+ B_WL[183] B_WL[184] B_WL[185] B_WL[186] B_WL[187] B_WL[188] B_WL[189]
+ B_WL[190] B_WL[191] B_WL[192] B_WL[193] B_WL[194] B_WL[195] B_WL[196]
+ B_WL[197] B_WL[198] B_WL[199] B_WL[200] B_WL[201] B_WL[202] B_WL[203]
+ B_WL[204] B_WL[205] B_WL[206] B_WL[207] B_WL[208] B_WL[209] B_WL[210]
+ B_WL[211] B_WL[212] B_WL[213] B_WL[214] B_WL[215] B_WL[216] B_WL[217]
+ B_WL[218] B_WL[219] B_WL[220] B_WL[221] B_WL[222] B_WL[223] B_WL[224]
+ B_WL[225] B_WL[226] B_WL[227] B_WL[228] B_WL[229] B_WL[230] B_WL[231]
+ B_WL[232] B_WL[233] B_WL[234] B_WL[235] B_WL[236] B_WL[237] B_WL[238]
+ B_WL[239] B_WL[240] B_WL[241] B_WL[242] B_WL[243] B_WL[244] B_WL[245]
+ B_WL[246] B_WL[247] B_WL[248] B_WL[249] B_WL[250] B_WL[251] B_WL[252]
+ B_WL[253] B_WL[254] B_WL[255] A_GCDEC[3] A_GCDEC[2] A_GCDEC[1] A_GCDEC[0]
+ A_RD A_VS[1] A_VS[0] A_WRT A_XA[7] A_XA[6] A_XA[5] A_XA[4] A_XA[3] A_XA[2]
+ A_XA[1] A_XA[0] A_XB[3] A_XB[2] A_XB[1] A_XB[0] A_XC[7] A_XC[6] A_XC[5]
+ A_XC[4] A_XC[3] A_XC[2] A_XC[1] A_XC[0] A_Y[7] A_Y[6] A_Y[5] A_Y[4] A_Y[3]
+ A_Y[2] A_Y[1] A_Y[0] B_GCDEC[3] B_GCDEC[2] B_GCDEC[1] B_GCDEC[0] B_RD B_VS[1]
+ B_VS[0] B_WRT B_XA[7] B_XA[6] B_XA[5] B_XA[4] B_XA[3] B_XA[2] B_XA[1] B_XA[0]
+ B_XB[3] B_XB[2] B_XB[1] B_XB[0] B_XC[7] B_XC[6] B_XC[5] B_XC[4] B_XC[3]
+ B_XC[2] B_XC[1] B_XC[0] B_Y[7] B_Y[6] B_Y[5] B_Y[4] B_Y[3] B_Y[2] B_Y[1]
+ B_Y[0] A_Z[7] A_Z[6] A_Z[5] A_Z[4] A_Z[3] A_Z[2] A_Z[1] A_Z[0] B_Z[7] B_Z[6]
+ B_Z[5] B_Z[4] B_Z[3] B_Z[2] B_Z[1] B_Z[0] A_RDL[0] A_SMPRS_0[3] A_SMPRS_0[2]
+ A_SMPRS_0[1] A_SMPRS_0[0] A_SOE[0] A_WRTL[0] A_YSEL_0[7] A_YSEL_0[6]
+ A_YSEL_0[5] A_YSEL_0[4] A_YSEL_0[3] A_YSEL_0[2] A_YSEL_0[1] A_YSEL_0[0]
+ B_RDL[0] B_SMPRS_0[3] B_SMPRS_0[2] B_SMPRS_0[1] B_SMPRS_0[0] B_SOE[0]
+ B_WRTL[0] B_YSEL_0[7] B_YSEL_0[6] B_YSEL_0[5] B_YSEL_0[4] B_YSEL_0[3]
+ B_YSEL_0[2] B_YSEL_0[1] B_YSEL_0[0]
XLCTRLA0 A_GCDEC[3] A_GCDEC[2] A_GCDEC[1] A_GCDEC[0] A_RD A_VS[1] A_VS[0]
+ A_WRT A_XA[7] A_XA[6] A_XA[5] A_XA[4] A_XA[3] A_XA[2] A_XA[1] A_XA[0] A_XB[3]
+ A_XB[2] A_XB[1] A_XB[0] A_XC[7] A_XC[6] A_XC[5] A_XC[4] A_XC[3] A_XC[2]
+ A_XC[1] A_XC[0] A_Y[7] A_Y[6] A_Y[5] A_Y[4] A_Y[3] A_Y[2] A_Y[1] A_Y[0]
+ B_GCDEC[3] B_GCDEC[2] B_GCDEC[1] B_GCDEC[0] B_RD B_VS[1] B_VS[0] B_WRT
+ B_XA[7] B_XA[6] B_XA[5] B_XA[4] B_XA[3] B_XA[2] B_XA[1] B_XA[0] B_XB[3]
+ B_XB[2] B_XB[1] B_XB[0] B_XC[7] B_XC[6] B_XC[5] B_XC[4] B_XC[3] B_XC[2]
+ B_XC[1] B_XC[0] B_Y[7] B_Y[6] B_Y[5] B_Y[4] B_Y[3] B_Y[2] B_Y[1] B_Y[0]
+ A_Z[0] A_RDL[0] A_SMPRS_0[3] A_SMPRS_0[2] A_SMPRS_0[1] A_SMPRS_0[0] A_SOE[0]
+ A_WRTL[0] A_XLA_0[7] A_XLA_0[6] A_XLA_0[5] A_XLA_0[4] A_XLA_0[3] A_XLA_0[2]
+ A_XLA_0[1] A_XLA_0[0] A_XLB_0[3] A_XLB_0[2] A_XLB_0[1] A_XLB_0[0] A_XLC_0[7]
+ A_XLC_0[6] A_XLC_0[5] A_XLC_0[4] A_XLC_0[3] A_XLC_0[2] A_XLC_0[1] A_XLC_0[0]
+ A_YSEL_0[7] A_YSEL_0[6] A_YSEL_0[5] A_YSEL_0[4] A_YSEL_0[3] A_YSEL_0[2]
+ A_YSEL_0[1] A_YSEL_0[0] A_Z[7] A_Z[6] A_Z[5] A_Z[4] A_Z[3] A_Z[2] A_Z[1]
+ A_Z[0] B_Z[7] B_Z[6] B_Z[5] B_Z[4] B_Z[3] B_Z[2] B_Z[1] B_Z[0]
+  SDL400W20S_NLCTRLA
XLCTRLB0 A_GCDEC[3] A_GCDEC[2] A_GCDEC[1] A_GCDEC[0] A_RD A_VS[1] A_VS[0]
+ A_WRT A_XA[7] A_XA[6] A_XA[5] A_XA[4] A_XA[3] A_XA[2] A_XA[1] A_XA[0] A_XB[3]
+ A_XB[2] A_XB[1] A_XB[0] A_XC[7] A_XC[6] A_XC[5] A_XC[4] A_XC[3] A_XC[2]
+ A_XC[1] A_XC[0] A_Y[7] A_Y[6] A_Y[5] A_Y[4] A_Y[3] A_Y[2] A_Y[1] A_Y[0]
+ B_GCDEC[3] B_GCDEC[2] B_GCDEC[1] B_GCDEC[0] B_RD B_VS[1] B_VS[0] B_WRT
+ B_XA[7] B_XA[6] B_XA[5] B_XA[4] B_XA[3] B_XA[2] B_XA[1] B_XA[0] B_XB[3]
+ B_XB[2] B_XB[1] B_XB[0] B_XC[7] B_XC[6] B_XC[5] B_XC[4] B_XC[3] B_XC[2]
+ B_XC[1] B_XC[0] B_Y[7] B_Y[6] B_Y[5] B_Y[4] B_Y[3] B_Y[2] B_Y[1] B_Y[0]
+ B_Z[0] B_RDL[0] B_SMPRS_0[3] B_SMPRS_0[2] B_SMPRS_0[1] B_SMPRS_0[0] B_SOE[0]
+ B_WRTL[0] B_XLA_0[7] B_XLA_0[6] B_XLA_0[5] B_XLA_0[4] B_XLA_0[3] B_XLA_0[2]
+ B_XLA_0[1] B_XLA_0[0] B_XLB_0[3] B_XLB_0[2] B_XLB_0[1] B_XLB_0[0] B_XLC_0[7]
+ B_XLC_0[6] B_XLC_0[5] B_XLC_0[4] B_XLC_0[3] B_XLC_0[2] B_XLC_0[1] B_XLC_0[0]
+ B_YSEL_0[7] B_YSEL_0[6] B_YSEL_0[5] B_YSEL_0[4] B_YSEL_0[3] B_YSEL_0[2]
+ B_YSEL_0[1] B_YSEL_0[0] A_Z[7] A_Z[6] A_Z[5] A_Z[4] A_Z[3] A_Z[2] A_Z[1]
+ A_Z[0] B_Z[7] B_Z[6] B_Z[5] B_Z[4] B_Z[3] B_Z[2] B_Z[1] B_Z[0]
+  SDL400W20S_NLCTRLB
XWLDV2P00 A_XLA_0[0] A_XLA_0[1] A_XLA_0[2] A_XLA_0[3] A_XLB_0[0] A_XLC_0[0]
+ B_XLA_0[0] B_XLA_0[1] B_XLA_0[2] B_XLA_0[3] B_XLB_0[0] B_XLC_0[0] A_WL[0]
+ A_WL[1] A_WL[2] A_WL[3] B_WL[0] B_WL[1] B_WL[2] B_WL[3] SDL400W20S_NWLDV2P
XWLDV2P04 A_XLA_0[4] A_XLA_0[5] A_XLA_0[6] A_XLA_0[7] A_XLB_0[0] A_XLC_0[0]
+ B_XLA_0[4] B_XLA_0[5] B_XLA_0[6] B_XLA_0[7] B_XLB_0[0] B_XLC_0[0] A_WL[4]
+ A_WL[5] A_WL[6] A_WL[7] B_WL[4] B_WL[5] B_WL[6] B_WL[7] SDL400W20S_NWLDV2P
XWLDV2P08 A_XLA_0[0] A_XLA_0[1] A_XLA_0[2] A_XLA_0[3] A_XLB_0[1] A_XLC_0[0]
+ B_XLA_0[0] B_XLA_0[1] B_XLA_0[2] B_XLA_0[3] B_XLB_0[1] B_XLC_0[0] A_WL[8]
+ A_WL[9] A_WL[10] A_WL[11] B_WL[8] B_WL[9] B_WL[10] B_WL[11]
+  SDL400W20S_NWLDV2P
XWLDV2P012 A_XLA_0[4] A_XLA_0[5] A_XLA_0[6] A_XLA_0[7] A_XLB_0[1] A_XLC_0[0]
+ B_XLA_0[4] B_XLA_0[5] B_XLA_0[6] B_XLA_0[7] B_XLB_0[1] B_XLC_0[0] A_WL[12]
+ A_WL[13] A_WL[14] A_WL[15] B_WL[12] B_WL[13] B_WL[14] B_WL[15]
+  SDL400W20S_NWLDV2P
XWLDV2P016 A_XLA_0[0] A_XLA_0[1] A_XLA_0[2] A_XLA_0[3] A_XLB_0[2] A_XLC_0[0]
+ B_XLA_0[0] B_XLA_0[1] B_XLA_0[2] B_XLA_0[3] B_XLB_0[2] B_XLC_0[0] A_WL[16]
+ A_WL[17] A_WL[18] A_WL[19] B_WL[16] B_WL[17] B_WL[18] B_WL[19]
+  SDL400W20S_NWLDV2P
XWLDV2P020 A_XLA_0[4] A_XLA_0[5] A_XLA_0[6] A_XLA_0[7] A_XLB_0[2] A_XLC_0[0]
+ B_XLA_0[4] B_XLA_0[5] B_XLA_0[6] B_XLA_0[7] B_XLB_0[2] B_XLC_0[0] A_WL[20]
+ A_WL[21] A_WL[22] A_WL[23] B_WL[20] B_WL[21] B_WL[22] B_WL[23]
+  SDL400W20S_NWLDV2P
XWLDV2P024 A_XLA_0[0] A_XLA_0[1] A_XLA_0[2] A_XLA_0[3] A_XLB_0[3] A_XLC_0[0]
+ B_XLA_0[0] B_XLA_0[1] B_XLA_0[2] B_XLA_0[3] B_XLB_0[3] B_XLC_0[0] A_WL[24]
+ A_WL[25] A_WL[26] A_WL[27] B_WL[24] B_WL[25] B_WL[26] B_WL[27]
+  SDL400W20S_NWLDV2P
XWLDV2P028 A_XLA_0[4] A_XLA_0[5] A_XLA_0[6] A_XLA_0[7] A_XLB_0[3] A_XLC_0[0]
+ B_XLA_0[4] B_XLA_0[5] B_XLA_0[6] B_XLA_0[7] B_XLB_0[3] B_XLC_0[0] A_WL[28]
+ A_WL[29] A_WL[30] A_WL[31] B_WL[28] B_WL[29] B_WL[30] B_WL[31]
+  SDL400W20S_NWLDV2P
XWLDV2P032 A_XLA_0[0] A_XLA_0[1] A_XLA_0[2] A_XLA_0[3] A_XLB_0[0] A_XLC_0[1]
+ B_XLA_0[0] B_XLA_0[1] B_XLA_0[2] B_XLA_0[3] B_XLB_0[0] B_XLC_0[1] A_WL[32]
+ A_WL[33] A_WL[34] A_WL[35] B_WL[32] B_WL[33] B_WL[34] B_WL[35]
+  SDL400W20S_NWLDV2P
XWLDV2P036 A_XLA_0[4] A_XLA_0[5] A_XLA_0[6] A_XLA_0[7] A_XLB_0[0] A_XLC_0[1]
+ B_XLA_0[4] B_XLA_0[5] B_XLA_0[6] B_XLA_0[7] B_XLB_0[0] B_XLC_0[1] A_WL[36]
+ A_WL[37] A_WL[38] A_WL[39] B_WL[36] B_WL[37] B_WL[38] B_WL[39]
+  SDL400W20S_NWLDV2P
XWLDV2P040 A_XLA_0[0] A_XLA_0[1] A_XLA_0[2] A_XLA_0[3] A_XLB_0[1] A_XLC_0[1]
+ B_XLA_0[0] B_XLA_0[1] B_XLA_0[2] B_XLA_0[3] B_XLB_0[1] B_XLC_0[1] A_WL[40]
+ A_WL[41] A_WL[42] A_WL[43] B_WL[40] B_WL[41] B_WL[42] B_WL[43]
+  SDL400W20S_NWLDV2P
XWLDV2P044 A_XLA_0[4] A_XLA_0[5] A_XLA_0[6] A_XLA_0[7] A_XLB_0[1] A_XLC_0[1]
+ B_XLA_0[4] B_XLA_0[5] B_XLA_0[6] B_XLA_0[7] B_XLB_0[1] B_XLC_0[1] A_WL[44]
+ A_WL[45] A_WL[46] A_WL[47] B_WL[44] B_WL[45] B_WL[46] B_WL[47]
+  SDL400W20S_NWLDV2P
XWLDV2P048 A_XLA_0[0] A_XLA_0[1] A_XLA_0[2] A_XLA_0[3] A_XLB_0[2] A_XLC_0[1]
+ B_XLA_0[0] B_XLA_0[1] B_XLA_0[2] B_XLA_0[3] B_XLB_0[2] B_XLC_0[1] A_WL[48]
+ A_WL[49] A_WL[50] A_WL[51] B_WL[48] B_WL[49] B_WL[50] B_WL[51]
+  SDL400W20S_NWLDV2P
XWLDV2P052 A_XLA_0[4] A_XLA_0[5] A_XLA_0[6] A_XLA_0[7] A_XLB_0[2] A_XLC_0[1]
+ B_XLA_0[4] B_XLA_0[5] B_XLA_0[6] B_XLA_0[7] B_XLB_0[2] B_XLC_0[1] A_WL[52]
+ A_WL[53] A_WL[54] A_WL[55] B_WL[52] B_WL[53] B_WL[54] B_WL[55]
+  SDL400W20S_NWLDV2P
XWLDV2P056 A_XLA_0[0] A_XLA_0[1] A_XLA_0[2] A_XLA_0[3] A_XLB_0[3] A_XLC_0[1]
+ B_XLA_0[0] B_XLA_0[1] B_XLA_0[2] B_XLA_0[3] B_XLB_0[3] B_XLC_0[1] A_WL[56]
+ A_WL[57] A_WL[58] A_WL[59] B_WL[56] B_WL[57] B_WL[58] B_WL[59]
+  SDL400W20S_NWLDV2P
XWLDV2P060 A_XLA_0[4] A_XLA_0[5] A_XLA_0[6] A_XLA_0[7] A_XLB_0[3] A_XLC_0[1]
+ B_XLA_0[4] B_XLA_0[5] B_XLA_0[6] B_XLA_0[7] B_XLB_0[3] B_XLC_0[1] A_WL[60]
+ A_WL[61] A_WL[62] A_WL[63] B_WL[60] B_WL[61] B_WL[62] B_WL[63]
+  SDL400W20S_NWLDV2P
XWLDV2P064 A_XLA_0[0] A_XLA_0[1] A_XLA_0[2] A_XLA_0[3] A_XLB_0[0] A_XLC_0[2]
+ B_XLA_0[0] B_XLA_0[1] B_XLA_0[2] B_XLA_0[3] B_XLB_0[0] B_XLC_0[2] A_WL[64]
+ A_WL[65] A_WL[66] A_WL[67] B_WL[64] B_WL[65] B_WL[66] B_WL[67]
+  SDL400W20S_NWLDV2P
XWLDV2P068 A_XLA_0[4] A_XLA_0[5] A_XLA_0[6] A_XLA_0[7] A_XLB_0[0] A_XLC_0[2]
+ B_XLA_0[4] B_XLA_0[5] B_XLA_0[6] B_XLA_0[7] B_XLB_0[0] B_XLC_0[2] A_WL[68]
+ A_WL[69] A_WL[70] A_WL[71] B_WL[68] B_WL[69] B_WL[70] B_WL[71]
+  SDL400W20S_NWLDV2P
XWLDV2P072 A_XLA_0[0] A_XLA_0[1] A_XLA_0[2] A_XLA_0[3] A_XLB_0[1] A_XLC_0[2]
+ B_XLA_0[0] B_XLA_0[1] B_XLA_0[2] B_XLA_0[3] B_XLB_0[1] B_XLC_0[2] A_WL[72]
+ A_WL[73] A_WL[74] A_WL[75] B_WL[72] B_WL[73] B_WL[74] B_WL[75]
+  SDL400W20S_NWLDV2P
XWLDV2P076 A_XLA_0[4] A_XLA_0[5] A_XLA_0[6] A_XLA_0[7] A_XLB_0[1] A_XLC_0[2]
+ B_XLA_0[4] B_XLA_0[5] B_XLA_0[6] B_XLA_0[7] B_XLB_0[1] B_XLC_0[2] A_WL[76]
+ A_WL[77] A_WL[78] A_WL[79] B_WL[76] B_WL[77] B_WL[78] B_WL[79]
+  SDL400W20S_NWLDV2P
XWLDV2P080 A_XLA_0[0] A_XLA_0[1] A_XLA_0[2] A_XLA_0[3] A_XLB_0[2] A_XLC_0[2]
+ B_XLA_0[0] B_XLA_0[1] B_XLA_0[2] B_XLA_0[3] B_XLB_0[2] B_XLC_0[2] A_WL[80]
+ A_WL[81] A_WL[82] A_WL[83] B_WL[80] B_WL[81] B_WL[82] B_WL[83]
+  SDL400W20S_NWLDV2P
XWLDV2P084 A_XLA_0[4] A_XLA_0[5] A_XLA_0[6] A_XLA_0[7] A_XLB_0[2] A_XLC_0[2]
+ B_XLA_0[4] B_XLA_0[5] B_XLA_0[6] B_XLA_0[7] B_XLB_0[2] B_XLC_0[2] A_WL[84]
+ A_WL[85] A_WL[86] A_WL[87] B_WL[84] B_WL[85] B_WL[86] B_WL[87]
+  SDL400W20S_NWLDV2P
XWLDV2P088 A_XLA_0[0] A_XLA_0[1] A_XLA_0[2] A_XLA_0[3] A_XLB_0[3] A_XLC_0[2]
+ B_XLA_0[0] B_XLA_0[1] B_XLA_0[2] B_XLA_0[3] B_XLB_0[3] B_XLC_0[2] A_WL[88]
+ A_WL[89] A_WL[90] A_WL[91] B_WL[88] B_WL[89] B_WL[90] B_WL[91]
+  SDL400W20S_NWLDV2P
XWLDV2P092 A_XLA_0[4] A_XLA_0[5] A_XLA_0[6] A_XLA_0[7] A_XLB_0[3] A_XLC_0[2]
+ B_XLA_0[4] B_XLA_0[5] B_XLA_0[6] B_XLA_0[7] B_XLB_0[3] B_XLC_0[2] A_WL[92]
+ A_WL[93] A_WL[94] A_WL[95] B_WL[92] B_WL[93] B_WL[94] B_WL[95]
+  SDL400W20S_NWLDV2P
XWLDV2P096 A_XLA_0[0] A_XLA_0[1] A_XLA_0[2] A_XLA_0[3] A_XLB_0[0] A_XLC_0[3]
+ B_XLA_0[0] B_XLA_0[1] B_XLA_0[2] B_XLA_0[3] B_XLB_0[0] B_XLC_0[3] A_WL[96]
+ A_WL[97] A_WL[98] A_WL[99] B_WL[96] B_WL[97] B_WL[98] B_WL[99]
+  SDL400W20S_NWLDV2P
XWLDV2P0100 A_XLA_0[4] A_XLA_0[5] A_XLA_0[6] A_XLA_0[7] A_XLB_0[0] A_XLC_0[3]
+ B_XLA_0[4] B_XLA_0[5] B_XLA_0[6] B_XLA_0[7] B_XLB_0[0] B_XLC_0[3] A_WL[100]
+ A_WL[101] A_WL[102] A_WL[103] B_WL[100] B_WL[101] B_WL[102] B_WL[103]
+  SDL400W20S_NWLDV2P
XWLDV2P0104 A_XLA_0[0] A_XLA_0[1] A_XLA_0[2] A_XLA_0[3] A_XLB_0[1] A_XLC_0[3]
+ B_XLA_0[0] B_XLA_0[1] B_XLA_0[2] B_XLA_0[3] B_XLB_0[1] B_XLC_0[3] A_WL[104]
+ A_WL[105] A_WL[106] A_WL[107] B_WL[104] B_WL[105] B_WL[106] B_WL[107]
+  SDL400W20S_NWLDV2P
XWLDV2P0108 A_XLA_0[4] A_XLA_0[5] A_XLA_0[6] A_XLA_0[7] A_XLB_0[1] A_XLC_0[3]
+ B_XLA_0[4] B_XLA_0[5] B_XLA_0[6] B_XLA_0[7] B_XLB_0[1] B_XLC_0[3] A_WL[108]
+ A_WL[109] A_WL[110] A_WL[111] B_WL[108] B_WL[109] B_WL[110] B_WL[111]
+  SDL400W20S_NWLDV2P
XWLDV2P0112 A_XLA_0[0] A_XLA_0[1] A_XLA_0[2] A_XLA_0[3] A_XLB_0[2] A_XLC_0[3]
+ B_XLA_0[0] B_XLA_0[1] B_XLA_0[2] B_XLA_0[3] B_XLB_0[2] B_XLC_0[3] A_WL[112]
+ A_WL[113] A_WL[114] A_WL[115] B_WL[112] B_WL[113] B_WL[114] B_WL[115]
+  SDL400W20S_NWLDV2P
XWLDV2P0116 A_XLA_0[4] A_XLA_0[5] A_XLA_0[6] A_XLA_0[7] A_XLB_0[2] A_XLC_0[3]
+ B_XLA_0[4] B_XLA_0[5] B_XLA_0[6] B_XLA_0[7] B_XLB_0[2] B_XLC_0[3] A_WL[116]
+ A_WL[117] A_WL[118] A_WL[119] B_WL[116] B_WL[117] B_WL[118] B_WL[119]
+  SDL400W20S_NWLDV2P
XWLDV2P0120 A_XLA_0[0] A_XLA_0[1] A_XLA_0[2] A_XLA_0[3] A_XLB_0[3] A_XLC_0[3]
+ B_XLA_0[0] B_XLA_0[1] B_XLA_0[2] B_XLA_0[3] B_XLB_0[3] B_XLC_0[3] A_WL[120]
+ A_WL[121] A_WL[122] A_WL[123] B_WL[120] B_WL[121] B_WL[122] B_WL[123]
+  SDL400W20S_NWLDV2P
XWLDV2P0124 A_XLA_0[4] A_XLA_0[5] A_XLA_0[6] A_XLA_0[7] A_XLB_0[3] A_XLC_0[3]
+ B_XLA_0[4] B_XLA_0[5] B_XLA_0[6] B_XLA_0[7] B_XLB_0[3] B_XLC_0[3] A_WL[124]
+ A_WL[125] A_WL[126] A_WL[127] B_WL[124] B_WL[125] B_WL[126] B_WL[127]
+  SDL400W20S_NWLDV2P
XWLDV2P0128 A_XLA_0[0] A_XLA_0[1] A_XLA_0[2] A_XLA_0[3] A_XLB_0[0] A_XLC_0[4]
+ B_XLA_0[0] B_XLA_0[1] B_XLA_0[2] B_XLA_0[3] B_XLB_0[0] B_XLC_0[4] A_WL[128]
+ A_WL[129] A_WL[130] A_WL[131] B_WL[128] B_WL[129] B_WL[130] B_WL[131]
+  SDL400W20S_NWLDV2P
XWLDV2P0132 A_XLA_0[4] A_XLA_0[5] A_XLA_0[6] A_XLA_0[7] A_XLB_0[0] A_XLC_0[4]
+ B_XLA_0[4] B_XLA_0[5] B_XLA_0[6] B_XLA_0[7] B_XLB_0[0] B_XLC_0[4] A_WL[132]
+ A_WL[133] A_WL[134] A_WL[135] B_WL[132] B_WL[133] B_WL[134] B_WL[135]
+  SDL400W20S_NWLDV2P
XWLDV2P0136 A_XLA_0[0] A_XLA_0[1] A_XLA_0[2] A_XLA_0[3] A_XLB_0[1] A_XLC_0[4]
+ B_XLA_0[0] B_XLA_0[1] B_XLA_0[2] B_XLA_0[3] B_XLB_0[1] B_XLC_0[4] A_WL[136]
+ A_WL[137] A_WL[138] A_WL[139] B_WL[136] B_WL[137] B_WL[138] B_WL[139]
+  SDL400W20S_NWLDV2P
XWLDV2P0140 A_XLA_0[4] A_XLA_0[5] A_XLA_0[6] A_XLA_0[7] A_XLB_0[1] A_XLC_0[4]
+ B_XLA_0[4] B_XLA_0[5] B_XLA_0[6] B_XLA_0[7] B_XLB_0[1] B_XLC_0[4] A_WL[140]
+ A_WL[141] A_WL[142] A_WL[143] B_WL[140] B_WL[141] B_WL[142] B_WL[143]
+  SDL400W20S_NWLDV2P
XWLDV2P0144 A_XLA_0[0] A_XLA_0[1] A_XLA_0[2] A_XLA_0[3] A_XLB_0[2] A_XLC_0[4]
+ B_XLA_0[0] B_XLA_0[1] B_XLA_0[2] B_XLA_0[3] B_XLB_0[2] B_XLC_0[4] A_WL[144]
+ A_WL[145] A_WL[146] A_WL[147] B_WL[144] B_WL[145] B_WL[146] B_WL[147]
+  SDL400W20S_NWLDV2P
XWLDV2P0148 A_XLA_0[4] A_XLA_0[5] A_XLA_0[6] A_XLA_0[7] A_XLB_0[2] A_XLC_0[4]
+ B_XLA_0[4] B_XLA_0[5] B_XLA_0[6] B_XLA_0[7] B_XLB_0[2] B_XLC_0[4] A_WL[148]
+ A_WL[149] A_WL[150] A_WL[151] B_WL[148] B_WL[149] B_WL[150] B_WL[151]
+  SDL400W20S_NWLDV2P
XWLDV2P0152 A_XLA_0[0] A_XLA_0[1] A_XLA_0[2] A_XLA_0[3] A_XLB_0[3] A_XLC_0[4]
+ B_XLA_0[0] B_XLA_0[1] B_XLA_0[2] B_XLA_0[3] B_XLB_0[3] B_XLC_0[4] A_WL[152]
+ A_WL[153] A_WL[154] A_WL[155] B_WL[152] B_WL[153] B_WL[154] B_WL[155]
+  SDL400W20S_NWLDV2P
XWLDV2P0156 A_XLA_0[4] A_XLA_0[5] A_XLA_0[6] A_XLA_0[7] A_XLB_0[3] A_XLC_0[4]
+ B_XLA_0[4] B_XLA_0[5] B_XLA_0[6] B_XLA_0[7] B_XLB_0[3] B_XLC_0[4] A_WL[156]
+ A_WL[157] A_WL[158] A_WL[159] B_WL[156] B_WL[157] B_WL[158] B_WL[159]
+  SDL400W20S_NWLDV2P
XWLDV2P0160 A_XLA_0[0] A_XLA_0[1] A_XLA_0[2] A_XLA_0[3] A_XLB_0[0] A_XLC_0[5]
+ B_XLA_0[0] B_XLA_0[1] B_XLA_0[2] B_XLA_0[3] B_XLB_0[0] B_XLC_0[5] A_WL[160]
+ A_WL[161] A_WL[162] A_WL[163] B_WL[160] B_WL[161] B_WL[162] B_WL[163]
+  SDL400W20S_NWLDV2P
XWLDV2P0164 A_XLA_0[4] A_XLA_0[5] A_XLA_0[6] A_XLA_0[7] A_XLB_0[0] A_XLC_0[5]
+ B_XLA_0[4] B_XLA_0[5] B_XLA_0[6] B_XLA_0[7] B_XLB_0[0] B_XLC_0[5] A_WL[164]
+ A_WL[165] A_WL[166] A_WL[167] B_WL[164] B_WL[165] B_WL[166] B_WL[167]
+  SDL400W20S_NWLDV2P
XWLDV2P0168 A_XLA_0[0] A_XLA_0[1] A_XLA_0[2] A_XLA_0[3] A_XLB_0[1] A_XLC_0[5]
+ B_XLA_0[0] B_XLA_0[1] B_XLA_0[2] B_XLA_0[3] B_XLB_0[1] B_XLC_0[5] A_WL[168]
+ A_WL[169] A_WL[170] A_WL[171] B_WL[168] B_WL[169] B_WL[170] B_WL[171]
+  SDL400W20S_NWLDV2P
XWLDV2P0172 A_XLA_0[4] A_XLA_0[5] A_XLA_0[6] A_XLA_0[7] A_XLB_0[1] A_XLC_0[5]
+ B_XLA_0[4] B_XLA_0[5] B_XLA_0[6] B_XLA_0[7] B_XLB_0[1] B_XLC_0[5] A_WL[172]
+ A_WL[173] A_WL[174] A_WL[175] B_WL[172] B_WL[173] B_WL[174] B_WL[175]
+  SDL400W20S_NWLDV2P
XWLDV2P0176 A_XLA_0[0] A_XLA_0[1] A_XLA_0[2] A_XLA_0[3] A_XLB_0[2] A_XLC_0[5]
+ B_XLA_0[0] B_XLA_0[1] B_XLA_0[2] B_XLA_0[3] B_XLB_0[2] B_XLC_0[5] A_WL[176]
+ A_WL[177] A_WL[178] A_WL[179] B_WL[176] B_WL[177] B_WL[178] B_WL[179]
+  SDL400W20S_NWLDV2P
XWLDV2P0180 A_XLA_0[4] A_XLA_0[5] A_XLA_0[6] A_XLA_0[7] A_XLB_0[2] A_XLC_0[5]
+ B_XLA_0[4] B_XLA_0[5] B_XLA_0[6] B_XLA_0[7] B_XLB_0[2] B_XLC_0[5] A_WL[180]
+ A_WL[181] A_WL[182] A_WL[183] B_WL[180] B_WL[181] B_WL[182] B_WL[183]
+  SDL400W20S_NWLDV2P
XWLDV2P0184 A_XLA_0[0] A_XLA_0[1] A_XLA_0[2] A_XLA_0[3] A_XLB_0[3] A_XLC_0[5]
+ B_XLA_0[0] B_XLA_0[1] B_XLA_0[2] B_XLA_0[3] B_XLB_0[3] B_XLC_0[5] A_WL[184]
+ A_WL[185] A_WL[186] A_WL[187] B_WL[184] B_WL[185] B_WL[186] B_WL[187]
+  SDL400W20S_NWLDV2P
XWLDV2P0188 A_XLA_0[4] A_XLA_0[5] A_XLA_0[6] A_XLA_0[7] A_XLB_0[3] A_XLC_0[5]
+ B_XLA_0[4] B_XLA_0[5] B_XLA_0[6] B_XLA_0[7] B_XLB_0[3] B_XLC_0[5] A_WL[188]
+ A_WL[189] A_WL[190] A_WL[191] B_WL[188] B_WL[189] B_WL[190] B_WL[191]
+  SDL400W20S_NWLDV2P
XWLDV2P0192 A_XLA_0[0] A_XLA_0[1] A_XLA_0[2] A_XLA_0[3] A_XLB_0[0] A_XLC_0[6]
+ B_XLA_0[0] B_XLA_0[1] B_XLA_0[2] B_XLA_0[3] B_XLB_0[0] B_XLC_0[6] A_WL[192]
+ A_WL[193] A_WL[194] A_WL[195] B_WL[192] B_WL[193] B_WL[194] B_WL[195]
+  SDL400W20S_NWLDV2P
XWLDV2P0196 A_XLA_0[4] A_XLA_0[5] A_XLA_0[6] A_XLA_0[7] A_XLB_0[0] A_XLC_0[6]
+ B_XLA_0[4] B_XLA_0[5] B_XLA_0[6] B_XLA_0[7] B_XLB_0[0] B_XLC_0[6] A_WL[196]
+ A_WL[197] A_WL[198] A_WL[199] B_WL[196] B_WL[197] B_WL[198] B_WL[199]
+  SDL400W20S_NWLDV2P
XWLDV2P0200 A_XLA_0[0] A_XLA_0[1] A_XLA_0[2] A_XLA_0[3] A_XLB_0[1] A_XLC_0[6]
+ B_XLA_0[0] B_XLA_0[1] B_XLA_0[2] B_XLA_0[3] B_XLB_0[1] B_XLC_0[6] A_WL[200]
+ A_WL[201] A_WL[202] A_WL[203] B_WL[200] B_WL[201] B_WL[202] B_WL[203]
+  SDL400W20S_NWLDV2P
XWLDV2P0204 A_XLA_0[4] A_XLA_0[5] A_XLA_0[6] A_XLA_0[7] A_XLB_0[1] A_XLC_0[6]
+ B_XLA_0[4] B_XLA_0[5] B_XLA_0[6] B_XLA_0[7] B_XLB_0[1] B_XLC_0[6] A_WL[204]
+ A_WL[205] A_WL[206] A_WL[207] B_WL[204] B_WL[205] B_WL[206] B_WL[207]
+  SDL400W20S_NWLDV2P
XWLDV2P0208 A_XLA_0[0] A_XLA_0[1] A_XLA_0[2] A_XLA_0[3] A_XLB_0[2] A_XLC_0[6]
+ B_XLA_0[0] B_XLA_0[1] B_XLA_0[2] B_XLA_0[3] B_XLB_0[2] B_XLC_0[6] A_WL[208]
+ A_WL[209] A_WL[210] A_WL[211] B_WL[208] B_WL[209] B_WL[210] B_WL[211]
+  SDL400W20S_NWLDV2P
XWLDV2P0212 A_XLA_0[4] A_XLA_0[5] A_XLA_0[6] A_XLA_0[7] A_XLB_0[2] A_XLC_0[6]
+ B_XLA_0[4] B_XLA_0[5] B_XLA_0[6] B_XLA_0[7] B_XLB_0[2] B_XLC_0[6] A_WL[212]
+ A_WL[213] A_WL[214] A_WL[215] B_WL[212] B_WL[213] B_WL[214] B_WL[215]
+  SDL400W20S_NWLDV2P
XWLDV2P0216 A_XLA_0[0] A_XLA_0[1] A_XLA_0[2] A_XLA_0[3] A_XLB_0[3] A_XLC_0[6]
+ B_XLA_0[0] B_XLA_0[1] B_XLA_0[2] B_XLA_0[3] B_XLB_0[3] B_XLC_0[6] A_WL[216]
+ A_WL[217] A_WL[218] A_WL[219] B_WL[216] B_WL[217] B_WL[218] B_WL[219]
+  SDL400W20S_NWLDV2P
XWLDV2P0220 A_XLA_0[4] A_XLA_0[5] A_XLA_0[6] A_XLA_0[7] A_XLB_0[3] A_XLC_0[6]
+ B_XLA_0[4] B_XLA_0[5] B_XLA_0[6] B_XLA_0[7] B_XLB_0[3] B_XLC_0[6] A_WL[220]
+ A_WL[221] A_WL[222] A_WL[223] B_WL[220] B_WL[221] B_WL[222] B_WL[223]
+  SDL400W20S_NWLDV2P
XWLDV2P0224 A_XLA_0[0] A_XLA_0[1] A_XLA_0[2] A_XLA_0[3] A_XLB_0[0] A_XLC_0[7]
+ B_XLA_0[0] B_XLA_0[1] B_XLA_0[2] B_XLA_0[3] B_XLB_0[0] B_XLC_0[7] A_WL[224]
+ A_WL[225] A_WL[226] A_WL[227] B_WL[224] B_WL[225] B_WL[226] B_WL[227]
+  SDL400W20S_NWLDV2P
XWLDV2P0228 A_XLA_0[4] A_XLA_0[5] A_XLA_0[6] A_XLA_0[7] A_XLB_0[0] A_XLC_0[7]
+ B_XLA_0[4] B_XLA_0[5] B_XLA_0[6] B_XLA_0[7] B_XLB_0[0] B_XLC_0[7] A_WL[228]
+ A_WL[229] A_WL[230] A_WL[231] B_WL[228] B_WL[229] B_WL[230] B_WL[231]
+  SDL400W20S_NWLDV2P
XWLDV2P0232 A_XLA_0[0] A_XLA_0[1] A_XLA_0[2] A_XLA_0[3] A_XLB_0[1] A_XLC_0[7]
+ B_XLA_0[0] B_XLA_0[1] B_XLA_0[2] B_XLA_0[3] B_XLB_0[1] B_XLC_0[7] A_WL[232]
+ A_WL[233] A_WL[234] A_WL[235] B_WL[232] B_WL[233] B_WL[234] B_WL[235]
+  SDL400W20S_NWLDV2P
XWLDV2P0236 A_XLA_0[4] A_XLA_0[5] A_XLA_0[6] A_XLA_0[7] A_XLB_0[1] A_XLC_0[7]
+ B_XLA_0[4] B_XLA_0[5] B_XLA_0[6] B_XLA_0[7] B_XLB_0[1] B_XLC_0[7] A_WL[236]
+ A_WL[237] A_WL[238] A_WL[239] B_WL[236] B_WL[237] B_WL[238] B_WL[239]
+  SDL400W20S_NWLDV2P
XWLDV2P0240 A_XLA_0[0] A_XLA_0[1] A_XLA_0[2] A_XLA_0[3] A_XLB_0[2] A_XLC_0[7]
+ B_XLA_0[0] B_XLA_0[1] B_XLA_0[2] B_XLA_0[3] B_XLB_0[2] B_XLC_0[7] A_WL[240]
+ A_WL[241] A_WL[242] A_WL[243] B_WL[240] B_WL[241] B_WL[242] B_WL[243]
+  SDL400W20S_NWLDV2P
XWLDV2P0244 A_XLA_0[4] A_XLA_0[5] A_XLA_0[6] A_XLA_0[7] A_XLB_0[2] A_XLC_0[7]
+ B_XLA_0[4] B_XLA_0[5] B_XLA_0[6] B_XLA_0[7] B_XLB_0[2] B_XLC_0[7] A_WL[244]
+ A_WL[245] A_WL[246] A_WL[247] B_WL[244] B_WL[245] B_WL[246] B_WL[247]
+  SDL400W20S_NWLDV2P
XWLDV2P0248 A_XLA_0[0] A_XLA_0[1] A_XLA_0[2] A_XLA_0[3] A_XLB_0[3] A_XLC_0[7]
+ B_XLA_0[0] B_XLA_0[1] B_XLA_0[2] B_XLA_0[3] B_XLB_0[3] B_XLC_0[7] A_WL[248]
+ A_WL[249] A_WL[250] A_WL[251] B_WL[248] B_WL[249] B_WL[250] B_WL[251]
+  SDL400W20S_NWLDV2P
XWLDV2P0252 A_XLA_0[4] A_XLA_0[5] A_XLA_0[6] A_XLA_0[7] A_XLB_0[3] A_XLC_0[7]
+ B_XLA_0[4] B_XLA_0[5] B_XLA_0[6] B_XLA_0[7] B_XLB_0[3] B_XLC_0[7] A_WL[252]
+ A_WL[253] A_WL[254] A_WL[255] B_WL[252] B_WL[253] B_WL[254] B_WL[255]
+  SDL400W20S_NWLDV2P
.ENDS

.SUBCKT SDL400W20S_NDMEMSLC A_WL[0] A_WL[1] A_WL[2] A_WL[3] A_WL[4] A_WL[5]
+ A_WL[6] A_WL[7] A_WL[8] A_WL[9] A_WL[10] A_WL[11] A_WL[12] A_WL[13] A_WL[14]
+ A_WL[15] A_WL[16] A_WL[17] A_WL[18] A_WL[19] A_WL[20] A_WL[21] A_WL[22]
+ A_WL[23] A_WL[24] A_WL[25] A_WL[26] A_WL[27] A_WL[28] A_WL[29] A_WL[30]
+ A_WL[31] A_WL[32] A_WL[33] A_WL[34] A_WL[35] A_WL[36] A_WL[37] A_WL[38]
+ A_WL[39] A_WL[40] A_WL[41] A_WL[42] A_WL[43] A_WL[44] A_WL[45] A_WL[46]
+ A_WL[47] A_WL[48] A_WL[49] A_WL[50] A_WL[51] A_WL[52] A_WL[53] A_WL[54]
+ A_WL[55] A_WL[56] A_WL[57] A_WL[58] A_WL[59] A_WL[60] A_WL[61] A_WL[62]
+ A_WL[63] A_WL[64] A_WL[65] A_WL[66] A_WL[67] A_WL[68] A_WL[69] A_WL[70]
+ A_WL[71] A_WL[72] A_WL[73] A_WL[74] A_WL[75] A_WL[76] A_WL[77] A_WL[78]
+ A_WL[79] A_WL[80] A_WL[81] A_WL[82] A_WL[83] A_WL[84] A_WL[85] A_WL[86]
+ A_WL[87] A_WL[88] A_WL[89] A_WL[90] A_WL[91] A_WL[92] A_WL[93] A_WL[94]
+ A_WL[95] A_WL[96] A_WL[97] A_WL[98] A_WL[99] A_WL[100] A_WL[101] A_WL[102]
+ A_WL[103] A_WL[104] A_WL[105] A_WL[106] A_WL[107] A_WL[108] A_WL[109]
+ A_WL[110] A_WL[111] A_WL[112] A_WL[113] A_WL[114] A_WL[115] A_WL[116]
+ A_WL[117] A_WL[118] A_WL[119] A_WL[120] A_WL[121] A_WL[122] A_WL[123]
+ A_WL[124] A_WL[125] A_WL[126] A_WL[127] A_WL[128] A_WL[129] A_WL[130]
+ A_WL[131] A_WL[132] A_WL[133] A_WL[134] A_WL[135] A_WL[136] A_WL[137]
+ A_WL[138] A_WL[139] A_WL[140] A_WL[141] A_WL[142] A_WL[143] A_WL[144]
+ A_WL[145] A_WL[146] A_WL[147] A_WL[148] A_WL[149] A_WL[150] A_WL[151]
+ A_WL[152] A_WL[153] A_WL[154] A_WL[155] A_WL[156] A_WL[157] A_WL[158]
+ A_WL[159] A_WL[160] A_WL[161] A_WL[162] A_WL[163] A_WL[164] A_WL[165]
+ A_WL[166] A_WL[167] A_WL[168] A_WL[169] A_WL[170] A_WL[171] A_WL[172]
+ A_WL[173] A_WL[174] A_WL[175] A_WL[176] A_WL[177] A_WL[178] A_WL[179]
+ A_WL[180] A_WL[181] A_WL[182] A_WL[183] A_WL[184] A_WL[185] A_WL[186]
+ A_WL[187] A_WL[188] A_WL[189] A_WL[190] A_WL[191] A_WL[192] A_WL[193]
+ A_WL[194] A_WL[195] A_WL[196] A_WL[197] A_WL[198] A_WL[199] A_WL[200]
+ A_WL[201] A_WL[202] A_WL[203] A_WL[204] A_WL[205] A_WL[206] A_WL[207]
+ A_WL[208] A_WL[209] A_WL[210] A_WL[211] A_WL[212] A_WL[213] A_WL[214]
+ A_WL[215] A_WL[216] A_WL[217] A_WL[218] A_WL[219] A_WL[220] A_WL[221]
+ A_WL[222] A_WL[223] A_WL[224] A_WL[225] A_WL[226] A_WL[227] A_WL[228]
+ A_WL[229] A_WL[230] A_WL[231] A_WL[232] A_WL[233] A_WL[234] A_WL[235]
+ A_WL[236] A_WL[237] A_WL[238] A_WL[239] A_WL[240] A_WL[241] A_WL[242]
+ A_WL[243] A_WL[244] A_WL[245] A_WL[246] A_WL[247] A_WL[248] A_WL[249]
+ A_WL[250] A_WL[251] A_WL[252] A_WL[253] A_WL[254] A_WL[255] B_WL[0] B_WL[1]
+ B_WL[2] B_WL[3] B_WL[4] B_WL[5] B_WL[6] B_WL[7] B_WL[8] B_WL[9] B_WL[10]
+ B_WL[11] B_WL[12] B_WL[13] B_WL[14] B_WL[15] B_WL[16] B_WL[17] B_WL[18]
+ B_WL[19] B_WL[20] B_WL[21] B_WL[22] B_WL[23] B_WL[24] B_WL[25] B_WL[26]
+ B_WL[27] B_WL[28] B_WL[29] B_WL[30] B_WL[31] B_WL[32] B_WL[33] B_WL[34]
+ B_WL[35] B_WL[36] B_WL[37] B_WL[38] B_WL[39] B_WL[40] B_WL[41] B_WL[42]
+ B_WL[43] B_WL[44] B_WL[45] B_WL[46] B_WL[47] B_WL[48] B_WL[49] B_WL[50]
+ B_WL[51] B_WL[52] B_WL[53] B_WL[54] B_WL[55] B_WL[56] B_WL[57] B_WL[58]
+ B_WL[59] B_WL[60] B_WL[61] B_WL[62] B_WL[63] B_WL[64] B_WL[65] B_WL[66]
+ B_WL[67] B_WL[68] B_WL[69] B_WL[70] B_WL[71] B_WL[72] B_WL[73] B_WL[74]
+ B_WL[75] B_WL[76] B_WL[77] B_WL[78] B_WL[79] B_WL[80] B_WL[81] B_WL[82]
+ B_WL[83] B_WL[84] B_WL[85] B_WL[86] B_WL[87] B_WL[88] B_WL[89] B_WL[90]
+ B_WL[91] B_WL[92] B_WL[93] B_WL[94] B_WL[95] B_WL[96] B_WL[97] B_WL[98]
+ B_WL[99] B_WL[100] B_WL[101] B_WL[102] B_WL[103] B_WL[104] B_WL[105]
+ B_WL[106] B_WL[107] B_WL[108] B_WL[109] B_WL[110] B_WL[111] B_WL[112]
+ B_WL[113] B_WL[114] B_WL[115] B_WL[116] B_WL[117] B_WL[118] B_WL[119]
+ B_WL[120] B_WL[121] B_WL[122] B_WL[123] B_WL[124] B_WL[125] B_WL[126]
+ B_WL[127] B_WL[128] B_WL[129] B_WL[130] B_WL[131] B_WL[132] B_WL[133]
+ B_WL[134] B_WL[135] B_WL[136] B_WL[137] B_WL[138] B_WL[139] B_WL[140]
+ B_WL[141] B_WL[142] B_WL[143] B_WL[144] B_WL[145] B_WL[146] B_WL[147]
+ B_WL[148] B_WL[149] B_WL[150] B_WL[151] B_WL[152] B_WL[153] B_WL[154]
+ B_WL[155] B_WL[156] B_WL[157] B_WL[158] B_WL[159] B_WL[160] B_WL[161]
+ B_WL[162] B_WL[163] B_WL[164] B_WL[165] B_WL[166] B_WL[167] B_WL[168]
+ B_WL[169] B_WL[170] B_WL[171] B_WL[172] B_WL[173] B_WL[174] B_WL[175]
+ B_WL[176] B_WL[177] B_WL[178] B_WL[179] B_WL[180] B_WL[181] B_WL[182]
+ B_WL[183] B_WL[184] B_WL[185] B_WL[186] B_WL[187] B_WL[188] B_WL[189]
+ B_WL[190] B_WL[191] B_WL[192] B_WL[193] B_WL[194] B_WL[195] B_WL[196]
+ B_WL[197] B_WL[198] B_WL[199] B_WL[200] B_WL[201] B_WL[202] B_WL[203]
+ B_WL[204] B_WL[205] B_WL[206] B_WL[207] B_WL[208] B_WL[209] B_WL[210]
+ B_WL[211] B_WL[212] B_WL[213] B_WL[214] B_WL[215] B_WL[216] B_WL[217]
+ B_WL[218] B_WL[219] B_WL[220] B_WL[221] B_WL[222] B_WL[223] B_WL[224]
+ B_WL[225] B_WL[226] B_WL[227] B_WL[228] B_WL[229] B_WL[230] B_WL[231]
+ B_WL[232] B_WL[233] B_WL[234] B_WL[235] B_WL[236] B_WL[237] B_WL[238]
+ B_WL[239] B_WL[240] B_WL[241] B_WL[242] B_WL[243] B_WL[244] B_WL[245]
+ B_WL[246] B_WL[247] B_WL[248] B_WL[249] B_WL[250] B_WL[251] B_WL[252]
+ B_WL[253] B_WL[254] B_WL[255] DBL VHI
XDMC00 A_WL[3] A_WL[2] A_WL[1] A_WL[0] B_WL[3] B_WL[2] B_WL[1] B_WL[0] VDD VSS
+ VHI DBL DBL VSS VDD SDL400W20S_NDMCBLX4G
XDMC04 A_WL[7] A_WL[6] A_WL[5] A_WL[4] B_WL[7] B_WL[6] B_WL[5] B_WL[4] VDD VSS
+ VHI DBL DBL VSS VDD SDL400W20S_NDMCBLX4G
XDMC08 A_WL[11] A_WL[10] A_WL[9] A_WL[8] B_WL[11] B_WL[10] B_WL[9] B_WL[8] VDD
+ VSS VHI DBL DBL VSS VDD SDL400W20S_NDMCBLX4G
XDMC012 A_WL[15] A_WL[14] A_WL[13] A_WL[12] B_WL[15] B_WL[14] B_WL[13]
+ B_WL[12] VDD VSS VHI DBL DBL VSS VDD SDL400W20S_NDMCBLX4G
XDMC016 A_WL[19] A_WL[18] A_WL[17] A_WL[16] B_WL[19] B_WL[18] B_WL[17]
+ B_WL[16] VDD VSS VHI DBL DBL VSS VDD SDL400W20S_NDMCBLX4G
XDMC020 A_WL[23] A_WL[22] A_WL[21] A_WL[20] B_WL[23] B_WL[22] B_WL[21]
+ B_WL[20] VDD VSS VHI DBL DBL VSS VDD SDL400W20S_NDMCBLX4G
XDMC024 A_WL[27] A_WL[26] A_WL[25] A_WL[24] B_WL[27] B_WL[26] B_WL[25]
+ B_WL[24] VDD VSS VHI DBL DBL VSS VDD SDL400W20S_NDMCBLX4G
XDMC028 A_WL[31] A_WL[30] A_WL[29] A_WL[28] B_WL[31] B_WL[30] B_WL[29]
+ B_WL[28] VDD VSS VHI DBL DBL VSS VDD SDL400W20S_NDMCBLX4G
XDMC032 A_WL[35] A_WL[34] A_WL[33] A_WL[32] B_WL[35] B_WL[34] B_WL[33]
+ B_WL[32] VDD VSS VHI DBL DBL VSS VDD SDL400W20S_NDMCBLX4G
XDMC036 A_WL[39] A_WL[38] A_WL[37] A_WL[36] B_WL[39] B_WL[38] B_WL[37]
+ B_WL[36] VDD VSS VHI DBL DBL VSS VDD SDL400W20S_NDMCBLX4G
XDMC040 A_WL[43] A_WL[42] A_WL[41] A_WL[40] B_WL[43] B_WL[42] B_WL[41]
+ B_WL[40] VDD VSS VHI DBL DBL VSS VDD SDL400W20S_NDMCBLX4G
XDMC044 A_WL[47] A_WL[46] A_WL[45] A_WL[44] B_WL[47] B_WL[46] B_WL[45]
+ B_WL[44] VDD VSS VHI DBL DBL VSS VDD SDL400W20S_NDMCBLX4G
XDMC048 A_WL[51] A_WL[50] A_WL[49] A_WL[48] B_WL[51] B_WL[50] B_WL[49]
+ B_WL[48] VDD VSS VHI DBL DBL VSS VDD SDL400W20S_NDMCBLX4G
XDMC052 A_WL[55] A_WL[54] A_WL[53] A_WL[52] B_WL[55] B_WL[54] B_WL[53]
+ B_WL[52] VDD VSS VHI DBL DBL VSS VDD SDL400W20S_NDMCBLX4G
XDMC056 A_WL[59] A_WL[58] A_WL[57] A_WL[56] B_WL[59] B_WL[58] B_WL[57]
+ B_WL[56] VDD VSS VHI DBL DBL VSS VDD SDL400W20S_NDMCBLX4G
XDMC060 A_WL[63] A_WL[62] A_WL[61] A_WL[60] B_WL[63] B_WL[62] B_WL[61]
+ B_WL[60] VDD VSS VHI DBL DBL VSS VDD SDL400W20S_NDMCBLX4G
XDMC064 A_WL[67] A_WL[66] A_WL[65] A_WL[64] B_WL[67] B_WL[66] B_WL[65]
+ B_WL[64] VDD VSS VHI DBL DBL VSS VDD SDL400W20S_NDMCBLX4G
XDMC068 A_WL[71] A_WL[70] A_WL[69] A_WL[68] B_WL[71] B_WL[70] B_WL[69]
+ B_WL[68] VDD VSS VHI DBL DBL VSS VDD SDL400W20S_NDMCBLX4G
XDMC072 A_WL[75] A_WL[74] A_WL[73] A_WL[72] B_WL[75] B_WL[74] B_WL[73]
+ B_WL[72] VDD VSS VHI DBL DBL VSS VDD SDL400W20S_NDMCBLX4G
XDMC076 A_WL[79] A_WL[78] A_WL[77] A_WL[76] B_WL[79] B_WL[78] B_WL[77]
+ B_WL[76] VDD VSS VHI DBL DBL VSS VDD SDL400W20S_NDMCBLX4G
XDMC080 A_WL[83] A_WL[82] A_WL[81] A_WL[80] B_WL[83] B_WL[82] B_WL[81]
+ B_WL[80] VDD VSS VHI DBL DBL VSS VDD SDL400W20S_NDMCBLX4G
XDMC084 A_WL[87] A_WL[86] A_WL[85] A_WL[84] B_WL[87] B_WL[86] B_WL[85]
+ B_WL[84] VDD VSS VHI DBL DBL VSS VDD SDL400W20S_NDMCBLX4G
XDMC088 A_WL[91] A_WL[90] A_WL[89] A_WL[88] B_WL[91] B_WL[90] B_WL[89]
+ B_WL[88] VDD VSS VHI DBL DBL VSS VDD SDL400W20S_NDMCBLX4G
XDMC092 A_WL[95] A_WL[94] A_WL[93] A_WL[92] B_WL[95] B_WL[94] B_WL[93]
+ B_WL[92] VDD VSS VHI DBL DBL VSS VDD SDL400W20S_NDMCBLX4G
XDMC096 A_WL[99] A_WL[98] A_WL[97] A_WL[96] B_WL[99] B_WL[98] B_WL[97]
+ B_WL[96] VDD VSS VHI DBL DBL VSS VDD SDL400W20S_NDMCBLX4G
XDMC0100 A_WL[103] A_WL[102] A_WL[101] A_WL[100] B_WL[103] B_WL[102] B_WL[101]
+ B_WL[100] VDD VSS VHI DBL DBL VSS VDD SDL400W20S_NDMCBLX4G
XDMC0104 A_WL[107] A_WL[106] A_WL[105] A_WL[104] B_WL[107] B_WL[106] B_WL[105]
+ B_WL[104] VDD VSS VHI DBL DBL VSS VDD SDL400W20S_NDMCBLX4G
XDMC0108 A_WL[111] A_WL[110] A_WL[109] A_WL[108] B_WL[111] B_WL[110] B_WL[109]
+ B_WL[108] VDD VSS VHI DBL DBL VSS VDD SDL400W20S_NDMCBLX4G
XDMC0112 A_WL[115] A_WL[114] A_WL[113] A_WL[112] B_WL[115] B_WL[114] B_WL[113]
+ B_WL[112] VDD VSS VHI DBL DBL VSS VDD SDL400W20S_NDMCBLX4G
XDMC0116 A_WL[119] A_WL[118] A_WL[117] A_WL[116] B_WL[119] B_WL[118] B_WL[117]
+ B_WL[116] VDD VSS VHI DBL DBL VSS VDD SDL400W20S_NDMCBLX4G
XDMC0120 A_WL[123] A_WL[122] A_WL[121] A_WL[120] B_WL[123] B_WL[122] B_WL[121]
+ B_WL[120] VDD VSS VHI DBL DBL VSS VDD SDL400W20S_NDMCBLX4G
XDMC0124 A_WL[127] A_WL[126] A_WL[125] A_WL[124] B_WL[127] B_WL[126] B_WL[125]
+ B_WL[124] VDD VSS VHI DBL DBL VSS VDD SDL400W20S_NDMCBLX4G
XDMC0128 A_WL[131] A_WL[130] A_WL[129] A_WL[128] B_WL[131] B_WL[130] B_WL[129]
+ B_WL[128] VDD VSS VHI DBL DBL VSS VDD SDL400W20S_NDMCBLX4G
XDMC0132 A_WL[135] A_WL[134] A_WL[133] A_WL[132] B_WL[135] B_WL[134] B_WL[133]
+ B_WL[132] VDD VSS VHI DBL DBL VSS VDD SDL400W20S_NDMCBLX4G
XDMC0136 A_WL[139] A_WL[138] A_WL[137] A_WL[136] B_WL[139] B_WL[138] B_WL[137]
+ B_WL[136] VDD VSS VHI DBL DBL VSS VDD SDL400W20S_NDMCBLX4G
XDMC0140 A_WL[143] A_WL[142] A_WL[141] A_WL[140] B_WL[143] B_WL[142] B_WL[141]
+ B_WL[140] VDD VSS VHI DBL DBL VSS VDD SDL400W20S_NDMCBLX4G
XDMC0144 A_WL[147] A_WL[146] A_WL[145] A_WL[144] B_WL[147] B_WL[146] B_WL[145]
+ B_WL[144] VDD VSS VHI DBL DBL VSS VDD SDL400W20S_NDMCBLX4G
XDMC0148 A_WL[151] A_WL[150] A_WL[149] A_WL[148] B_WL[151] B_WL[150] B_WL[149]
+ B_WL[148] VDD VSS VHI DBL DBL VSS VDD SDL400W20S_NDMCBLX4G
XDMC0152 A_WL[155] A_WL[154] A_WL[153] A_WL[152] B_WL[155] B_WL[154] B_WL[153]
+ B_WL[152] VDD VSS VHI DBL DBL VSS VDD SDL400W20S_NDMCBLX4G
XDMC0156 A_WL[159] A_WL[158] A_WL[157] A_WL[156] B_WL[159] B_WL[158] B_WL[157]
+ B_WL[156] VDD VSS VHI DBL DBL VSS VDD SDL400W20S_NDMCBLX4G
XDMC0160 A_WL[163] A_WL[162] A_WL[161] A_WL[160] B_WL[163] B_WL[162] B_WL[161]
+ B_WL[160] VDD VSS VHI DBL DBL VSS VDD SDL400W20S_NDMCBLX4G
XDMC0164 A_WL[167] A_WL[166] A_WL[165] A_WL[164] B_WL[167] B_WL[166] B_WL[165]
+ B_WL[164] VDD VSS VHI DBL DBL VSS VDD SDL400W20S_NDMCBLX4G
XDMC0168 A_WL[171] A_WL[170] A_WL[169] A_WL[168] B_WL[171] B_WL[170] B_WL[169]
+ B_WL[168] VDD VSS VHI DBL DBL VSS VDD SDL400W20S_NDMCBLX4G
XDMC0172 A_WL[175] A_WL[174] A_WL[173] A_WL[172] B_WL[175] B_WL[174] B_WL[173]
+ B_WL[172] VDD VSS VHI DBL DBL VSS VDD SDL400W20S_NDMCBLX4G
XDMC0176 A_WL[179] A_WL[178] A_WL[177] A_WL[176] B_WL[179] B_WL[178] B_WL[177]
+ B_WL[176] VDD VSS VHI DBL DBL VSS VDD SDL400W20S_NDMCBLX4G
XDMC0180 A_WL[183] A_WL[182] A_WL[181] A_WL[180] B_WL[183] B_WL[182] B_WL[181]
+ B_WL[180] VDD VSS VHI DBL DBL VSS VDD SDL400W20S_NDMCBLX4G
XDMC0184 A_WL[187] A_WL[186] A_WL[185] A_WL[184] B_WL[187] B_WL[186] B_WL[185]
+ B_WL[184] VDD VSS VHI DBL DBL VSS VDD SDL400W20S_NDMCBLX4G
XDMC0188 A_WL[191] A_WL[190] A_WL[189] A_WL[188] B_WL[191] B_WL[190] B_WL[189]
+ B_WL[188] VDD VSS VHI DBL DBL VSS VDD SDL400W20S_NDMCBLX4G
XDMC0192 A_WL[195] A_WL[194] A_WL[193] A_WL[192] B_WL[195] B_WL[194] B_WL[193]
+ B_WL[192] VDD VSS VHI DBL DBL VSS VDD SDL400W20S_NDMCBLX4G
XDMC0196 A_WL[199] A_WL[198] A_WL[197] A_WL[196] B_WL[199] B_WL[198] B_WL[197]
+ B_WL[196] VDD VSS VHI DBL DBL VSS VDD SDL400W20S_NDMCBLX4G
XDMC0200 A_WL[203] A_WL[202] A_WL[201] A_WL[200] B_WL[203] B_WL[202] B_WL[201]
+ B_WL[200] VDD VSS VHI DBL DBL VSS VDD SDL400W20S_NDMCBLX4G
XDMC0204 A_WL[207] A_WL[206] A_WL[205] A_WL[204] B_WL[207] B_WL[206] B_WL[205]
+ B_WL[204] VDD VSS VHI DBL DBL VSS VDD SDL400W20S_NDMCBLX4G
XDMC0208 A_WL[211] A_WL[210] A_WL[209] A_WL[208] B_WL[211] B_WL[210] B_WL[209]
+ B_WL[208] VDD VSS VHI DBL DBL VSS VDD SDL400W20S_NDMCBLX4G
XDMC0212 A_WL[215] A_WL[214] A_WL[213] A_WL[212] B_WL[215] B_WL[214] B_WL[213]
+ B_WL[212] VDD VSS VHI DBL DBL VSS VDD SDL400W20S_NDMCBLX4G
XDMC0216 A_WL[219] A_WL[218] A_WL[217] A_WL[216] B_WL[219] B_WL[218] B_WL[217]
+ B_WL[216] VDD VSS VHI DBL DBL VSS VDD SDL400W20S_NDMCBLX4G
XDMC0220 A_WL[223] A_WL[222] A_WL[221] A_WL[220] B_WL[223] B_WL[222] B_WL[221]
+ B_WL[220] VDD VSS VHI DBL DBL VSS VDD SDL400W20S_NDMCBLX4G
XDMC0224 A_WL[227] A_WL[226] A_WL[225] A_WL[224] B_WL[227] B_WL[226] B_WL[225]
+ B_WL[224] VDD VSS VHI DBL DBL VSS VDD SDL400W20S_NDMCBLX4G
XDMC0228 A_WL[231] A_WL[230] A_WL[229] A_WL[228] B_WL[231] B_WL[230] B_WL[229]
+ B_WL[228] VDD VSS VHI DBL DBL VSS VDD SDL400W20S_NDMCBLX4G
XDMC0232 A_WL[235] A_WL[234] A_WL[233] A_WL[232] B_WL[235] B_WL[234] B_WL[233]
+ B_WL[232] VDD VSS VHI DBL DBL VSS VDD SDL400W20S_NDMCBLX4G
XDMC0236 A_WL[239] A_WL[238] A_WL[237] A_WL[236] B_WL[239] B_WL[238] B_WL[237]
+ B_WL[236] VDD VSS VHI DBL DBL VSS VDD SDL400W20S_NDMCBLX4G
XDMC0240 A_WL[243] A_WL[242] A_WL[241] A_WL[240] B_WL[243] B_WL[242] B_WL[241]
+ B_WL[240] VDD VSS VHI DBL DBL VSS VDD SDL400W20S_NDMCBLX4G
XDMC0244 A_WL[247] A_WL[246] A_WL[245] A_WL[244] B_WL[247] B_WL[246] B_WL[245]
+ B_WL[244] VDD VSS VHI DBL DBL VSS VDD SDL400W20S_NDMCBLX4G
XDMC0248 A_WL[251] A_WL[250] A_WL[249] A_WL[248] B_WL[251] B_WL[250] B_WL[249]
+ B_WL[248] VDD VSS VHI DBL DBL VSS VDD SDL400W20S_NDMCBLX4G
XDMC0252 A_WL[255] A_WL[254] A_WL[253] A_WL[252] B_WL[255] B_WL[254] B_WL[253]
+ B_WL[252] VDD VSS VHI DBL DBL VSS VDD SDL400W20S_NDMCBLX4G
.ENDS

.SUBCKT SDL400W20S_NDWLGRPA A_DWL VHI
XDMCWL0 A_DWL A_DWL VHI VSS VSS VSS VSS VSS VSS VSS VSS SDL400W20S_DMCWLN
XDMCWL1 A_DWL A_DWL VHI VSS VSS VSS VSS VSS VSS VSS VSS SDL400W20S_DMCWL
XDMCWL2 A_DWL A_DWL VHI VSS VSS VSS VSS VSS VSS VSS VSS SDL400W20S_DMCWL
XDMCWL3 A_DWL A_DWL VHI VSS VSS VSS VSS VSS VSS VSS VSS SDL400W20S_DMCWL
XDMCWL4 A_DWL A_DWL VHI VSS VSS VSS VSS VSS VSS VSS VSS SDL400W20S_DMCWL
XDMCWL5 A_DWL A_DWL VHI VSS VSS VSS VSS VSS VSS VSS VSS SDL400W20S_DMCWL
XDMCWL6 A_DWL A_DWL VHI VSS VSS VSS VSS VSS VSS VSS VSS SDL400W20S_DMCWL
XDMCWL7 A_DWL A_DWL VHI VSS VSS VSS VSS VSS VSS VSS VSS SDL400W20S_DMCWL
.ENDS

.SUBCKT SDL400W20S_NDWLGRPB B_DWL VHI
XDMCWL0 B_DWL B_DWL VHI VSS VSS VSS VSS VSS VSS VSS VSS SDL400W20S_DMCWLN
XDMCWL1 B_DWL B_DWL VHI VSS VSS VSS VSS VSS VSS VSS VSS SDL400W20S_DMCWL
XDMCWL2 B_DWL B_DWL VHI VSS VSS VSS VSS VSS VSS VSS VSS SDL400W20S_DMCWL
XDMCWL3 B_DWL B_DWL VHI VSS VSS VSS VSS VSS VSS VSS VSS SDL400W20S_DMCWL
XDMCWL4 B_DWL B_DWL VHI VSS VSS VSS VSS VSS VSS VSS VSS SDL400W20S_DMCWL
XDMCWL5 B_DWL B_DWL VHI VSS VSS VSS VSS VSS VSS VSS VSS SDL400W20S_DMCWL
XDMCWL6 B_DWL B_DWL VHI VSS VSS VSS VSS VSS VSS VSS VSS SDL400W20S_DMCWL
XDMCWL7 B_DWL B_DWL VHI VSS VSS VSS VSS VSS VSS VSS VSS SDL400W20S_DMCWL
.ENDS

.SUBCKT SDL400W20S_NARRAY AA[15] AA[14] AA[13] AA[12] AA[11] AA[10] AA[9]
+ AA[8] AA[7] AA[6] AA[5] AA[4] AA[3] AA[2] AA[1] AA[0] DA[31] DA[30] DA[29]
+ DA[28] DA[27] DA[26] DA[25] DA[24] DA[23] DA[22] DA[21] DA[20] DA[19] DA[18]
+ DA[17] DA[16] DA[15] DA[14] DA[13] DA[12] DA[11] DA[10] DA[9] DA[8] DA[7]
+ DA[6] DA[5] DA[4] DA[3] DA[2] DA[1] DA[0] BWEBA[31] BWEBA[30] BWEBA[29]
+ BWEBA[28] BWEBA[27] BWEBA[26] BWEBA[25] BWEBA[24] BWEBA[23] BWEBA[22]
+ BWEBA[21] BWEBA[20] BWEBA[19] BWEBA[18] BWEBA[17] BWEBA[16] BWEBA[15]
+ BWEBA[14] BWEBA[13] BWEBA[12] BWEBA[11] BWEBA[10] BWEBA[9] BWEBA[8] BWEBA[7]
+ BWEBA[6] BWEBA[5] BWEBA[4] BWEBA[3] BWEBA[2] BWEBA[1] BWEBA[0] WEBA CEBA CLKA
+ AB[15] AB[14] AB[13] AB[12] AB[11] AB[10] AB[9] AB[8] AB[7] AB[6] AB[5] AB[4]
+ AB[3] AB[2] AB[1] AB[0] DB[31] DB[30] DB[29] DB[28] DB[27] DB[26] DB[25]
+ DB[24] DB[23] DB[22] DB[21] DB[20] DB[19] DB[18] DB[17] DB[16] DB[15] DB[14]
+ DB[13] DB[12] DB[11] DB[10] DB[9] DB[8] DB[7] DB[6] DB[5] DB[4] DB[3] DB[2]
+ DB[1] DB[0] BWEBB[31] BWEBB[30] BWEBB[29] BWEBB[28] BWEBB[27] BWEBB[26]
+ BWEBB[25] BWEBB[24] BWEBB[23] BWEBB[22] BWEBB[21] BWEBB[20] BWEBB[19]
+ BWEBB[18] BWEBB[17] BWEBB[16] BWEBB[15] BWEBB[14] BWEBB[13] BWEBB[12]
+ BWEBB[11] BWEBB[10] BWEBB[9] BWEBB[8] BWEBB[7] BWEBB[6] BWEBB[5] BWEBB[4]
+ BWEBB[3] BWEBB[2] BWEBB[1] BWEBB[0] WEBB CEBB CLKB AMA[15] AMA[14] AMA[13]
+ AMA[12] AMA[11] AMA[10] AMA[9] AMA[8] AMA[7] AMA[6] AMA[5] AMA[4] AMA[3]
+ AMA[2] AMA[1] AMA[0] DMA[31] DMA[30] DMA[29] DMA[28] DMA[27] DMA[26] DMA[25]
+ DMA[24] DMA[23] DMA[22] DMA[21] DMA[20] DMA[19] DMA[18] DMA[17] DMA[16]
+ DMA[15] DMA[14] DMA[13] DMA[12] DMA[11] DMA[10] DMA[9] DMA[8] DMA[7] DMA[6]
+ DMA[5] DMA[4] DMA[3] DMA[2] DMA[1] DMA[0] BWEBMA[31] BWEBMA[30] BWEBMA[29]
+ BWEBMA[28] BWEBMA[27] BWEBMA[26] BWEBMA[25] BWEBMA[24] BWEBMA[23] BWEBMA[22]
+ BWEBMA[21] BWEBMA[20] BWEBMA[19] BWEBMA[18] BWEBMA[17] BWEBMA[16] BWEBMA[15]
+ BWEBMA[14] BWEBMA[13] BWEBMA[12] BWEBMA[11] BWEBMA[10] BWEBMA[9] BWEBMA[8]
+ BWEBMA[7] BWEBMA[6] BWEBMA[5] BWEBMA[4] BWEBMA[3] BWEBMA[2] BWEBMA[1]
+ BWEBMA[0] WEBMA CEBMA AMB[15] AMB[14] AMB[13] AMB[12] AMB[11] AMB[10] AMB[9]
+ AMB[8] AMB[7] AMB[6] AMB[5] AMB[4] AMB[3] AMB[2] AMB[1] AMB[0] DMB[31]
+ DMB[30] DMB[29] DMB[28] DMB[27] DMB[26] DMB[25] DMB[24] DMB[23] DMB[22]
+ DMB[21] DMB[20] DMB[19] DMB[18] DMB[17] DMB[16] DMB[15] DMB[14] DMB[13]
+ DMB[12] DMB[11] DMB[10] DMB[9] DMB[8] DMB[7] DMB[6] DMB[5] DMB[4] DMB[3]
+ DMB[2] DMB[1] DMB[0] BWEBMB[31] BWEBMB[30] BWEBMB[29] BWEBMB[28] BWEBMB[27]
+ BWEBMB[26] BWEBMB[25] BWEBMB[24] BWEBMB[23] BWEBMB[22] BWEBMB[21] BWEBMB[20]
+ BWEBMB[19] BWEBMB[18] BWEBMB[17] BWEBMB[16] BWEBMB[15] BWEBMB[14] BWEBMB[13]
+ BWEBMB[12] BWEBMB[11] BWEBMB[10] BWEBMB[9] BWEBMB[8] BWEBMB[7] BWEBMB[6]
+ BWEBMB[5] BWEBMB[4] BWEBMB[3] BWEBMB[2] BWEBMB[1] BWEBMB[0] WEBMB CEBMB AWT
+ BIST CLKM TM VB[2] VB[1] VB[0] VD[1] VD[0] VR[1] VR[0] VS[1] VS[0] VW[1]
+ VW[0] QA[31] QA[30] QA[29] QA[28] QA[27] QA[26] QA[25] QA[24] QA[23] QA[22]
+ QA[21] QA[20] QA[19] QA[18] QA[17] QA[16] QA[15] QA[14] QA[13] QA[12] QA[11]
+ QA[10] QA[9] QA[8] QA[7] QA[6] QA[5] QA[4] QA[3] QA[2] QA[1] QA[0] QB[31]
+ QB[30] QB[29] QB[28] QB[27] QB[26] QB[25] QB[24] QB[23] QB[22] QB[21] QB[20]
+ QB[19] QB[18] QB[17] QB[16] QB[15] QB[14] QB[13] QB[12] QB[11] QB[10] QB[9]
+ QB[8] QB[7] QB[6] QB[5] QB[4] QB[3] QB[2] QB[1] QB[0] VHI VLO
XCTRL2P AA[15] AA[14] AA[13] AA[12] AA[11] AA[10] AA[9] AA[8] AA[7] AA[6]
+ AA[5] AA[4] AA[3] AA[2] AA[1] AA[0] AB[15] AB[14] AB[13] AB[12] AB[11] AB[10]
+ AB[9] AB[8] AB[7] AB[6] AB[5] AB[4] AB[3] AB[2] AB[1] AB[0] AMA[15] AMA[14]
+ AMA[13] AMA[12] AMA[11] AMA[10] AMA[9] AMA[8] AMA[7] AMA[6] AMA[5] AMA[4]
+ AMA[3] AMA[2] AMA[1] AMA[0] AMB[15] AMB[14] AMB[13] AMB[12] AMB[11] AMB[10]
+ AMB[9] AMB[8] AMB[7] AMB[6] AMB[5] AMB[4] AMB[3] AMB[2] AMB[1] AMB[0] AWT
+ A_DWL BIST B_DWL CEBA CEBB CEBMA CEBMB CLKA CLKB CLKM TM VB[2] VB[1] VB[0]
+ VD[1] VD[0] VR[1] VR[0] VS[1] VS[0] VW[1] VW[0] WEBA WEBB WEBMA WEBMB A_CKD
+ A_DLRS A_DWL A_GCDEC[3] A_GCDEC[2] A_GCDEC[1] A_GCDEC[0] A_RD A_WENB[3]
+ A_WENB[2] A_WENB[1] A_WENB[0] A_WRT A_XA[7] A_XA[6] A_XA[5] A_XA[4] A_XA[3]
+ A_XA[2] A_XA[1] A_XA[0] A_XB[3] A_XB[2] A_XB[1] A_XB[0] A_XC[7] A_XC[6]
+ A_XC[5] A_XC[4] A_XC[3] A_XC[2] A_XC[1] A_XC[0] A_Y[7] A_Y[6] A_Y[5] A_Y[4]
+ A_Y[3] A_Y[2] A_Y[1] A_Y[0] A_Z[7] A_Z[6] A_Z[5] A_Z[4] A_Z[3] A_Z[2] A_Z[1]
+ A_Z[0] B_CKD B_DLRS B_DWL B_GCDEC[3] B_GCDEC[2] B_GCDEC[1] B_GCDEC[0] B_RD
+ B_WENB[3] B_WENB[2] B_WENB[1] B_WENB[0] B_WRT B_XA[7] B_XA[6] B_XA[5] B_XA[4]
+ B_XA[3] B_XA[2] B_XA[1] B_XA[0] B_XB[3] B_XB[2] B_XB[1] B_XB[0] B_XC[7]
+ B_XC[6] B_XC[5] B_XC[4] B_XC[3] B_XC[2] B_XC[1] B_XC[0] B_Y[7] B_Y[6] B_Y[5]
+ B_Y[4] B_Y[3] B_Y[2] B_Y[1] B_Y[0] B_Z[7] B_Z[6] B_Z[5] B_Z[4] B_Z[3] B_Z[2]
+ B_Z[1] B_Z[0] AWTI A_DBL BISTC BISTT B_DBL VHI VLO SDL400W20S_NCTRL2P
XDMEMSLCA A_WL[0] A_WL[1] A_WL[2] A_WL[3] A_WL[4] A_WL[5] A_WL[6] A_WL[7]
+ A_WL[8] A_WL[9] A_WL[10] A_WL[11] A_WL[12] A_WL[13] A_WL[14] A_WL[15]
+ A_WL[16] A_WL[17] A_WL[18] A_WL[19] A_WL[20] A_WL[21] A_WL[22] A_WL[23]
+ A_WL[24] A_WL[25] A_WL[26] A_WL[27] A_WL[28] A_WL[29] A_WL[30] A_WL[31]
+ A_WL[32] A_WL[33] A_WL[34] A_WL[35] A_WL[36] A_WL[37] A_WL[38] A_WL[39]
+ A_WL[40] A_WL[41] A_WL[42] A_WL[43] A_WL[44] A_WL[45] A_WL[46] A_WL[47]
+ A_WL[48] A_WL[49] A_WL[50] A_WL[51] A_WL[52] A_WL[53] A_WL[54] A_WL[55]
+ A_WL[56] A_WL[57] A_WL[58] A_WL[59] A_WL[60] A_WL[61] A_WL[62] A_WL[63]
+ A_WL[64] A_WL[65] A_WL[66] A_WL[67] A_WL[68] A_WL[69] A_WL[70] A_WL[71]
+ A_WL[72] A_WL[73] A_WL[74] A_WL[75] A_WL[76] A_WL[77] A_WL[78] A_WL[79]
+ A_WL[80] A_WL[81] A_WL[82] A_WL[83] A_WL[84] A_WL[85] A_WL[86] A_WL[87]
+ A_WL[88] A_WL[89] A_WL[90] A_WL[91] A_WL[92] A_WL[93] A_WL[94] A_WL[95]
+ A_WL[96] A_WL[97] A_WL[98] A_WL[99] A_WL[100] A_WL[101] A_WL[102] A_WL[103]
+ A_WL[104] A_WL[105] A_WL[106] A_WL[107] A_WL[108] A_WL[109] A_WL[110]
+ A_WL[111] A_WL[112] A_WL[113] A_WL[114] A_WL[115] A_WL[116] A_WL[117]
+ A_WL[118] A_WL[119] A_WL[120] A_WL[121] A_WL[122] A_WL[123] A_WL[124]
+ A_WL[125] A_WL[126] A_WL[127] A_WL[128] A_WL[129] A_WL[130] A_WL[131]
+ A_WL[132] A_WL[133] A_WL[134] A_WL[135] A_WL[136] A_WL[137] A_WL[138]
+ A_WL[139] A_WL[140] A_WL[141] A_WL[142] A_WL[143] A_WL[144] A_WL[145]
+ A_WL[146] A_WL[147] A_WL[148] A_WL[149] A_WL[150] A_WL[151] A_WL[152]
+ A_WL[153] A_WL[154] A_WL[155] A_WL[156] A_WL[157] A_WL[158] A_WL[159]
+ A_WL[160] A_WL[161] A_WL[162] A_WL[163] A_WL[164] A_WL[165] A_WL[166]
+ A_WL[167] A_WL[168] A_WL[169] A_WL[170] A_WL[171] A_WL[172] A_WL[173]
+ A_WL[174] A_WL[175] A_WL[176] A_WL[177] A_WL[178] A_WL[179] A_WL[180]
+ A_WL[181] A_WL[182] A_WL[183] A_WL[184] A_WL[185] A_WL[186] A_WL[187]
+ A_WL[188] A_WL[189] A_WL[190] A_WL[191] A_WL[192] A_WL[193] A_WL[194]
+ A_WL[195] A_WL[196] A_WL[197] A_WL[198] A_WL[199] A_WL[200] A_WL[201]
+ A_WL[202] A_WL[203] A_WL[204] A_WL[205] A_WL[206] A_WL[207] A_WL[208]
+ A_WL[209] A_WL[210] A_WL[211] A_WL[212] A_WL[213] A_WL[214] A_WL[215]
+ A_WL[216] A_WL[217] A_WL[218] A_WL[219] A_WL[220] A_WL[221] A_WL[222]
+ A_WL[223] A_WL[224] A_WL[225] A_WL[226] A_WL[227] A_WL[228] A_WL[229]
+ A_WL[230] A_WL[231] A_WL[232] A_WL[233] A_WL[234] A_WL[235] A_WL[236]
+ A_WL[237] A_WL[238] A_WL[239] A_WL[240] A_WL[241] A_WL[242] A_WL[243]
+ A_WL[244] A_WL[245] A_WL[246] A_WL[247] A_WL[248] A_WL[249] A_WL[250]
+ A_WL[251] A_WL[252] A_WL[253] A_WL[254] A_WL[255] B_WL[0] B_WL[1] B_WL[2]
+ B_WL[3] B_WL[4] B_WL[5] B_WL[6] B_WL[7] B_WL[8] B_WL[9] B_WL[10] B_WL[11]
+ B_WL[12] B_WL[13] B_WL[14] B_WL[15] B_WL[16] B_WL[17] B_WL[18] B_WL[19]
+ B_WL[20] B_WL[21] B_WL[22] B_WL[23] B_WL[24] B_WL[25] B_WL[26] B_WL[27]
+ B_WL[28] B_WL[29] B_WL[30] B_WL[31] B_WL[32] B_WL[33] B_WL[34] B_WL[35]
+ B_WL[36] B_WL[37] B_WL[38] B_WL[39] B_WL[40] B_WL[41] B_WL[42] B_WL[43]
+ B_WL[44] B_WL[45] B_WL[46] B_WL[47] B_WL[48] B_WL[49] B_WL[50] B_WL[51]
+ B_WL[52] B_WL[53] B_WL[54] B_WL[55] B_WL[56] B_WL[57] B_WL[58] B_WL[59]
+ B_WL[60] B_WL[61] B_WL[62] B_WL[63] B_WL[64] B_WL[65] B_WL[66] B_WL[67]
+ B_WL[68] B_WL[69] B_WL[70] B_WL[71] B_WL[72] B_WL[73] B_WL[74] B_WL[75]
+ B_WL[76] B_WL[77] B_WL[78] B_WL[79] B_WL[80] B_WL[81] B_WL[82] B_WL[83]
+ B_WL[84] B_WL[85] B_WL[86] B_WL[87] B_WL[88] B_WL[89] B_WL[90] B_WL[91]
+ B_WL[92] B_WL[93] B_WL[94] B_WL[95] B_WL[96] B_WL[97] B_WL[98] B_WL[99]
+ B_WL[100] B_WL[101] B_WL[102] B_WL[103] B_WL[104] B_WL[105] B_WL[106]
+ B_WL[107] B_WL[108] B_WL[109] B_WL[110] B_WL[111] B_WL[112] B_WL[113]
+ B_WL[114] B_WL[115] B_WL[116] B_WL[117] B_WL[118] B_WL[119] B_WL[120]
+ B_WL[121] B_WL[122] B_WL[123] B_WL[124] B_WL[125] B_WL[126] B_WL[127]
+ B_WL[128] B_WL[129] B_WL[130] B_WL[131] B_WL[132] B_WL[133] B_WL[134]
+ B_WL[135] B_WL[136] B_WL[137] B_WL[138] B_WL[139] B_WL[140] B_WL[141]
+ B_WL[142] B_WL[143] B_WL[144] B_WL[145] B_WL[146] B_WL[147] B_WL[148]
+ B_WL[149] B_WL[150] B_WL[151] B_WL[152] B_WL[153] B_WL[154] B_WL[155]
+ B_WL[156] B_WL[157] B_WL[158] B_WL[159] B_WL[160] B_WL[161] B_WL[162]
+ B_WL[163] B_WL[164] B_WL[165] B_WL[166] B_WL[167] B_WL[168] B_WL[169]
+ B_WL[170] B_WL[171] B_WL[172] B_WL[173] B_WL[174] B_WL[175] B_WL[176]
+ B_WL[177] B_WL[178] B_WL[179] B_WL[180] B_WL[181] B_WL[182] B_WL[183]
+ B_WL[184] B_WL[185] B_WL[186] B_WL[187] B_WL[188] B_WL[189] B_WL[190]
+ B_WL[191] B_WL[192] B_WL[193] B_WL[194] B_WL[195] B_WL[196] B_WL[197]
+ B_WL[198] B_WL[199] B_WL[200] B_WL[201] B_WL[202] B_WL[203] B_WL[204]
+ B_WL[205] B_WL[206] B_WL[207] B_WL[208] B_WL[209] B_WL[210] B_WL[211]
+ B_WL[212] B_WL[213] B_WL[214] B_WL[215] B_WL[216] B_WL[217] B_WL[218]
+ B_WL[219] B_WL[220] B_WL[221] B_WL[222] B_WL[223] B_WL[224] B_WL[225]
+ B_WL[226] B_WL[227] B_WL[228] B_WL[229] B_WL[230] B_WL[231] B_WL[232]
+ B_WL[233] B_WL[234] B_WL[235] B_WL[236] B_WL[237] B_WL[238] B_WL[239]
+ B_WL[240] B_WL[241] B_WL[242] B_WL[243] B_WL[244] B_WL[245] B_WL[246]
+ B_WL[247] B_WL[248] B_WL[249] B_WL[250] B_WL[251] B_WL[252] B_WL[253]
+ B_WL[254] B_WL[255] A_DBL VHI SDL400W20S_NDMEMSLC
XDMEMSLCB A_WL[0] A_WL[1] A_WL[2] A_WL[3] A_WL[4] A_WL[5] A_WL[6] A_WL[7]
+ A_WL[8] A_WL[9] A_WL[10] A_WL[11] A_WL[12] A_WL[13] A_WL[14] A_WL[15]
+ A_WL[16] A_WL[17] A_WL[18] A_WL[19] A_WL[20] A_WL[21] A_WL[22] A_WL[23]
+ A_WL[24] A_WL[25] A_WL[26] A_WL[27] A_WL[28] A_WL[29] A_WL[30] A_WL[31]
+ A_WL[32] A_WL[33] A_WL[34] A_WL[35] A_WL[36] A_WL[37] A_WL[38] A_WL[39]
+ A_WL[40] A_WL[41] A_WL[42] A_WL[43] A_WL[44] A_WL[45] A_WL[46] A_WL[47]
+ A_WL[48] A_WL[49] A_WL[50] A_WL[51] A_WL[52] A_WL[53] A_WL[54] A_WL[55]
+ A_WL[56] A_WL[57] A_WL[58] A_WL[59] A_WL[60] A_WL[61] A_WL[62] A_WL[63]
+ A_WL[64] A_WL[65] A_WL[66] A_WL[67] A_WL[68] A_WL[69] A_WL[70] A_WL[71]
+ A_WL[72] A_WL[73] A_WL[74] A_WL[75] A_WL[76] A_WL[77] A_WL[78] A_WL[79]
+ A_WL[80] A_WL[81] A_WL[82] A_WL[83] A_WL[84] A_WL[85] A_WL[86] A_WL[87]
+ A_WL[88] A_WL[89] A_WL[90] A_WL[91] A_WL[92] A_WL[93] A_WL[94] A_WL[95]
+ A_WL[96] A_WL[97] A_WL[98] A_WL[99] A_WL[100] A_WL[101] A_WL[102] A_WL[103]
+ A_WL[104] A_WL[105] A_WL[106] A_WL[107] A_WL[108] A_WL[109] A_WL[110]
+ A_WL[111] A_WL[112] A_WL[113] A_WL[114] A_WL[115] A_WL[116] A_WL[117]
+ A_WL[118] A_WL[119] A_WL[120] A_WL[121] A_WL[122] A_WL[123] A_WL[124]
+ A_WL[125] A_WL[126] A_WL[127] A_WL[128] A_WL[129] A_WL[130] A_WL[131]
+ A_WL[132] A_WL[133] A_WL[134] A_WL[135] A_WL[136] A_WL[137] A_WL[138]
+ A_WL[139] A_WL[140] A_WL[141] A_WL[142] A_WL[143] A_WL[144] A_WL[145]
+ A_WL[146] A_WL[147] A_WL[148] A_WL[149] A_WL[150] A_WL[151] A_WL[152]
+ A_WL[153] A_WL[154] A_WL[155] A_WL[156] A_WL[157] A_WL[158] A_WL[159]
+ A_WL[160] A_WL[161] A_WL[162] A_WL[163] A_WL[164] A_WL[165] A_WL[166]
+ A_WL[167] A_WL[168] A_WL[169] A_WL[170] A_WL[171] A_WL[172] A_WL[173]
+ A_WL[174] A_WL[175] A_WL[176] A_WL[177] A_WL[178] A_WL[179] A_WL[180]
+ A_WL[181] A_WL[182] A_WL[183] A_WL[184] A_WL[185] A_WL[186] A_WL[187]
+ A_WL[188] A_WL[189] A_WL[190] A_WL[191] A_WL[192] A_WL[193] A_WL[194]
+ A_WL[195] A_WL[196] A_WL[197] A_WL[198] A_WL[199] A_WL[200] A_WL[201]
+ A_WL[202] A_WL[203] A_WL[204] A_WL[205] A_WL[206] A_WL[207] A_WL[208]
+ A_WL[209] A_WL[210] A_WL[211] A_WL[212] A_WL[213] A_WL[214] A_WL[215]
+ A_WL[216] A_WL[217] A_WL[218] A_WL[219] A_WL[220] A_WL[221] A_WL[222]
+ A_WL[223] A_WL[224] A_WL[225] A_WL[226] A_WL[227] A_WL[228] A_WL[229]
+ A_WL[230] A_WL[231] A_WL[232] A_WL[233] A_WL[234] A_WL[235] A_WL[236]
+ A_WL[237] A_WL[238] A_WL[239] A_WL[240] A_WL[241] A_WL[242] A_WL[243]
+ A_WL[244] A_WL[245] A_WL[246] A_WL[247] A_WL[248] A_WL[249] A_WL[250]
+ A_WL[251] A_WL[252] A_WL[253] A_WL[254] A_WL[255] B_WL[0] B_WL[1] B_WL[2]
+ B_WL[3] B_WL[4] B_WL[5] B_WL[6] B_WL[7] B_WL[8] B_WL[9] B_WL[10] B_WL[11]
+ B_WL[12] B_WL[13] B_WL[14] B_WL[15] B_WL[16] B_WL[17] B_WL[18] B_WL[19]
+ B_WL[20] B_WL[21] B_WL[22] B_WL[23] B_WL[24] B_WL[25] B_WL[26] B_WL[27]
+ B_WL[28] B_WL[29] B_WL[30] B_WL[31] B_WL[32] B_WL[33] B_WL[34] B_WL[35]
+ B_WL[36] B_WL[37] B_WL[38] B_WL[39] B_WL[40] B_WL[41] B_WL[42] B_WL[43]
+ B_WL[44] B_WL[45] B_WL[46] B_WL[47] B_WL[48] B_WL[49] B_WL[50] B_WL[51]
+ B_WL[52] B_WL[53] B_WL[54] B_WL[55] B_WL[56] B_WL[57] B_WL[58] B_WL[59]
+ B_WL[60] B_WL[61] B_WL[62] B_WL[63] B_WL[64] B_WL[65] B_WL[66] B_WL[67]
+ B_WL[68] B_WL[69] B_WL[70] B_WL[71] B_WL[72] B_WL[73] B_WL[74] B_WL[75]
+ B_WL[76] B_WL[77] B_WL[78] B_WL[79] B_WL[80] B_WL[81] B_WL[82] B_WL[83]
+ B_WL[84] B_WL[85] B_WL[86] B_WL[87] B_WL[88] B_WL[89] B_WL[90] B_WL[91]
+ B_WL[92] B_WL[93] B_WL[94] B_WL[95] B_WL[96] B_WL[97] B_WL[98] B_WL[99]
+ B_WL[100] B_WL[101] B_WL[102] B_WL[103] B_WL[104] B_WL[105] B_WL[106]
+ B_WL[107] B_WL[108] B_WL[109] B_WL[110] B_WL[111] B_WL[112] B_WL[113]
+ B_WL[114] B_WL[115] B_WL[116] B_WL[117] B_WL[118] B_WL[119] B_WL[120]
+ B_WL[121] B_WL[122] B_WL[123] B_WL[124] B_WL[125] B_WL[126] B_WL[127]
+ B_WL[128] B_WL[129] B_WL[130] B_WL[131] B_WL[132] B_WL[133] B_WL[134]
+ B_WL[135] B_WL[136] B_WL[137] B_WL[138] B_WL[139] B_WL[140] B_WL[141]
+ B_WL[142] B_WL[143] B_WL[144] B_WL[145] B_WL[146] B_WL[147] B_WL[148]
+ B_WL[149] B_WL[150] B_WL[151] B_WL[152] B_WL[153] B_WL[154] B_WL[155]
+ B_WL[156] B_WL[157] B_WL[158] B_WL[159] B_WL[160] B_WL[161] B_WL[162]
+ B_WL[163] B_WL[164] B_WL[165] B_WL[166] B_WL[167] B_WL[168] B_WL[169]
+ B_WL[170] B_WL[171] B_WL[172] B_WL[173] B_WL[174] B_WL[175] B_WL[176]
+ B_WL[177] B_WL[178] B_WL[179] B_WL[180] B_WL[181] B_WL[182] B_WL[183]
+ B_WL[184] B_WL[185] B_WL[186] B_WL[187] B_WL[188] B_WL[189] B_WL[190]
+ B_WL[191] B_WL[192] B_WL[193] B_WL[194] B_WL[195] B_WL[196] B_WL[197]
+ B_WL[198] B_WL[199] B_WL[200] B_WL[201] B_WL[202] B_WL[203] B_WL[204]
+ B_WL[205] B_WL[206] B_WL[207] B_WL[208] B_WL[209] B_WL[210] B_WL[211]
+ B_WL[212] B_WL[213] B_WL[214] B_WL[215] B_WL[216] B_WL[217] B_WL[218]
+ B_WL[219] B_WL[220] B_WL[221] B_WL[222] B_WL[223] B_WL[224] B_WL[225]
+ B_WL[226] B_WL[227] B_WL[228] B_WL[229] B_WL[230] B_WL[231] B_WL[232]
+ B_WL[233] B_WL[234] B_WL[235] B_WL[236] B_WL[237] B_WL[238] B_WL[239]
+ B_WL[240] B_WL[241] B_WL[242] B_WL[243] B_WL[244] B_WL[245] B_WL[246]
+ B_WL[247] B_WL[248] B_WL[249] B_WL[250] B_WL[251] B_WL[252] B_WL[253]
+ B_WL[254] B_WL[255] B_DBL VHI SDL400W20S_NDMEMSLC
XDWLGRPA A_DWL VHI SDL400W20S_NDWLGRPA
XDWLGRPB B_DWL VHI SDL400W20S_NDWLGRPB
XWSLC A_WL[0] A_WL[1] A_WL[2] A_WL[3] A_WL[4] A_WL[5] A_WL[6] A_WL[7] A_WL[8]
+ A_WL[9] A_WL[10] A_WL[11] A_WL[12] A_WL[13] A_WL[14] A_WL[15] A_WL[16]
+ A_WL[17] A_WL[18] A_WL[19] A_WL[20] A_WL[21] A_WL[22] A_WL[23] A_WL[24]
+ A_WL[25] A_WL[26] A_WL[27] A_WL[28] A_WL[29] A_WL[30] A_WL[31] A_WL[32]
+ A_WL[33] A_WL[34] A_WL[35] A_WL[36] A_WL[37] A_WL[38] A_WL[39] A_WL[40]
+ A_WL[41] A_WL[42] A_WL[43] A_WL[44] A_WL[45] A_WL[46] A_WL[47] A_WL[48]
+ A_WL[49] A_WL[50] A_WL[51] A_WL[52] A_WL[53] A_WL[54] A_WL[55] A_WL[56]
+ A_WL[57] A_WL[58] A_WL[59] A_WL[60] A_WL[61] A_WL[62] A_WL[63] A_WL[64]
+ A_WL[65] A_WL[66] A_WL[67] A_WL[68] A_WL[69] A_WL[70] A_WL[71] A_WL[72]
+ A_WL[73] A_WL[74] A_WL[75] A_WL[76] A_WL[77] A_WL[78] A_WL[79] A_WL[80]
+ A_WL[81] A_WL[82] A_WL[83] A_WL[84] A_WL[85] A_WL[86] A_WL[87] A_WL[88]
+ A_WL[89] A_WL[90] A_WL[91] A_WL[92] A_WL[93] A_WL[94] A_WL[95] A_WL[96]
+ A_WL[97] A_WL[98] A_WL[99] A_WL[100] A_WL[101] A_WL[102] A_WL[103] A_WL[104]
+ A_WL[105] A_WL[106] A_WL[107] A_WL[108] A_WL[109] A_WL[110] A_WL[111]
+ A_WL[112] A_WL[113] A_WL[114] A_WL[115] A_WL[116] A_WL[117] A_WL[118]
+ A_WL[119] A_WL[120] A_WL[121] A_WL[122] A_WL[123] A_WL[124] A_WL[125]
+ A_WL[126] A_WL[127] A_WL[128] A_WL[129] A_WL[130] A_WL[131] A_WL[132]
+ A_WL[133] A_WL[134] A_WL[135] A_WL[136] A_WL[137] A_WL[138] A_WL[139]
+ A_WL[140] A_WL[141] A_WL[142] A_WL[143] A_WL[144] A_WL[145] A_WL[146]
+ A_WL[147] A_WL[148] A_WL[149] A_WL[150] A_WL[151] A_WL[152] A_WL[153]
+ A_WL[154] A_WL[155] A_WL[156] A_WL[157] A_WL[158] A_WL[159] A_WL[160]
+ A_WL[161] A_WL[162] A_WL[163] A_WL[164] A_WL[165] A_WL[166] A_WL[167]
+ A_WL[168] A_WL[169] A_WL[170] A_WL[171] A_WL[172] A_WL[173] A_WL[174]
+ A_WL[175] A_WL[176] A_WL[177] A_WL[178] A_WL[179] A_WL[180] A_WL[181]
+ A_WL[182] A_WL[183] A_WL[184] A_WL[185] A_WL[186] A_WL[187] A_WL[188]
+ A_WL[189] A_WL[190] A_WL[191] A_WL[192] A_WL[193] A_WL[194] A_WL[195]
+ A_WL[196] A_WL[197] A_WL[198] A_WL[199] A_WL[200] A_WL[201] A_WL[202]
+ A_WL[203] A_WL[204] A_WL[205] A_WL[206] A_WL[207] A_WL[208] A_WL[209]
+ A_WL[210] A_WL[211] A_WL[212] A_WL[213] A_WL[214] A_WL[215] A_WL[216]
+ A_WL[217] A_WL[218] A_WL[219] A_WL[220] A_WL[221] A_WL[222] A_WL[223]
+ A_WL[224] A_WL[225] A_WL[226] A_WL[227] A_WL[228] A_WL[229] A_WL[230]
+ A_WL[231] A_WL[232] A_WL[233] A_WL[234] A_WL[235] A_WL[236] A_WL[237]
+ A_WL[238] A_WL[239] A_WL[240] A_WL[241] A_WL[242] A_WL[243] A_WL[244]
+ A_WL[245] A_WL[246] A_WL[247] A_WL[248] A_WL[249] A_WL[250] A_WL[251]
+ A_WL[252] A_WL[253] A_WL[254] A_WL[255] B_WL[0] B_WL[1] B_WL[2] B_WL[3]
+ B_WL[4] B_WL[5] B_WL[6] B_WL[7] B_WL[8] B_WL[9] B_WL[10] B_WL[11] B_WL[12]
+ B_WL[13] B_WL[14] B_WL[15] B_WL[16] B_WL[17] B_WL[18] B_WL[19] B_WL[20]
+ B_WL[21] B_WL[22] B_WL[23] B_WL[24] B_WL[25] B_WL[26] B_WL[27] B_WL[28]
+ B_WL[29] B_WL[30] B_WL[31] B_WL[32] B_WL[33] B_WL[34] B_WL[35] B_WL[36]
+ B_WL[37] B_WL[38] B_WL[39] B_WL[40] B_WL[41] B_WL[42] B_WL[43] B_WL[44]
+ B_WL[45] B_WL[46] B_WL[47] B_WL[48] B_WL[49] B_WL[50] B_WL[51] B_WL[52]
+ B_WL[53] B_WL[54] B_WL[55] B_WL[56] B_WL[57] B_WL[58] B_WL[59] B_WL[60]
+ B_WL[61] B_WL[62] B_WL[63] B_WL[64] B_WL[65] B_WL[66] B_WL[67] B_WL[68]
+ B_WL[69] B_WL[70] B_WL[71] B_WL[72] B_WL[73] B_WL[74] B_WL[75] B_WL[76]
+ B_WL[77] B_WL[78] B_WL[79] B_WL[80] B_WL[81] B_WL[82] B_WL[83] B_WL[84]
+ B_WL[85] B_WL[86] B_WL[87] B_WL[88] B_WL[89] B_WL[90] B_WL[91] B_WL[92]
+ B_WL[93] B_WL[94] B_WL[95] B_WL[96] B_WL[97] B_WL[98] B_WL[99] B_WL[100]
+ B_WL[101] B_WL[102] B_WL[103] B_WL[104] B_WL[105] B_WL[106] B_WL[107]
+ B_WL[108] B_WL[109] B_WL[110] B_WL[111] B_WL[112] B_WL[113] B_WL[114]
+ B_WL[115] B_WL[116] B_WL[117] B_WL[118] B_WL[119] B_WL[120] B_WL[121]
+ B_WL[122] B_WL[123] B_WL[124] B_WL[125] B_WL[126] B_WL[127] B_WL[128]
+ B_WL[129] B_WL[130] B_WL[131] B_WL[132] B_WL[133] B_WL[134] B_WL[135]
+ B_WL[136] B_WL[137] B_WL[138] B_WL[139] B_WL[140] B_WL[141] B_WL[142]
+ B_WL[143] B_WL[144] B_WL[145] B_WL[146] B_WL[147] B_WL[148] B_WL[149]
+ B_WL[150] B_WL[151] B_WL[152] B_WL[153] B_WL[154] B_WL[155] B_WL[156]
+ B_WL[157] B_WL[158] B_WL[159] B_WL[160] B_WL[161] B_WL[162] B_WL[163]
+ B_WL[164] B_WL[165] B_WL[166] B_WL[167] B_WL[168] B_WL[169] B_WL[170]
+ B_WL[171] B_WL[172] B_WL[173] B_WL[174] B_WL[175] B_WL[176] B_WL[177]
+ B_WL[178] B_WL[179] B_WL[180] B_WL[181] B_WL[182] B_WL[183] B_WL[184]
+ B_WL[185] B_WL[186] B_WL[187] B_WL[188] B_WL[189] B_WL[190] B_WL[191]
+ B_WL[192] B_WL[193] B_WL[194] B_WL[195] B_WL[196] B_WL[197] B_WL[198]
+ B_WL[199] B_WL[200] B_WL[201] B_WL[202] B_WL[203] B_WL[204] B_WL[205]
+ B_WL[206] B_WL[207] B_WL[208] B_WL[209] B_WL[210] B_WL[211] B_WL[212]
+ B_WL[213] B_WL[214] B_WL[215] B_WL[216] B_WL[217] B_WL[218] B_WL[219]
+ B_WL[220] B_WL[221] B_WL[222] B_WL[223] B_WL[224] B_WL[225] B_WL[226]
+ B_WL[227] B_WL[228] B_WL[229] B_WL[230] B_WL[231] B_WL[232] B_WL[233]
+ B_WL[234] B_WL[235] B_WL[236] B_WL[237] B_WL[238] B_WL[239] B_WL[240]
+ B_WL[241] B_WL[242] B_WL[243] B_WL[244] B_WL[245] B_WL[246] B_WL[247]
+ B_WL[248] B_WL[249] B_WL[250] B_WL[251] B_WL[252] B_WL[253] B_WL[254]
+ B_WL[255] A_GCDEC[3] A_GCDEC[2] A_GCDEC[1] A_GCDEC[0] A_RD VS[1] VS[0] A_WRT
+ A_XA[7] A_XA[6] A_XA[5] A_XA[4] A_XA[3] A_XA[2] A_XA[1] A_XA[0] A_XB[3]
+ A_XB[2] A_XB[1] A_XB[0] A_XC[7] A_XC[6] A_XC[5] A_XC[4] A_XC[3] A_XC[2]
+ A_XC[1] A_XC[0] A_Y[7] A_Y[6] A_Y[5] A_Y[4] A_Y[3] A_Y[2] A_Y[1] A_Y[0]
+ B_GCDEC[3] B_GCDEC[2] B_GCDEC[1] B_GCDEC[0] B_RD VS[1] VS[0] B_WRT B_XA[7]
+ B_XA[6] B_XA[5] B_XA[4] B_XA[3] B_XA[2] B_XA[1] B_XA[0] B_XB[3] B_XB[2]
+ B_XB[1] B_XB[0] B_XC[7] B_XC[6] B_XC[5] B_XC[4] B_XC[3] B_XC[2] B_XC[1]
+ B_XC[0] B_Y[7] B_Y[6] B_Y[5] B_Y[4] B_Y[3] B_Y[2] B_Y[1] B_Y[0] A_Z[7] A_Z[6]
+ A_Z[5] A_Z[4] A_Z[3] A_Z[2] A_Z[1] A_Z[0] B_Z[7] B_Z[6] B_Z[5] B_Z[4] B_Z[3]
+ B_Z[2] B_Z[1] B_Z[0] A_RDL[0] A_SMPRS_0[3] A_SMPRS_0[2] A_SMPRS_0[1]
+ A_SMPRS_0[0] A_SOE[0] A_WRTL[0] A_YSEL_0[7] A_YSEL_0[6] A_YSEL_0[5]
+ A_YSEL_0[4] A_YSEL_0[3] A_YSEL_0[2] A_YSEL_0[1] A_YSEL_0[0] B_RDL[0]
+ B_SMPRS_0[3] B_SMPRS_0[2] B_SMPRS_0[1] B_SMPRS_0[0] B_SOE[0] B_WRTL[0]
+ B_YSEL_0[7] B_YSEL_0[6] B_YSEL_0[5] B_YSEL_0[4] B_YSEL_0[3] B_YSEL_0[2]
+ B_YSEL_0[1] B_YSEL_0[0] SDL400W20S_NWSLC
XBIT0 A_WL[0] A_WL[1] A_WL[2] A_WL[3] A_WL[4] A_WL[5] A_WL[6] A_WL[7] A_WL[8]
+ A_WL[9] A_WL[10] A_WL[11] A_WL[12] A_WL[13] A_WL[14] A_WL[15] A_WL[16]
+ A_WL[17] A_WL[18] A_WL[19] A_WL[20] A_WL[21] A_WL[22] A_WL[23] A_WL[24]
+ A_WL[25] A_WL[26] A_WL[27] A_WL[28] A_WL[29] A_WL[30] A_WL[31] A_WL[32]
+ A_WL[33] A_WL[34] A_WL[35] A_WL[36] A_WL[37] A_WL[38] A_WL[39] A_WL[40]
+ A_WL[41] A_WL[42] A_WL[43] A_WL[44] A_WL[45] A_WL[46] A_WL[47] A_WL[48]
+ A_WL[49] A_WL[50] A_WL[51] A_WL[52] A_WL[53] A_WL[54] A_WL[55] A_WL[56]
+ A_WL[57] A_WL[58] A_WL[59] A_WL[60] A_WL[61] A_WL[62] A_WL[63] A_WL[64]
+ A_WL[65] A_WL[66] A_WL[67] A_WL[68] A_WL[69] A_WL[70] A_WL[71] A_WL[72]
+ A_WL[73] A_WL[74] A_WL[75] A_WL[76] A_WL[77] A_WL[78] A_WL[79] A_WL[80]
+ A_WL[81] A_WL[82] A_WL[83] A_WL[84] A_WL[85] A_WL[86] A_WL[87] A_WL[88]
+ A_WL[89] A_WL[90] A_WL[91] A_WL[92] A_WL[93] A_WL[94] A_WL[95] A_WL[96]
+ A_WL[97] A_WL[98] A_WL[99] A_WL[100] A_WL[101] A_WL[102] A_WL[103] A_WL[104]
+ A_WL[105] A_WL[106] A_WL[107] A_WL[108] A_WL[109] A_WL[110] A_WL[111]
+ A_WL[112] A_WL[113] A_WL[114] A_WL[115] A_WL[116] A_WL[117] A_WL[118]
+ A_WL[119] A_WL[120] A_WL[121] A_WL[122] A_WL[123] A_WL[124] A_WL[125]
+ A_WL[126] A_WL[127] A_WL[128] A_WL[129] A_WL[130] A_WL[131] A_WL[132]
+ A_WL[133] A_WL[134] A_WL[135] A_WL[136] A_WL[137] A_WL[138] A_WL[139]
+ A_WL[140] A_WL[141] A_WL[142] A_WL[143] A_WL[144] A_WL[145] A_WL[146]
+ A_WL[147] A_WL[148] A_WL[149] A_WL[150] A_WL[151] A_WL[152] A_WL[153]
+ A_WL[154] A_WL[155] A_WL[156] A_WL[157] A_WL[158] A_WL[159] A_WL[160]
+ A_WL[161] A_WL[162] A_WL[163] A_WL[164] A_WL[165] A_WL[166] A_WL[167]
+ A_WL[168] A_WL[169] A_WL[170] A_WL[171] A_WL[172] A_WL[173] A_WL[174]
+ A_WL[175] A_WL[176] A_WL[177] A_WL[178] A_WL[179] A_WL[180] A_WL[181]
+ A_WL[182] A_WL[183] A_WL[184] A_WL[185] A_WL[186] A_WL[187] A_WL[188]
+ A_WL[189] A_WL[190] A_WL[191] A_WL[192] A_WL[193] A_WL[194] A_WL[195]
+ A_WL[196] A_WL[197] A_WL[198] A_WL[199] A_WL[200] A_WL[201] A_WL[202]
+ A_WL[203] A_WL[204] A_WL[205] A_WL[206] A_WL[207] A_WL[208] A_WL[209]
+ A_WL[210] A_WL[211] A_WL[212] A_WL[213] A_WL[214] A_WL[215] A_WL[216]
+ A_WL[217] A_WL[218] A_WL[219] A_WL[220] A_WL[221] A_WL[222] A_WL[223]
+ A_WL[224] A_WL[225] A_WL[226] A_WL[227] A_WL[228] A_WL[229] A_WL[230]
+ A_WL[231] A_WL[232] A_WL[233] A_WL[234] A_WL[235] A_WL[236] A_WL[237]
+ A_WL[238] A_WL[239] A_WL[240] A_WL[241] A_WL[242] A_WL[243] A_WL[244]
+ A_WL[245] A_WL[246] A_WL[247] A_WL[248] A_WL[249] A_WL[250] A_WL[251]
+ A_WL[252] A_WL[253] A_WL[254] A_WL[255] B_WL[0] B_WL[1] B_WL[2] B_WL[3]
+ B_WL[4] B_WL[5] B_WL[6] B_WL[7] B_WL[8] B_WL[9] B_WL[10] B_WL[11] B_WL[12]
+ B_WL[13] B_WL[14] B_WL[15] B_WL[16] B_WL[17] B_WL[18] B_WL[19] B_WL[20]
+ B_WL[21] B_WL[22] B_WL[23] B_WL[24] B_WL[25] B_WL[26] B_WL[27] B_WL[28]
+ B_WL[29] B_WL[30] B_WL[31] B_WL[32] B_WL[33] B_WL[34] B_WL[35] B_WL[36]
+ B_WL[37] B_WL[38] B_WL[39] B_WL[40] B_WL[41] B_WL[42] B_WL[43] B_WL[44]
+ B_WL[45] B_WL[46] B_WL[47] B_WL[48] B_WL[49] B_WL[50] B_WL[51] B_WL[52]
+ B_WL[53] B_WL[54] B_WL[55] B_WL[56] B_WL[57] B_WL[58] B_WL[59] B_WL[60]
+ B_WL[61] B_WL[62] B_WL[63] B_WL[64] B_WL[65] B_WL[66] B_WL[67] B_WL[68]
+ B_WL[69] B_WL[70] B_WL[71] B_WL[72] B_WL[73] B_WL[74] B_WL[75] B_WL[76]
+ B_WL[77] B_WL[78] B_WL[79] B_WL[80] B_WL[81] B_WL[82] B_WL[83] B_WL[84]
+ B_WL[85] B_WL[86] B_WL[87] B_WL[88] B_WL[89] B_WL[90] B_WL[91] B_WL[92]
+ B_WL[93] B_WL[94] B_WL[95] B_WL[96] B_WL[97] B_WL[98] B_WL[99] B_WL[100]
+ B_WL[101] B_WL[102] B_WL[103] B_WL[104] B_WL[105] B_WL[106] B_WL[107]
+ B_WL[108] B_WL[109] B_WL[110] B_WL[111] B_WL[112] B_WL[113] B_WL[114]
+ B_WL[115] B_WL[116] B_WL[117] B_WL[118] B_WL[119] B_WL[120] B_WL[121]
+ B_WL[122] B_WL[123] B_WL[124] B_WL[125] B_WL[126] B_WL[127] B_WL[128]
+ B_WL[129] B_WL[130] B_WL[131] B_WL[132] B_WL[133] B_WL[134] B_WL[135]
+ B_WL[136] B_WL[137] B_WL[138] B_WL[139] B_WL[140] B_WL[141] B_WL[142]
+ B_WL[143] B_WL[144] B_WL[145] B_WL[146] B_WL[147] B_WL[148] B_WL[149]
+ B_WL[150] B_WL[151] B_WL[152] B_WL[153] B_WL[154] B_WL[155] B_WL[156]
+ B_WL[157] B_WL[158] B_WL[159] B_WL[160] B_WL[161] B_WL[162] B_WL[163]
+ B_WL[164] B_WL[165] B_WL[166] B_WL[167] B_WL[168] B_WL[169] B_WL[170]
+ B_WL[171] B_WL[172] B_WL[173] B_WL[174] B_WL[175] B_WL[176] B_WL[177]
+ B_WL[178] B_WL[179] B_WL[180] B_WL[181] B_WL[182] B_WL[183] B_WL[184]
+ B_WL[185] B_WL[186] B_WL[187] B_WL[188] B_WL[189] B_WL[190] B_WL[191]
+ B_WL[192] B_WL[193] B_WL[194] B_WL[195] B_WL[196] B_WL[197] B_WL[198]
+ B_WL[199] B_WL[200] B_WL[201] B_WL[202] B_WL[203] B_WL[204] B_WL[205]
+ B_WL[206] B_WL[207] B_WL[208] B_WL[209] B_WL[210] B_WL[211] B_WL[212]
+ B_WL[213] B_WL[214] B_WL[215] B_WL[216] B_WL[217] B_WL[218] B_WL[219]
+ B_WL[220] B_WL[221] B_WL[222] B_WL[223] B_WL[224] B_WL[225] B_WL[226]
+ B_WL[227] B_WL[228] B_WL[229] B_WL[230] B_WL[231] B_WL[232] B_WL[233]
+ B_WL[234] B_WL[235] B_WL[236] B_WL[237] B_WL[238] B_WL[239] B_WL[240]
+ B_WL[241] B_WL[242] B_WL[243] B_WL[244] B_WL[245] B_WL[246] B_WL[247]
+ B_WL[248] B_WL[249] B_WL[250] B_WL[251] B_WL[252] B_WL[253] B_WL[254]
+ B_WL[255] A_RDL[0] A_SMPRS_0[3] A_SMPRS_0[2] A_SMPRS_0[1] A_SMPRS_0[0]
+ A_SOE[0] A_WRTL[0] A_YSEL_0[7] A_YSEL_0[6] A_YSEL_0[5] A_YSEL_0[4]
+ A_YSEL_0[3] A_YSEL_0[2] A_YSEL_0[1] A_YSEL_0[0] B_RDL[0] B_SMPRS_0[3]
+ B_SMPRS_0[2] B_SMPRS_0[1] B_SMPRS_0[0] B_SOE[0] B_WRTL[0] B_YSEL_0[7]
+ B_YSEL_0[6] B_YSEL_0[5] B_YSEL_0[4] B_YSEL_0[3] B_YSEL_0[2] B_YSEL_0[1]
+ B_YSEL_0[0] AWTI BWEBA[0] BWEBMA[0] A_CKD DA[0] A_DLRS DMA[0] A_WENB[3]
+ A_WENB[2] A_WENB[1] A_WENB[0] BISTC BISTT BWEBB[0] BWEBMB[0] B_CKD DB[0]
+ B_DLRS DMB[0] B_WENB[3] B_WENB[2] B_WENB[1] B_WENB[0] QA[0] QB[0]
+  SDL400W20S_NBITSLC
XBIT1 A_WL[0] A_WL[1] A_WL[2] A_WL[3] A_WL[4] A_WL[5] A_WL[6] A_WL[7] A_WL[8]
+ A_WL[9] A_WL[10] A_WL[11] A_WL[12] A_WL[13] A_WL[14] A_WL[15] A_WL[16]
+ A_WL[17] A_WL[18] A_WL[19] A_WL[20] A_WL[21] A_WL[22] A_WL[23] A_WL[24]
+ A_WL[25] A_WL[26] A_WL[27] A_WL[28] A_WL[29] A_WL[30] A_WL[31] A_WL[32]
+ A_WL[33] A_WL[34] A_WL[35] A_WL[36] A_WL[37] A_WL[38] A_WL[39] A_WL[40]
+ A_WL[41] A_WL[42] A_WL[43] A_WL[44] A_WL[45] A_WL[46] A_WL[47] A_WL[48]
+ A_WL[49] A_WL[50] A_WL[51] A_WL[52] A_WL[53] A_WL[54] A_WL[55] A_WL[56]
+ A_WL[57] A_WL[58] A_WL[59] A_WL[60] A_WL[61] A_WL[62] A_WL[63] A_WL[64]
+ A_WL[65] A_WL[66] A_WL[67] A_WL[68] A_WL[69] A_WL[70] A_WL[71] A_WL[72]
+ A_WL[73] A_WL[74] A_WL[75] A_WL[76] A_WL[77] A_WL[78] A_WL[79] A_WL[80]
+ A_WL[81] A_WL[82] A_WL[83] A_WL[84] A_WL[85] A_WL[86] A_WL[87] A_WL[88]
+ A_WL[89] A_WL[90] A_WL[91] A_WL[92] A_WL[93] A_WL[94] A_WL[95] A_WL[96]
+ A_WL[97] A_WL[98] A_WL[99] A_WL[100] A_WL[101] A_WL[102] A_WL[103] A_WL[104]
+ A_WL[105] A_WL[106] A_WL[107] A_WL[108] A_WL[109] A_WL[110] A_WL[111]
+ A_WL[112] A_WL[113] A_WL[114] A_WL[115] A_WL[116] A_WL[117] A_WL[118]
+ A_WL[119] A_WL[120] A_WL[121] A_WL[122] A_WL[123] A_WL[124] A_WL[125]
+ A_WL[126] A_WL[127] A_WL[128] A_WL[129] A_WL[130] A_WL[131] A_WL[132]
+ A_WL[133] A_WL[134] A_WL[135] A_WL[136] A_WL[137] A_WL[138] A_WL[139]
+ A_WL[140] A_WL[141] A_WL[142] A_WL[143] A_WL[144] A_WL[145] A_WL[146]
+ A_WL[147] A_WL[148] A_WL[149] A_WL[150] A_WL[151] A_WL[152] A_WL[153]
+ A_WL[154] A_WL[155] A_WL[156] A_WL[157] A_WL[158] A_WL[159] A_WL[160]
+ A_WL[161] A_WL[162] A_WL[163] A_WL[164] A_WL[165] A_WL[166] A_WL[167]
+ A_WL[168] A_WL[169] A_WL[170] A_WL[171] A_WL[172] A_WL[173] A_WL[174]
+ A_WL[175] A_WL[176] A_WL[177] A_WL[178] A_WL[179] A_WL[180] A_WL[181]
+ A_WL[182] A_WL[183] A_WL[184] A_WL[185] A_WL[186] A_WL[187] A_WL[188]
+ A_WL[189] A_WL[190] A_WL[191] A_WL[192] A_WL[193] A_WL[194] A_WL[195]
+ A_WL[196] A_WL[197] A_WL[198] A_WL[199] A_WL[200] A_WL[201] A_WL[202]
+ A_WL[203] A_WL[204] A_WL[205] A_WL[206] A_WL[207] A_WL[208] A_WL[209]
+ A_WL[210] A_WL[211] A_WL[212] A_WL[213] A_WL[214] A_WL[215] A_WL[216]
+ A_WL[217] A_WL[218] A_WL[219] A_WL[220] A_WL[221] A_WL[222] A_WL[223]
+ A_WL[224] A_WL[225] A_WL[226] A_WL[227] A_WL[228] A_WL[229] A_WL[230]
+ A_WL[231] A_WL[232] A_WL[233] A_WL[234] A_WL[235] A_WL[236] A_WL[237]
+ A_WL[238] A_WL[239] A_WL[240] A_WL[241] A_WL[242] A_WL[243] A_WL[244]
+ A_WL[245] A_WL[246] A_WL[247] A_WL[248] A_WL[249] A_WL[250] A_WL[251]
+ A_WL[252] A_WL[253] A_WL[254] A_WL[255] B_WL[0] B_WL[1] B_WL[2] B_WL[3]
+ B_WL[4] B_WL[5] B_WL[6] B_WL[7] B_WL[8] B_WL[9] B_WL[10] B_WL[11] B_WL[12]
+ B_WL[13] B_WL[14] B_WL[15] B_WL[16] B_WL[17] B_WL[18] B_WL[19] B_WL[20]
+ B_WL[21] B_WL[22] B_WL[23] B_WL[24] B_WL[25] B_WL[26] B_WL[27] B_WL[28]
+ B_WL[29] B_WL[30] B_WL[31] B_WL[32] B_WL[33] B_WL[34] B_WL[35] B_WL[36]
+ B_WL[37] B_WL[38] B_WL[39] B_WL[40] B_WL[41] B_WL[42] B_WL[43] B_WL[44]
+ B_WL[45] B_WL[46] B_WL[47] B_WL[48] B_WL[49] B_WL[50] B_WL[51] B_WL[52]
+ B_WL[53] B_WL[54] B_WL[55] B_WL[56] B_WL[57] B_WL[58] B_WL[59] B_WL[60]
+ B_WL[61] B_WL[62] B_WL[63] B_WL[64] B_WL[65] B_WL[66] B_WL[67] B_WL[68]
+ B_WL[69] B_WL[70] B_WL[71] B_WL[72] B_WL[73] B_WL[74] B_WL[75] B_WL[76]
+ B_WL[77] B_WL[78] B_WL[79] B_WL[80] B_WL[81] B_WL[82] B_WL[83] B_WL[84]
+ B_WL[85] B_WL[86] B_WL[87] B_WL[88] B_WL[89] B_WL[90] B_WL[91] B_WL[92]
+ B_WL[93] B_WL[94] B_WL[95] B_WL[96] B_WL[97] B_WL[98] B_WL[99] B_WL[100]
+ B_WL[101] B_WL[102] B_WL[103] B_WL[104] B_WL[105] B_WL[106] B_WL[107]
+ B_WL[108] B_WL[109] B_WL[110] B_WL[111] B_WL[112] B_WL[113] B_WL[114]
+ B_WL[115] B_WL[116] B_WL[117] B_WL[118] B_WL[119] B_WL[120] B_WL[121]
+ B_WL[122] B_WL[123] B_WL[124] B_WL[125] B_WL[126] B_WL[127] B_WL[128]
+ B_WL[129] B_WL[130] B_WL[131] B_WL[132] B_WL[133] B_WL[134] B_WL[135]
+ B_WL[136] B_WL[137] B_WL[138] B_WL[139] B_WL[140] B_WL[141] B_WL[142]
+ B_WL[143] B_WL[144] B_WL[145] B_WL[146] B_WL[147] B_WL[148] B_WL[149]
+ B_WL[150] B_WL[151] B_WL[152] B_WL[153] B_WL[154] B_WL[155] B_WL[156]
+ B_WL[157] B_WL[158] B_WL[159] B_WL[160] B_WL[161] B_WL[162] B_WL[163]
+ B_WL[164] B_WL[165] B_WL[166] B_WL[167] B_WL[168] B_WL[169] B_WL[170]
+ B_WL[171] B_WL[172] B_WL[173] B_WL[174] B_WL[175] B_WL[176] B_WL[177]
+ B_WL[178] B_WL[179] B_WL[180] B_WL[181] B_WL[182] B_WL[183] B_WL[184]
+ B_WL[185] B_WL[186] B_WL[187] B_WL[188] B_WL[189] B_WL[190] B_WL[191]
+ B_WL[192] B_WL[193] B_WL[194] B_WL[195] B_WL[196] B_WL[197] B_WL[198]
+ B_WL[199] B_WL[200] B_WL[201] B_WL[202] B_WL[203] B_WL[204] B_WL[205]
+ B_WL[206] B_WL[207] B_WL[208] B_WL[209] B_WL[210] B_WL[211] B_WL[212]
+ B_WL[213] B_WL[214] B_WL[215] B_WL[216] B_WL[217] B_WL[218] B_WL[219]
+ B_WL[220] B_WL[221] B_WL[222] B_WL[223] B_WL[224] B_WL[225] B_WL[226]
+ B_WL[227] B_WL[228] B_WL[229] B_WL[230] B_WL[231] B_WL[232] B_WL[233]
+ B_WL[234] B_WL[235] B_WL[236] B_WL[237] B_WL[238] B_WL[239] B_WL[240]
+ B_WL[241] B_WL[242] B_WL[243] B_WL[244] B_WL[245] B_WL[246] B_WL[247]
+ B_WL[248] B_WL[249] B_WL[250] B_WL[251] B_WL[252] B_WL[253] B_WL[254]
+ B_WL[255] A_RDL[0] A_SMPRS_0[3] A_SMPRS_0[2] A_SMPRS_0[1] A_SMPRS_0[0]
+ A_SOE[0] A_WRTL[0] A_YSEL_0[7] A_YSEL_0[6] A_YSEL_0[5] A_YSEL_0[4]
+ A_YSEL_0[3] A_YSEL_0[2] A_YSEL_0[1] A_YSEL_0[0] B_RDL[0] B_SMPRS_0[3]
+ B_SMPRS_0[2] B_SMPRS_0[1] B_SMPRS_0[0] B_SOE[0] B_WRTL[0] B_YSEL_0[7]
+ B_YSEL_0[6] B_YSEL_0[5] B_YSEL_0[4] B_YSEL_0[3] B_YSEL_0[2] B_YSEL_0[1]
+ B_YSEL_0[0] AWTI BWEBA[1] BWEBMA[1] A_CKD DA[1] A_DLRS DMA[1] A_WENB[3]
+ A_WENB[2] A_WENB[1] A_WENB[0] BISTC BISTT BWEBB[1] BWEBMB[1] B_CKD DB[1]
+ B_DLRS DMB[1] B_WENB[3] B_WENB[2] B_WENB[1] B_WENB[0] QA[1] QB[1]
+  SDL400W20S_NBITSLC
XBIT2 A_WL[0] A_WL[1] A_WL[2] A_WL[3] A_WL[4] A_WL[5] A_WL[6] A_WL[7] A_WL[8]
+ A_WL[9] A_WL[10] A_WL[11] A_WL[12] A_WL[13] A_WL[14] A_WL[15] A_WL[16]
+ A_WL[17] A_WL[18] A_WL[19] A_WL[20] A_WL[21] A_WL[22] A_WL[23] A_WL[24]
+ A_WL[25] A_WL[26] A_WL[27] A_WL[28] A_WL[29] A_WL[30] A_WL[31] A_WL[32]
+ A_WL[33] A_WL[34] A_WL[35] A_WL[36] A_WL[37] A_WL[38] A_WL[39] A_WL[40]
+ A_WL[41] A_WL[42] A_WL[43] A_WL[44] A_WL[45] A_WL[46] A_WL[47] A_WL[48]
+ A_WL[49] A_WL[50] A_WL[51] A_WL[52] A_WL[53] A_WL[54] A_WL[55] A_WL[56]
+ A_WL[57] A_WL[58] A_WL[59] A_WL[60] A_WL[61] A_WL[62] A_WL[63] A_WL[64]
+ A_WL[65] A_WL[66] A_WL[67] A_WL[68] A_WL[69] A_WL[70] A_WL[71] A_WL[72]
+ A_WL[73] A_WL[74] A_WL[75] A_WL[76] A_WL[77] A_WL[78] A_WL[79] A_WL[80]
+ A_WL[81] A_WL[82] A_WL[83] A_WL[84] A_WL[85] A_WL[86] A_WL[87] A_WL[88]
+ A_WL[89] A_WL[90] A_WL[91] A_WL[92] A_WL[93] A_WL[94] A_WL[95] A_WL[96]
+ A_WL[97] A_WL[98] A_WL[99] A_WL[100] A_WL[101] A_WL[102] A_WL[103] A_WL[104]
+ A_WL[105] A_WL[106] A_WL[107] A_WL[108] A_WL[109] A_WL[110] A_WL[111]
+ A_WL[112] A_WL[113] A_WL[114] A_WL[115] A_WL[116] A_WL[117] A_WL[118]
+ A_WL[119] A_WL[120] A_WL[121] A_WL[122] A_WL[123] A_WL[124] A_WL[125]
+ A_WL[126] A_WL[127] A_WL[128] A_WL[129] A_WL[130] A_WL[131] A_WL[132]
+ A_WL[133] A_WL[134] A_WL[135] A_WL[136] A_WL[137] A_WL[138] A_WL[139]
+ A_WL[140] A_WL[141] A_WL[142] A_WL[143] A_WL[144] A_WL[145] A_WL[146]
+ A_WL[147] A_WL[148] A_WL[149] A_WL[150] A_WL[151] A_WL[152] A_WL[153]
+ A_WL[154] A_WL[155] A_WL[156] A_WL[157] A_WL[158] A_WL[159] A_WL[160]
+ A_WL[161] A_WL[162] A_WL[163] A_WL[164] A_WL[165] A_WL[166] A_WL[167]
+ A_WL[168] A_WL[169] A_WL[170] A_WL[171] A_WL[172] A_WL[173] A_WL[174]
+ A_WL[175] A_WL[176] A_WL[177] A_WL[178] A_WL[179] A_WL[180] A_WL[181]
+ A_WL[182] A_WL[183] A_WL[184] A_WL[185] A_WL[186] A_WL[187] A_WL[188]
+ A_WL[189] A_WL[190] A_WL[191] A_WL[192] A_WL[193] A_WL[194] A_WL[195]
+ A_WL[196] A_WL[197] A_WL[198] A_WL[199] A_WL[200] A_WL[201] A_WL[202]
+ A_WL[203] A_WL[204] A_WL[205] A_WL[206] A_WL[207] A_WL[208] A_WL[209]
+ A_WL[210] A_WL[211] A_WL[212] A_WL[213] A_WL[214] A_WL[215] A_WL[216]
+ A_WL[217] A_WL[218] A_WL[219] A_WL[220] A_WL[221] A_WL[222] A_WL[223]
+ A_WL[224] A_WL[225] A_WL[226] A_WL[227] A_WL[228] A_WL[229] A_WL[230]
+ A_WL[231] A_WL[232] A_WL[233] A_WL[234] A_WL[235] A_WL[236] A_WL[237]
+ A_WL[238] A_WL[239] A_WL[240] A_WL[241] A_WL[242] A_WL[243] A_WL[244]
+ A_WL[245] A_WL[246] A_WL[247] A_WL[248] A_WL[249] A_WL[250] A_WL[251]
+ A_WL[252] A_WL[253] A_WL[254] A_WL[255] B_WL[0] B_WL[1] B_WL[2] B_WL[3]
+ B_WL[4] B_WL[5] B_WL[6] B_WL[7] B_WL[8] B_WL[9] B_WL[10] B_WL[11] B_WL[12]
+ B_WL[13] B_WL[14] B_WL[15] B_WL[16] B_WL[17] B_WL[18] B_WL[19] B_WL[20]
+ B_WL[21] B_WL[22] B_WL[23] B_WL[24] B_WL[25] B_WL[26] B_WL[27] B_WL[28]
+ B_WL[29] B_WL[30] B_WL[31] B_WL[32] B_WL[33] B_WL[34] B_WL[35] B_WL[36]
+ B_WL[37] B_WL[38] B_WL[39] B_WL[40] B_WL[41] B_WL[42] B_WL[43] B_WL[44]
+ B_WL[45] B_WL[46] B_WL[47] B_WL[48] B_WL[49] B_WL[50] B_WL[51] B_WL[52]
+ B_WL[53] B_WL[54] B_WL[55] B_WL[56] B_WL[57] B_WL[58] B_WL[59] B_WL[60]
+ B_WL[61] B_WL[62] B_WL[63] B_WL[64] B_WL[65] B_WL[66] B_WL[67] B_WL[68]
+ B_WL[69] B_WL[70] B_WL[71] B_WL[72] B_WL[73] B_WL[74] B_WL[75] B_WL[76]
+ B_WL[77] B_WL[78] B_WL[79] B_WL[80] B_WL[81] B_WL[82] B_WL[83] B_WL[84]
+ B_WL[85] B_WL[86] B_WL[87] B_WL[88] B_WL[89] B_WL[90] B_WL[91] B_WL[92]
+ B_WL[93] B_WL[94] B_WL[95] B_WL[96] B_WL[97] B_WL[98] B_WL[99] B_WL[100]
+ B_WL[101] B_WL[102] B_WL[103] B_WL[104] B_WL[105] B_WL[106] B_WL[107]
+ B_WL[108] B_WL[109] B_WL[110] B_WL[111] B_WL[112] B_WL[113] B_WL[114]
+ B_WL[115] B_WL[116] B_WL[117] B_WL[118] B_WL[119] B_WL[120] B_WL[121]
+ B_WL[122] B_WL[123] B_WL[124] B_WL[125] B_WL[126] B_WL[127] B_WL[128]
+ B_WL[129] B_WL[130] B_WL[131] B_WL[132] B_WL[133] B_WL[134] B_WL[135]
+ B_WL[136] B_WL[137] B_WL[138] B_WL[139] B_WL[140] B_WL[141] B_WL[142]
+ B_WL[143] B_WL[144] B_WL[145] B_WL[146] B_WL[147] B_WL[148] B_WL[149]
+ B_WL[150] B_WL[151] B_WL[152] B_WL[153] B_WL[154] B_WL[155] B_WL[156]
+ B_WL[157] B_WL[158] B_WL[159] B_WL[160] B_WL[161] B_WL[162] B_WL[163]
+ B_WL[164] B_WL[165] B_WL[166] B_WL[167] B_WL[168] B_WL[169] B_WL[170]
+ B_WL[171] B_WL[172] B_WL[173] B_WL[174] B_WL[175] B_WL[176] B_WL[177]
+ B_WL[178] B_WL[179] B_WL[180] B_WL[181] B_WL[182] B_WL[183] B_WL[184]
+ B_WL[185] B_WL[186] B_WL[187] B_WL[188] B_WL[189] B_WL[190] B_WL[191]
+ B_WL[192] B_WL[193] B_WL[194] B_WL[195] B_WL[196] B_WL[197] B_WL[198]
+ B_WL[199] B_WL[200] B_WL[201] B_WL[202] B_WL[203] B_WL[204] B_WL[205]
+ B_WL[206] B_WL[207] B_WL[208] B_WL[209] B_WL[210] B_WL[211] B_WL[212]
+ B_WL[213] B_WL[214] B_WL[215] B_WL[216] B_WL[217] B_WL[218] B_WL[219]
+ B_WL[220] B_WL[221] B_WL[222] B_WL[223] B_WL[224] B_WL[225] B_WL[226]
+ B_WL[227] B_WL[228] B_WL[229] B_WL[230] B_WL[231] B_WL[232] B_WL[233]
+ B_WL[234] B_WL[235] B_WL[236] B_WL[237] B_WL[238] B_WL[239] B_WL[240]
+ B_WL[241] B_WL[242] B_WL[243] B_WL[244] B_WL[245] B_WL[246] B_WL[247]
+ B_WL[248] B_WL[249] B_WL[250] B_WL[251] B_WL[252] B_WL[253] B_WL[254]
+ B_WL[255] A_RDL[0] A_SMPRS_0[3] A_SMPRS_0[2] A_SMPRS_0[1] A_SMPRS_0[0]
+ A_SOE[0] A_WRTL[0] A_YSEL_0[7] A_YSEL_0[6] A_YSEL_0[5] A_YSEL_0[4]
+ A_YSEL_0[3] A_YSEL_0[2] A_YSEL_0[1] A_YSEL_0[0] B_RDL[0] B_SMPRS_0[3]
+ B_SMPRS_0[2] B_SMPRS_0[1] B_SMPRS_0[0] B_SOE[0] B_WRTL[0] B_YSEL_0[7]
+ B_YSEL_0[6] B_YSEL_0[5] B_YSEL_0[4] B_YSEL_0[3] B_YSEL_0[2] B_YSEL_0[1]
+ B_YSEL_0[0] AWTI BWEBA[2] BWEBMA[2] A_CKD DA[2] A_DLRS DMA[2] A_WENB[3]
+ A_WENB[2] A_WENB[1] A_WENB[0] BISTC BISTT BWEBB[2] BWEBMB[2] B_CKD DB[2]
+ B_DLRS DMB[2] B_WENB[3] B_WENB[2] B_WENB[1] B_WENB[0] QA[2] QB[2]
+  SDL400W20S_NBITSLC
XBIT3 A_WL[0] A_WL[1] A_WL[2] A_WL[3] A_WL[4] A_WL[5] A_WL[6] A_WL[7] A_WL[8]
+ A_WL[9] A_WL[10] A_WL[11] A_WL[12] A_WL[13] A_WL[14] A_WL[15] A_WL[16]
+ A_WL[17] A_WL[18] A_WL[19] A_WL[20] A_WL[21] A_WL[22] A_WL[23] A_WL[24]
+ A_WL[25] A_WL[26] A_WL[27] A_WL[28] A_WL[29] A_WL[30] A_WL[31] A_WL[32]
+ A_WL[33] A_WL[34] A_WL[35] A_WL[36] A_WL[37] A_WL[38] A_WL[39] A_WL[40]
+ A_WL[41] A_WL[42] A_WL[43] A_WL[44] A_WL[45] A_WL[46] A_WL[47] A_WL[48]
+ A_WL[49] A_WL[50] A_WL[51] A_WL[52] A_WL[53] A_WL[54] A_WL[55] A_WL[56]
+ A_WL[57] A_WL[58] A_WL[59] A_WL[60] A_WL[61] A_WL[62] A_WL[63] A_WL[64]
+ A_WL[65] A_WL[66] A_WL[67] A_WL[68] A_WL[69] A_WL[70] A_WL[71] A_WL[72]
+ A_WL[73] A_WL[74] A_WL[75] A_WL[76] A_WL[77] A_WL[78] A_WL[79] A_WL[80]
+ A_WL[81] A_WL[82] A_WL[83] A_WL[84] A_WL[85] A_WL[86] A_WL[87] A_WL[88]
+ A_WL[89] A_WL[90] A_WL[91] A_WL[92] A_WL[93] A_WL[94] A_WL[95] A_WL[96]
+ A_WL[97] A_WL[98] A_WL[99] A_WL[100] A_WL[101] A_WL[102] A_WL[103] A_WL[104]
+ A_WL[105] A_WL[106] A_WL[107] A_WL[108] A_WL[109] A_WL[110] A_WL[111]
+ A_WL[112] A_WL[113] A_WL[114] A_WL[115] A_WL[116] A_WL[117] A_WL[118]
+ A_WL[119] A_WL[120] A_WL[121] A_WL[122] A_WL[123] A_WL[124] A_WL[125]
+ A_WL[126] A_WL[127] A_WL[128] A_WL[129] A_WL[130] A_WL[131] A_WL[132]
+ A_WL[133] A_WL[134] A_WL[135] A_WL[136] A_WL[137] A_WL[138] A_WL[139]
+ A_WL[140] A_WL[141] A_WL[142] A_WL[143] A_WL[144] A_WL[145] A_WL[146]
+ A_WL[147] A_WL[148] A_WL[149] A_WL[150] A_WL[151] A_WL[152] A_WL[153]
+ A_WL[154] A_WL[155] A_WL[156] A_WL[157] A_WL[158] A_WL[159] A_WL[160]
+ A_WL[161] A_WL[162] A_WL[163] A_WL[164] A_WL[165] A_WL[166] A_WL[167]
+ A_WL[168] A_WL[169] A_WL[170] A_WL[171] A_WL[172] A_WL[173] A_WL[174]
+ A_WL[175] A_WL[176] A_WL[177] A_WL[178] A_WL[179] A_WL[180] A_WL[181]
+ A_WL[182] A_WL[183] A_WL[184] A_WL[185] A_WL[186] A_WL[187] A_WL[188]
+ A_WL[189] A_WL[190] A_WL[191] A_WL[192] A_WL[193] A_WL[194] A_WL[195]
+ A_WL[196] A_WL[197] A_WL[198] A_WL[199] A_WL[200] A_WL[201] A_WL[202]
+ A_WL[203] A_WL[204] A_WL[205] A_WL[206] A_WL[207] A_WL[208] A_WL[209]
+ A_WL[210] A_WL[211] A_WL[212] A_WL[213] A_WL[214] A_WL[215] A_WL[216]
+ A_WL[217] A_WL[218] A_WL[219] A_WL[220] A_WL[221] A_WL[222] A_WL[223]
+ A_WL[224] A_WL[225] A_WL[226] A_WL[227] A_WL[228] A_WL[229] A_WL[230]
+ A_WL[231] A_WL[232] A_WL[233] A_WL[234] A_WL[235] A_WL[236] A_WL[237]
+ A_WL[238] A_WL[239] A_WL[240] A_WL[241] A_WL[242] A_WL[243] A_WL[244]
+ A_WL[245] A_WL[246] A_WL[247] A_WL[248] A_WL[249] A_WL[250] A_WL[251]
+ A_WL[252] A_WL[253] A_WL[254] A_WL[255] B_WL[0] B_WL[1] B_WL[2] B_WL[3]
+ B_WL[4] B_WL[5] B_WL[6] B_WL[7] B_WL[8] B_WL[9] B_WL[10] B_WL[11] B_WL[12]
+ B_WL[13] B_WL[14] B_WL[15] B_WL[16] B_WL[17] B_WL[18] B_WL[19] B_WL[20]
+ B_WL[21] B_WL[22] B_WL[23] B_WL[24] B_WL[25] B_WL[26] B_WL[27] B_WL[28]
+ B_WL[29] B_WL[30] B_WL[31] B_WL[32] B_WL[33] B_WL[34] B_WL[35] B_WL[36]
+ B_WL[37] B_WL[38] B_WL[39] B_WL[40] B_WL[41] B_WL[42] B_WL[43] B_WL[44]
+ B_WL[45] B_WL[46] B_WL[47] B_WL[48] B_WL[49] B_WL[50] B_WL[51] B_WL[52]
+ B_WL[53] B_WL[54] B_WL[55] B_WL[56] B_WL[57] B_WL[58] B_WL[59] B_WL[60]
+ B_WL[61] B_WL[62] B_WL[63] B_WL[64] B_WL[65] B_WL[66] B_WL[67] B_WL[68]
+ B_WL[69] B_WL[70] B_WL[71] B_WL[72] B_WL[73] B_WL[74] B_WL[75] B_WL[76]
+ B_WL[77] B_WL[78] B_WL[79] B_WL[80] B_WL[81] B_WL[82] B_WL[83] B_WL[84]
+ B_WL[85] B_WL[86] B_WL[87] B_WL[88] B_WL[89] B_WL[90] B_WL[91] B_WL[92]
+ B_WL[93] B_WL[94] B_WL[95] B_WL[96] B_WL[97] B_WL[98] B_WL[99] B_WL[100]
+ B_WL[101] B_WL[102] B_WL[103] B_WL[104] B_WL[105] B_WL[106] B_WL[107]
+ B_WL[108] B_WL[109] B_WL[110] B_WL[111] B_WL[112] B_WL[113] B_WL[114]
+ B_WL[115] B_WL[116] B_WL[117] B_WL[118] B_WL[119] B_WL[120] B_WL[121]
+ B_WL[122] B_WL[123] B_WL[124] B_WL[125] B_WL[126] B_WL[127] B_WL[128]
+ B_WL[129] B_WL[130] B_WL[131] B_WL[132] B_WL[133] B_WL[134] B_WL[135]
+ B_WL[136] B_WL[137] B_WL[138] B_WL[139] B_WL[140] B_WL[141] B_WL[142]
+ B_WL[143] B_WL[144] B_WL[145] B_WL[146] B_WL[147] B_WL[148] B_WL[149]
+ B_WL[150] B_WL[151] B_WL[152] B_WL[153] B_WL[154] B_WL[155] B_WL[156]
+ B_WL[157] B_WL[158] B_WL[159] B_WL[160] B_WL[161] B_WL[162] B_WL[163]
+ B_WL[164] B_WL[165] B_WL[166] B_WL[167] B_WL[168] B_WL[169] B_WL[170]
+ B_WL[171] B_WL[172] B_WL[173] B_WL[174] B_WL[175] B_WL[176] B_WL[177]
+ B_WL[178] B_WL[179] B_WL[180] B_WL[181] B_WL[182] B_WL[183] B_WL[184]
+ B_WL[185] B_WL[186] B_WL[187] B_WL[188] B_WL[189] B_WL[190] B_WL[191]
+ B_WL[192] B_WL[193] B_WL[194] B_WL[195] B_WL[196] B_WL[197] B_WL[198]
+ B_WL[199] B_WL[200] B_WL[201] B_WL[202] B_WL[203] B_WL[204] B_WL[205]
+ B_WL[206] B_WL[207] B_WL[208] B_WL[209] B_WL[210] B_WL[211] B_WL[212]
+ B_WL[213] B_WL[214] B_WL[215] B_WL[216] B_WL[217] B_WL[218] B_WL[219]
+ B_WL[220] B_WL[221] B_WL[222] B_WL[223] B_WL[224] B_WL[225] B_WL[226]
+ B_WL[227] B_WL[228] B_WL[229] B_WL[230] B_WL[231] B_WL[232] B_WL[233]
+ B_WL[234] B_WL[235] B_WL[236] B_WL[237] B_WL[238] B_WL[239] B_WL[240]
+ B_WL[241] B_WL[242] B_WL[243] B_WL[244] B_WL[245] B_WL[246] B_WL[247]
+ B_WL[248] B_WL[249] B_WL[250] B_WL[251] B_WL[252] B_WL[253] B_WL[254]
+ B_WL[255] A_RDL[0] A_SMPRS_0[3] A_SMPRS_0[2] A_SMPRS_0[1] A_SMPRS_0[0]
+ A_SOE[0] A_WRTL[0] A_YSEL_0[7] A_YSEL_0[6] A_YSEL_0[5] A_YSEL_0[4]
+ A_YSEL_0[3] A_YSEL_0[2] A_YSEL_0[1] A_YSEL_0[0] B_RDL[0] B_SMPRS_0[3]
+ B_SMPRS_0[2] B_SMPRS_0[1] B_SMPRS_0[0] B_SOE[0] B_WRTL[0] B_YSEL_0[7]
+ B_YSEL_0[6] B_YSEL_0[5] B_YSEL_0[4] B_YSEL_0[3] B_YSEL_0[2] B_YSEL_0[1]
+ B_YSEL_0[0] AWTI BWEBA[3] BWEBMA[3] A_CKD DA[3] A_DLRS DMA[3] A_WENB[3]
+ A_WENB[2] A_WENB[1] A_WENB[0] BISTC BISTT BWEBB[3] BWEBMB[3] B_CKD DB[3]
+ B_DLRS DMB[3] B_WENB[3] B_WENB[2] B_WENB[1] B_WENB[0] QA[3] QB[3]
+  SDL400W20S_NBITSLC
XBIT4 A_WL[0] A_WL[1] A_WL[2] A_WL[3] A_WL[4] A_WL[5] A_WL[6] A_WL[7] A_WL[8]
+ A_WL[9] A_WL[10] A_WL[11] A_WL[12] A_WL[13] A_WL[14] A_WL[15] A_WL[16]
+ A_WL[17] A_WL[18] A_WL[19] A_WL[20] A_WL[21] A_WL[22] A_WL[23] A_WL[24]
+ A_WL[25] A_WL[26] A_WL[27] A_WL[28] A_WL[29] A_WL[30] A_WL[31] A_WL[32]
+ A_WL[33] A_WL[34] A_WL[35] A_WL[36] A_WL[37] A_WL[38] A_WL[39] A_WL[40]
+ A_WL[41] A_WL[42] A_WL[43] A_WL[44] A_WL[45] A_WL[46] A_WL[47] A_WL[48]
+ A_WL[49] A_WL[50] A_WL[51] A_WL[52] A_WL[53] A_WL[54] A_WL[55] A_WL[56]
+ A_WL[57] A_WL[58] A_WL[59] A_WL[60] A_WL[61] A_WL[62] A_WL[63] A_WL[64]
+ A_WL[65] A_WL[66] A_WL[67] A_WL[68] A_WL[69] A_WL[70] A_WL[71] A_WL[72]
+ A_WL[73] A_WL[74] A_WL[75] A_WL[76] A_WL[77] A_WL[78] A_WL[79] A_WL[80]
+ A_WL[81] A_WL[82] A_WL[83] A_WL[84] A_WL[85] A_WL[86] A_WL[87] A_WL[88]
+ A_WL[89] A_WL[90] A_WL[91] A_WL[92] A_WL[93] A_WL[94] A_WL[95] A_WL[96]
+ A_WL[97] A_WL[98] A_WL[99] A_WL[100] A_WL[101] A_WL[102] A_WL[103] A_WL[104]
+ A_WL[105] A_WL[106] A_WL[107] A_WL[108] A_WL[109] A_WL[110] A_WL[111]
+ A_WL[112] A_WL[113] A_WL[114] A_WL[115] A_WL[116] A_WL[117] A_WL[118]
+ A_WL[119] A_WL[120] A_WL[121] A_WL[122] A_WL[123] A_WL[124] A_WL[125]
+ A_WL[126] A_WL[127] A_WL[128] A_WL[129] A_WL[130] A_WL[131] A_WL[132]
+ A_WL[133] A_WL[134] A_WL[135] A_WL[136] A_WL[137] A_WL[138] A_WL[139]
+ A_WL[140] A_WL[141] A_WL[142] A_WL[143] A_WL[144] A_WL[145] A_WL[146]
+ A_WL[147] A_WL[148] A_WL[149] A_WL[150] A_WL[151] A_WL[152] A_WL[153]
+ A_WL[154] A_WL[155] A_WL[156] A_WL[157] A_WL[158] A_WL[159] A_WL[160]
+ A_WL[161] A_WL[162] A_WL[163] A_WL[164] A_WL[165] A_WL[166] A_WL[167]
+ A_WL[168] A_WL[169] A_WL[170] A_WL[171] A_WL[172] A_WL[173] A_WL[174]
+ A_WL[175] A_WL[176] A_WL[177] A_WL[178] A_WL[179] A_WL[180] A_WL[181]
+ A_WL[182] A_WL[183] A_WL[184] A_WL[185] A_WL[186] A_WL[187] A_WL[188]
+ A_WL[189] A_WL[190] A_WL[191] A_WL[192] A_WL[193] A_WL[194] A_WL[195]
+ A_WL[196] A_WL[197] A_WL[198] A_WL[199] A_WL[200] A_WL[201] A_WL[202]
+ A_WL[203] A_WL[204] A_WL[205] A_WL[206] A_WL[207] A_WL[208] A_WL[209]
+ A_WL[210] A_WL[211] A_WL[212] A_WL[213] A_WL[214] A_WL[215] A_WL[216]
+ A_WL[217] A_WL[218] A_WL[219] A_WL[220] A_WL[221] A_WL[222] A_WL[223]
+ A_WL[224] A_WL[225] A_WL[226] A_WL[227] A_WL[228] A_WL[229] A_WL[230]
+ A_WL[231] A_WL[232] A_WL[233] A_WL[234] A_WL[235] A_WL[236] A_WL[237]
+ A_WL[238] A_WL[239] A_WL[240] A_WL[241] A_WL[242] A_WL[243] A_WL[244]
+ A_WL[245] A_WL[246] A_WL[247] A_WL[248] A_WL[249] A_WL[250] A_WL[251]
+ A_WL[252] A_WL[253] A_WL[254] A_WL[255] B_WL[0] B_WL[1] B_WL[2] B_WL[3]
+ B_WL[4] B_WL[5] B_WL[6] B_WL[7] B_WL[8] B_WL[9] B_WL[10] B_WL[11] B_WL[12]
+ B_WL[13] B_WL[14] B_WL[15] B_WL[16] B_WL[17] B_WL[18] B_WL[19] B_WL[20]
+ B_WL[21] B_WL[22] B_WL[23] B_WL[24] B_WL[25] B_WL[26] B_WL[27] B_WL[28]
+ B_WL[29] B_WL[30] B_WL[31] B_WL[32] B_WL[33] B_WL[34] B_WL[35] B_WL[36]
+ B_WL[37] B_WL[38] B_WL[39] B_WL[40] B_WL[41] B_WL[42] B_WL[43] B_WL[44]
+ B_WL[45] B_WL[46] B_WL[47] B_WL[48] B_WL[49] B_WL[50] B_WL[51] B_WL[52]
+ B_WL[53] B_WL[54] B_WL[55] B_WL[56] B_WL[57] B_WL[58] B_WL[59] B_WL[60]
+ B_WL[61] B_WL[62] B_WL[63] B_WL[64] B_WL[65] B_WL[66] B_WL[67] B_WL[68]
+ B_WL[69] B_WL[70] B_WL[71] B_WL[72] B_WL[73] B_WL[74] B_WL[75] B_WL[76]
+ B_WL[77] B_WL[78] B_WL[79] B_WL[80] B_WL[81] B_WL[82] B_WL[83] B_WL[84]
+ B_WL[85] B_WL[86] B_WL[87] B_WL[88] B_WL[89] B_WL[90] B_WL[91] B_WL[92]
+ B_WL[93] B_WL[94] B_WL[95] B_WL[96] B_WL[97] B_WL[98] B_WL[99] B_WL[100]
+ B_WL[101] B_WL[102] B_WL[103] B_WL[104] B_WL[105] B_WL[106] B_WL[107]
+ B_WL[108] B_WL[109] B_WL[110] B_WL[111] B_WL[112] B_WL[113] B_WL[114]
+ B_WL[115] B_WL[116] B_WL[117] B_WL[118] B_WL[119] B_WL[120] B_WL[121]
+ B_WL[122] B_WL[123] B_WL[124] B_WL[125] B_WL[126] B_WL[127] B_WL[128]
+ B_WL[129] B_WL[130] B_WL[131] B_WL[132] B_WL[133] B_WL[134] B_WL[135]
+ B_WL[136] B_WL[137] B_WL[138] B_WL[139] B_WL[140] B_WL[141] B_WL[142]
+ B_WL[143] B_WL[144] B_WL[145] B_WL[146] B_WL[147] B_WL[148] B_WL[149]
+ B_WL[150] B_WL[151] B_WL[152] B_WL[153] B_WL[154] B_WL[155] B_WL[156]
+ B_WL[157] B_WL[158] B_WL[159] B_WL[160] B_WL[161] B_WL[162] B_WL[163]
+ B_WL[164] B_WL[165] B_WL[166] B_WL[167] B_WL[168] B_WL[169] B_WL[170]
+ B_WL[171] B_WL[172] B_WL[173] B_WL[174] B_WL[175] B_WL[176] B_WL[177]
+ B_WL[178] B_WL[179] B_WL[180] B_WL[181] B_WL[182] B_WL[183] B_WL[184]
+ B_WL[185] B_WL[186] B_WL[187] B_WL[188] B_WL[189] B_WL[190] B_WL[191]
+ B_WL[192] B_WL[193] B_WL[194] B_WL[195] B_WL[196] B_WL[197] B_WL[198]
+ B_WL[199] B_WL[200] B_WL[201] B_WL[202] B_WL[203] B_WL[204] B_WL[205]
+ B_WL[206] B_WL[207] B_WL[208] B_WL[209] B_WL[210] B_WL[211] B_WL[212]
+ B_WL[213] B_WL[214] B_WL[215] B_WL[216] B_WL[217] B_WL[218] B_WL[219]
+ B_WL[220] B_WL[221] B_WL[222] B_WL[223] B_WL[224] B_WL[225] B_WL[226]
+ B_WL[227] B_WL[228] B_WL[229] B_WL[230] B_WL[231] B_WL[232] B_WL[233]
+ B_WL[234] B_WL[235] B_WL[236] B_WL[237] B_WL[238] B_WL[239] B_WL[240]
+ B_WL[241] B_WL[242] B_WL[243] B_WL[244] B_WL[245] B_WL[246] B_WL[247]
+ B_WL[248] B_WL[249] B_WL[250] B_WL[251] B_WL[252] B_WL[253] B_WL[254]
+ B_WL[255] A_RDL[0] A_SMPRS_0[3] A_SMPRS_0[2] A_SMPRS_0[1] A_SMPRS_0[0]
+ A_SOE[0] A_WRTL[0] A_YSEL_0[7] A_YSEL_0[6] A_YSEL_0[5] A_YSEL_0[4]
+ A_YSEL_0[3] A_YSEL_0[2] A_YSEL_0[1] A_YSEL_0[0] B_RDL[0] B_SMPRS_0[3]
+ B_SMPRS_0[2] B_SMPRS_0[1] B_SMPRS_0[0] B_SOE[0] B_WRTL[0] B_YSEL_0[7]
+ B_YSEL_0[6] B_YSEL_0[5] B_YSEL_0[4] B_YSEL_0[3] B_YSEL_0[2] B_YSEL_0[1]
+ B_YSEL_0[0] AWTI BWEBA[4] BWEBMA[4] A_CKD DA[4] A_DLRS DMA[4] A_WENB[3]
+ A_WENB[2] A_WENB[1] A_WENB[0] BISTC BISTT BWEBB[4] BWEBMB[4] B_CKD DB[4]
+ B_DLRS DMB[4] B_WENB[3] B_WENB[2] B_WENB[1] B_WENB[0] QA[4] QB[4]
+  SDL400W20S_NBITSLC
XBIT5 A_WL[0] A_WL[1] A_WL[2] A_WL[3] A_WL[4] A_WL[5] A_WL[6] A_WL[7] A_WL[8]
+ A_WL[9] A_WL[10] A_WL[11] A_WL[12] A_WL[13] A_WL[14] A_WL[15] A_WL[16]
+ A_WL[17] A_WL[18] A_WL[19] A_WL[20] A_WL[21] A_WL[22] A_WL[23] A_WL[24]
+ A_WL[25] A_WL[26] A_WL[27] A_WL[28] A_WL[29] A_WL[30] A_WL[31] A_WL[32]
+ A_WL[33] A_WL[34] A_WL[35] A_WL[36] A_WL[37] A_WL[38] A_WL[39] A_WL[40]
+ A_WL[41] A_WL[42] A_WL[43] A_WL[44] A_WL[45] A_WL[46] A_WL[47] A_WL[48]
+ A_WL[49] A_WL[50] A_WL[51] A_WL[52] A_WL[53] A_WL[54] A_WL[55] A_WL[56]
+ A_WL[57] A_WL[58] A_WL[59] A_WL[60] A_WL[61] A_WL[62] A_WL[63] A_WL[64]
+ A_WL[65] A_WL[66] A_WL[67] A_WL[68] A_WL[69] A_WL[70] A_WL[71] A_WL[72]
+ A_WL[73] A_WL[74] A_WL[75] A_WL[76] A_WL[77] A_WL[78] A_WL[79] A_WL[80]
+ A_WL[81] A_WL[82] A_WL[83] A_WL[84] A_WL[85] A_WL[86] A_WL[87] A_WL[88]
+ A_WL[89] A_WL[90] A_WL[91] A_WL[92] A_WL[93] A_WL[94] A_WL[95] A_WL[96]
+ A_WL[97] A_WL[98] A_WL[99] A_WL[100] A_WL[101] A_WL[102] A_WL[103] A_WL[104]
+ A_WL[105] A_WL[106] A_WL[107] A_WL[108] A_WL[109] A_WL[110] A_WL[111]
+ A_WL[112] A_WL[113] A_WL[114] A_WL[115] A_WL[116] A_WL[117] A_WL[118]
+ A_WL[119] A_WL[120] A_WL[121] A_WL[122] A_WL[123] A_WL[124] A_WL[125]
+ A_WL[126] A_WL[127] A_WL[128] A_WL[129] A_WL[130] A_WL[131] A_WL[132]
+ A_WL[133] A_WL[134] A_WL[135] A_WL[136] A_WL[137] A_WL[138] A_WL[139]
+ A_WL[140] A_WL[141] A_WL[142] A_WL[143] A_WL[144] A_WL[145] A_WL[146]
+ A_WL[147] A_WL[148] A_WL[149] A_WL[150] A_WL[151] A_WL[152] A_WL[153]
+ A_WL[154] A_WL[155] A_WL[156] A_WL[157] A_WL[158] A_WL[159] A_WL[160]
+ A_WL[161] A_WL[162] A_WL[163] A_WL[164] A_WL[165] A_WL[166] A_WL[167]
+ A_WL[168] A_WL[169] A_WL[170] A_WL[171] A_WL[172] A_WL[173] A_WL[174]
+ A_WL[175] A_WL[176] A_WL[177] A_WL[178] A_WL[179] A_WL[180] A_WL[181]
+ A_WL[182] A_WL[183] A_WL[184] A_WL[185] A_WL[186] A_WL[187] A_WL[188]
+ A_WL[189] A_WL[190] A_WL[191] A_WL[192] A_WL[193] A_WL[194] A_WL[195]
+ A_WL[196] A_WL[197] A_WL[198] A_WL[199] A_WL[200] A_WL[201] A_WL[202]
+ A_WL[203] A_WL[204] A_WL[205] A_WL[206] A_WL[207] A_WL[208] A_WL[209]
+ A_WL[210] A_WL[211] A_WL[212] A_WL[213] A_WL[214] A_WL[215] A_WL[216]
+ A_WL[217] A_WL[218] A_WL[219] A_WL[220] A_WL[221] A_WL[222] A_WL[223]
+ A_WL[224] A_WL[225] A_WL[226] A_WL[227] A_WL[228] A_WL[229] A_WL[230]
+ A_WL[231] A_WL[232] A_WL[233] A_WL[234] A_WL[235] A_WL[236] A_WL[237]
+ A_WL[238] A_WL[239] A_WL[240] A_WL[241] A_WL[242] A_WL[243] A_WL[244]
+ A_WL[245] A_WL[246] A_WL[247] A_WL[248] A_WL[249] A_WL[250] A_WL[251]
+ A_WL[252] A_WL[253] A_WL[254] A_WL[255] B_WL[0] B_WL[1] B_WL[2] B_WL[3]
+ B_WL[4] B_WL[5] B_WL[6] B_WL[7] B_WL[8] B_WL[9] B_WL[10] B_WL[11] B_WL[12]
+ B_WL[13] B_WL[14] B_WL[15] B_WL[16] B_WL[17] B_WL[18] B_WL[19] B_WL[20]
+ B_WL[21] B_WL[22] B_WL[23] B_WL[24] B_WL[25] B_WL[26] B_WL[27] B_WL[28]
+ B_WL[29] B_WL[30] B_WL[31] B_WL[32] B_WL[33] B_WL[34] B_WL[35] B_WL[36]
+ B_WL[37] B_WL[38] B_WL[39] B_WL[40] B_WL[41] B_WL[42] B_WL[43] B_WL[44]
+ B_WL[45] B_WL[46] B_WL[47] B_WL[48] B_WL[49] B_WL[50] B_WL[51] B_WL[52]
+ B_WL[53] B_WL[54] B_WL[55] B_WL[56] B_WL[57] B_WL[58] B_WL[59] B_WL[60]
+ B_WL[61] B_WL[62] B_WL[63] B_WL[64] B_WL[65] B_WL[66] B_WL[67] B_WL[68]
+ B_WL[69] B_WL[70] B_WL[71] B_WL[72] B_WL[73] B_WL[74] B_WL[75] B_WL[76]
+ B_WL[77] B_WL[78] B_WL[79] B_WL[80] B_WL[81] B_WL[82] B_WL[83] B_WL[84]
+ B_WL[85] B_WL[86] B_WL[87] B_WL[88] B_WL[89] B_WL[90] B_WL[91] B_WL[92]
+ B_WL[93] B_WL[94] B_WL[95] B_WL[96] B_WL[97] B_WL[98] B_WL[99] B_WL[100]
+ B_WL[101] B_WL[102] B_WL[103] B_WL[104] B_WL[105] B_WL[106] B_WL[107]
+ B_WL[108] B_WL[109] B_WL[110] B_WL[111] B_WL[112] B_WL[113] B_WL[114]
+ B_WL[115] B_WL[116] B_WL[117] B_WL[118] B_WL[119] B_WL[120] B_WL[121]
+ B_WL[122] B_WL[123] B_WL[124] B_WL[125] B_WL[126] B_WL[127] B_WL[128]
+ B_WL[129] B_WL[130] B_WL[131] B_WL[132] B_WL[133] B_WL[134] B_WL[135]
+ B_WL[136] B_WL[137] B_WL[138] B_WL[139] B_WL[140] B_WL[141] B_WL[142]
+ B_WL[143] B_WL[144] B_WL[145] B_WL[146] B_WL[147] B_WL[148] B_WL[149]
+ B_WL[150] B_WL[151] B_WL[152] B_WL[153] B_WL[154] B_WL[155] B_WL[156]
+ B_WL[157] B_WL[158] B_WL[159] B_WL[160] B_WL[161] B_WL[162] B_WL[163]
+ B_WL[164] B_WL[165] B_WL[166] B_WL[167] B_WL[168] B_WL[169] B_WL[170]
+ B_WL[171] B_WL[172] B_WL[173] B_WL[174] B_WL[175] B_WL[176] B_WL[177]
+ B_WL[178] B_WL[179] B_WL[180] B_WL[181] B_WL[182] B_WL[183] B_WL[184]
+ B_WL[185] B_WL[186] B_WL[187] B_WL[188] B_WL[189] B_WL[190] B_WL[191]
+ B_WL[192] B_WL[193] B_WL[194] B_WL[195] B_WL[196] B_WL[197] B_WL[198]
+ B_WL[199] B_WL[200] B_WL[201] B_WL[202] B_WL[203] B_WL[204] B_WL[205]
+ B_WL[206] B_WL[207] B_WL[208] B_WL[209] B_WL[210] B_WL[211] B_WL[212]
+ B_WL[213] B_WL[214] B_WL[215] B_WL[216] B_WL[217] B_WL[218] B_WL[219]
+ B_WL[220] B_WL[221] B_WL[222] B_WL[223] B_WL[224] B_WL[225] B_WL[226]
+ B_WL[227] B_WL[228] B_WL[229] B_WL[230] B_WL[231] B_WL[232] B_WL[233]
+ B_WL[234] B_WL[235] B_WL[236] B_WL[237] B_WL[238] B_WL[239] B_WL[240]
+ B_WL[241] B_WL[242] B_WL[243] B_WL[244] B_WL[245] B_WL[246] B_WL[247]
+ B_WL[248] B_WL[249] B_WL[250] B_WL[251] B_WL[252] B_WL[253] B_WL[254]
+ B_WL[255] A_RDL[0] A_SMPRS_0[3] A_SMPRS_0[2] A_SMPRS_0[1] A_SMPRS_0[0]
+ A_SOE[0] A_WRTL[0] A_YSEL_0[7] A_YSEL_0[6] A_YSEL_0[5] A_YSEL_0[4]
+ A_YSEL_0[3] A_YSEL_0[2] A_YSEL_0[1] A_YSEL_0[0] B_RDL[0] B_SMPRS_0[3]
+ B_SMPRS_0[2] B_SMPRS_0[1] B_SMPRS_0[0] B_SOE[0] B_WRTL[0] B_YSEL_0[7]
+ B_YSEL_0[6] B_YSEL_0[5] B_YSEL_0[4] B_YSEL_0[3] B_YSEL_0[2] B_YSEL_0[1]
+ B_YSEL_0[0] AWTI BWEBA[5] BWEBMA[5] A_CKD DA[5] A_DLRS DMA[5] A_WENB[3]
+ A_WENB[2] A_WENB[1] A_WENB[0] BISTC BISTT BWEBB[5] BWEBMB[5] B_CKD DB[5]
+ B_DLRS DMB[5] B_WENB[3] B_WENB[2] B_WENB[1] B_WENB[0] QA[5] QB[5]
+  SDL400W20S_NBITSLC
XBIT6 A_WL[0] A_WL[1] A_WL[2] A_WL[3] A_WL[4] A_WL[5] A_WL[6] A_WL[7] A_WL[8]
+ A_WL[9] A_WL[10] A_WL[11] A_WL[12] A_WL[13] A_WL[14] A_WL[15] A_WL[16]
+ A_WL[17] A_WL[18] A_WL[19] A_WL[20] A_WL[21] A_WL[22] A_WL[23] A_WL[24]
+ A_WL[25] A_WL[26] A_WL[27] A_WL[28] A_WL[29] A_WL[30] A_WL[31] A_WL[32]
+ A_WL[33] A_WL[34] A_WL[35] A_WL[36] A_WL[37] A_WL[38] A_WL[39] A_WL[40]
+ A_WL[41] A_WL[42] A_WL[43] A_WL[44] A_WL[45] A_WL[46] A_WL[47] A_WL[48]
+ A_WL[49] A_WL[50] A_WL[51] A_WL[52] A_WL[53] A_WL[54] A_WL[55] A_WL[56]
+ A_WL[57] A_WL[58] A_WL[59] A_WL[60] A_WL[61] A_WL[62] A_WL[63] A_WL[64]
+ A_WL[65] A_WL[66] A_WL[67] A_WL[68] A_WL[69] A_WL[70] A_WL[71] A_WL[72]
+ A_WL[73] A_WL[74] A_WL[75] A_WL[76] A_WL[77] A_WL[78] A_WL[79] A_WL[80]
+ A_WL[81] A_WL[82] A_WL[83] A_WL[84] A_WL[85] A_WL[86] A_WL[87] A_WL[88]
+ A_WL[89] A_WL[90] A_WL[91] A_WL[92] A_WL[93] A_WL[94] A_WL[95] A_WL[96]
+ A_WL[97] A_WL[98] A_WL[99] A_WL[100] A_WL[101] A_WL[102] A_WL[103] A_WL[104]
+ A_WL[105] A_WL[106] A_WL[107] A_WL[108] A_WL[109] A_WL[110] A_WL[111]
+ A_WL[112] A_WL[113] A_WL[114] A_WL[115] A_WL[116] A_WL[117] A_WL[118]
+ A_WL[119] A_WL[120] A_WL[121] A_WL[122] A_WL[123] A_WL[124] A_WL[125]
+ A_WL[126] A_WL[127] A_WL[128] A_WL[129] A_WL[130] A_WL[131] A_WL[132]
+ A_WL[133] A_WL[134] A_WL[135] A_WL[136] A_WL[137] A_WL[138] A_WL[139]
+ A_WL[140] A_WL[141] A_WL[142] A_WL[143] A_WL[144] A_WL[145] A_WL[146]
+ A_WL[147] A_WL[148] A_WL[149] A_WL[150] A_WL[151] A_WL[152] A_WL[153]
+ A_WL[154] A_WL[155] A_WL[156] A_WL[157] A_WL[158] A_WL[159] A_WL[160]
+ A_WL[161] A_WL[162] A_WL[163] A_WL[164] A_WL[165] A_WL[166] A_WL[167]
+ A_WL[168] A_WL[169] A_WL[170] A_WL[171] A_WL[172] A_WL[173] A_WL[174]
+ A_WL[175] A_WL[176] A_WL[177] A_WL[178] A_WL[179] A_WL[180] A_WL[181]
+ A_WL[182] A_WL[183] A_WL[184] A_WL[185] A_WL[186] A_WL[187] A_WL[188]
+ A_WL[189] A_WL[190] A_WL[191] A_WL[192] A_WL[193] A_WL[194] A_WL[195]
+ A_WL[196] A_WL[197] A_WL[198] A_WL[199] A_WL[200] A_WL[201] A_WL[202]
+ A_WL[203] A_WL[204] A_WL[205] A_WL[206] A_WL[207] A_WL[208] A_WL[209]
+ A_WL[210] A_WL[211] A_WL[212] A_WL[213] A_WL[214] A_WL[215] A_WL[216]
+ A_WL[217] A_WL[218] A_WL[219] A_WL[220] A_WL[221] A_WL[222] A_WL[223]
+ A_WL[224] A_WL[225] A_WL[226] A_WL[227] A_WL[228] A_WL[229] A_WL[230]
+ A_WL[231] A_WL[232] A_WL[233] A_WL[234] A_WL[235] A_WL[236] A_WL[237]
+ A_WL[238] A_WL[239] A_WL[240] A_WL[241] A_WL[242] A_WL[243] A_WL[244]
+ A_WL[245] A_WL[246] A_WL[247] A_WL[248] A_WL[249] A_WL[250] A_WL[251]
+ A_WL[252] A_WL[253] A_WL[254] A_WL[255] B_WL[0] B_WL[1] B_WL[2] B_WL[3]
+ B_WL[4] B_WL[5] B_WL[6] B_WL[7] B_WL[8] B_WL[9] B_WL[10] B_WL[11] B_WL[12]
+ B_WL[13] B_WL[14] B_WL[15] B_WL[16] B_WL[17] B_WL[18] B_WL[19] B_WL[20]
+ B_WL[21] B_WL[22] B_WL[23] B_WL[24] B_WL[25] B_WL[26] B_WL[27] B_WL[28]
+ B_WL[29] B_WL[30] B_WL[31] B_WL[32] B_WL[33] B_WL[34] B_WL[35] B_WL[36]
+ B_WL[37] B_WL[38] B_WL[39] B_WL[40] B_WL[41] B_WL[42] B_WL[43] B_WL[44]
+ B_WL[45] B_WL[46] B_WL[47] B_WL[48] B_WL[49] B_WL[50] B_WL[51] B_WL[52]
+ B_WL[53] B_WL[54] B_WL[55] B_WL[56] B_WL[57] B_WL[58] B_WL[59] B_WL[60]
+ B_WL[61] B_WL[62] B_WL[63] B_WL[64] B_WL[65] B_WL[66] B_WL[67] B_WL[68]
+ B_WL[69] B_WL[70] B_WL[71] B_WL[72] B_WL[73] B_WL[74] B_WL[75] B_WL[76]
+ B_WL[77] B_WL[78] B_WL[79] B_WL[80] B_WL[81] B_WL[82] B_WL[83] B_WL[84]
+ B_WL[85] B_WL[86] B_WL[87] B_WL[88] B_WL[89] B_WL[90] B_WL[91] B_WL[92]
+ B_WL[93] B_WL[94] B_WL[95] B_WL[96] B_WL[97] B_WL[98] B_WL[99] B_WL[100]
+ B_WL[101] B_WL[102] B_WL[103] B_WL[104] B_WL[105] B_WL[106] B_WL[107]
+ B_WL[108] B_WL[109] B_WL[110] B_WL[111] B_WL[112] B_WL[113] B_WL[114]
+ B_WL[115] B_WL[116] B_WL[117] B_WL[118] B_WL[119] B_WL[120] B_WL[121]
+ B_WL[122] B_WL[123] B_WL[124] B_WL[125] B_WL[126] B_WL[127] B_WL[128]
+ B_WL[129] B_WL[130] B_WL[131] B_WL[132] B_WL[133] B_WL[134] B_WL[135]
+ B_WL[136] B_WL[137] B_WL[138] B_WL[139] B_WL[140] B_WL[141] B_WL[142]
+ B_WL[143] B_WL[144] B_WL[145] B_WL[146] B_WL[147] B_WL[148] B_WL[149]
+ B_WL[150] B_WL[151] B_WL[152] B_WL[153] B_WL[154] B_WL[155] B_WL[156]
+ B_WL[157] B_WL[158] B_WL[159] B_WL[160] B_WL[161] B_WL[162] B_WL[163]
+ B_WL[164] B_WL[165] B_WL[166] B_WL[167] B_WL[168] B_WL[169] B_WL[170]
+ B_WL[171] B_WL[172] B_WL[173] B_WL[174] B_WL[175] B_WL[176] B_WL[177]
+ B_WL[178] B_WL[179] B_WL[180] B_WL[181] B_WL[182] B_WL[183] B_WL[184]
+ B_WL[185] B_WL[186] B_WL[187] B_WL[188] B_WL[189] B_WL[190] B_WL[191]
+ B_WL[192] B_WL[193] B_WL[194] B_WL[195] B_WL[196] B_WL[197] B_WL[198]
+ B_WL[199] B_WL[200] B_WL[201] B_WL[202] B_WL[203] B_WL[204] B_WL[205]
+ B_WL[206] B_WL[207] B_WL[208] B_WL[209] B_WL[210] B_WL[211] B_WL[212]
+ B_WL[213] B_WL[214] B_WL[215] B_WL[216] B_WL[217] B_WL[218] B_WL[219]
+ B_WL[220] B_WL[221] B_WL[222] B_WL[223] B_WL[224] B_WL[225] B_WL[226]
+ B_WL[227] B_WL[228] B_WL[229] B_WL[230] B_WL[231] B_WL[232] B_WL[233]
+ B_WL[234] B_WL[235] B_WL[236] B_WL[237] B_WL[238] B_WL[239] B_WL[240]
+ B_WL[241] B_WL[242] B_WL[243] B_WL[244] B_WL[245] B_WL[246] B_WL[247]
+ B_WL[248] B_WL[249] B_WL[250] B_WL[251] B_WL[252] B_WL[253] B_WL[254]
+ B_WL[255] A_RDL[0] A_SMPRS_0[3] A_SMPRS_0[2] A_SMPRS_0[1] A_SMPRS_0[0]
+ A_SOE[0] A_WRTL[0] A_YSEL_0[7] A_YSEL_0[6] A_YSEL_0[5] A_YSEL_0[4]
+ A_YSEL_0[3] A_YSEL_0[2] A_YSEL_0[1] A_YSEL_0[0] B_RDL[0] B_SMPRS_0[3]
+ B_SMPRS_0[2] B_SMPRS_0[1] B_SMPRS_0[0] B_SOE[0] B_WRTL[0] B_YSEL_0[7]
+ B_YSEL_0[6] B_YSEL_0[5] B_YSEL_0[4] B_YSEL_0[3] B_YSEL_0[2] B_YSEL_0[1]
+ B_YSEL_0[0] AWTI BWEBA[6] BWEBMA[6] A_CKD DA[6] A_DLRS DMA[6] A_WENB[3]
+ A_WENB[2] A_WENB[1] A_WENB[0] BISTC BISTT BWEBB[6] BWEBMB[6] B_CKD DB[6]
+ B_DLRS DMB[6] B_WENB[3] B_WENB[2] B_WENB[1] B_WENB[0] QA[6] QB[6]
+  SDL400W20S_NBITSLC
XBIT7 A_WL[0] A_WL[1] A_WL[2] A_WL[3] A_WL[4] A_WL[5] A_WL[6] A_WL[7] A_WL[8]
+ A_WL[9] A_WL[10] A_WL[11] A_WL[12] A_WL[13] A_WL[14] A_WL[15] A_WL[16]
+ A_WL[17] A_WL[18] A_WL[19] A_WL[20] A_WL[21] A_WL[22] A_WL[23] A_WL[24]
+ A_WL[25] A_WL[26] A_WL[27] A_WL[28] A_WL[29] A_WL[30] A_WL[31] A_WL[32]
+ A_WL[33] A_WL[34] A_WL[35] A_WL[36] A_WL[37] A_WL[38] A_WL[39] A_WL[40]
+ A_WL[41] A_WL[42] A_WL[43] A_WL[44] A_WL[45] A_WL[46] A_WL[47] A_WL[48]
+ A_WL[49] A_WL[50] A_WL[51] A_WL[52] A_WL[53] A_WL[54] A_WL[55] A_WL[56]
+ A_WL[57] A_WL[58] A_WL[59] A_WL[60] A_WL[61] A_WL[62] A_WL[63] A_WL[64]
+ A_WL[65] A_WL[66] A_WL[67] A_WL[68] A_WL[69] A_WL[70] A_WL[71] A_WL[72]
+ A_WL[73] A_WL[74] A_WL[75] A_WL[76] A_WL[77] A_WL[78] A_WL[79] A_WL[80]
+ A_WL[81] A_WL[82] A_WL[83] A_WL[84] A_WL[85] A_WL[86] A_WL[87] A_WL[88]
+ A_WL[89] A_WL[90] A_WL[91] A_WL[92] A_WL[93] A_WL[94] A_WL[95] A_WL[96]
+ A_WL[97] A_WL[98] A_WL[99] A_WL[100] A_WL[101] A_WL[102] A_WL[103] A_WL[104]
+ A_WL[105] A_WL[106] A_WL[107] A_WL[108] A_WL[109] A_WL[110] A_WL[111]
+ A_WL[112] A_WL[113] A_WL[114] A_WL[115] A_WL[116] A_WL[117] A_WL[118]
+ A_WL[119] A_WL[120] A_WL[121] A_WL[122] A_WL[123] A_WL[124] A_WL[125]
+ A_WL[126] A_WL[127] A_WL[128] A_WL[129] A_WL[130] A_WL[131] A_WL[132]
+ A_WL[133] A_WL[134] A_WL[135] A_WL[136] A_WL[137] A_WL[138] A_WL[139]
+ A_WL[140] A_WL[141] A_WL[142] A_WL[143] A_WL[144] A_WL[145] A_WL[146]
+ A_WL[147] A_WL[148] A_WL[149] A_WL[150] A_WL[151] A_WL[152] A_WL[153]
+ A_WL[154] A_WL[155] A_WL[156] A_WL[157] A_WL[158] A_WL[159] A_WL[160]
+ A_WL[161] A_WL[162] A_WL[163] A_WL[164] A_WL[165] A_WL[166] A_WL[167]
+ A_WL[168] A_WL[169] A_WL[170] A_WL[171] A_WL[172] A_WL[173] A_WL[174]
+ A_WL[175] A_WL[176] A_WL[177] A_WL[178] A_WL[179] A_WL[180] A_WL[181]
+ A_WL[182] A_WL[183] A_WL[184] A_WL[185] A_WL[186] A_WL[187] A_WL[188]
+ A_WL[189] A_WL[190] A_WL[191] A_WL[192] A_WL[193] A_WL[194] A_WL[195]
+ A_WL[196] A_WL[197] A_WL[198] A_WL[199] A_WL[200] A_WL[201] A_WL[202]
+ A_WL[203] A_WL[204] A_WL[205] A_WL[206] A_WL[207] A_WL[208] A_WL[209]
+ A_WL[210] A_WL[211] A_WL[212] A_WL[213] A_WL[214] A_WL[215] A_WL[216]
+ A_WL[217] A_WL[218] A_WL[219] A_WL[220] A_WL[221] A_WL[222] A_WL[223]
+ A_WL[224] A_WL[225] A_WL[226] A_WL[227] A_WL[228] A_WL[229] A_WL[230]
+ A_WL[231] A_WL[232] A_WL[233] A_WL[234] A_WL[235] A_WL[236] A_WL[237]
+ A_WL[238] A_WL[239] A_WL[240] A_WL[241] A_WL[242] A_WL[243] A_WL[244]
+ A_WL[245] A_WL[246] A_WL[247] A_WL[248] A_WL[249] A_WL[250] A_WL[251]
+ A_WL[252] A_WL[253] A_WL[254] A_WL[255] B_WL[0] B_WL[1] B_WL[2] B_WL[3]
+ B_WL[4] B_WL[5] B_WL[6] B_WL[7] B_WL[8] B_WL[9] B_WL[10] B_WL[11] B_WL[12]
+ B_WL[13] B_WL[14] B_WL[15] B_WL[16] B_WL[17] B_WL[18] B_WL[19] B_WL[20]
+ B_WL[21] B_WL[22] B_WL[23] B_WL[24] B_WL[25] B_WL[26] B_WL[27] B_WL[28]
+ B_WL[29] B_WL[30] B_WL[31] B_WL[32] B_WL[33] B_WL[34] B_WL[35] B_WL[36]
+ B_WL[37] B_WL[38] B_WL[39] B_WL[40] B_WL[41] B_WL[42] B_WL[43] B_WL[44]
+ B_WL[45] B_WL[46] B_WL[47] B_WL[48] B_WL[49] B_WL[50] B_WL[51] B_WL[52]
+ B_WL[53] B_WL[54] B_WL[55] B_WL[56] B_WL[57] B_WL[58] B_WL[59] B_WL[60]
+ B_WL[61] B_WL[62] B_WL[63] B_WL[64] B_WL[65] B_WL[66] B_WL[67] B_WL[68]
+ B_WL[69] B_WL[70] B_WL[71] B_WL[72] B_WL[73] B_WL[74] B_WL[75] B_WL[76]
+ B_WL[77] B_WL[78] B_WL[79] B_WL[80] B_WL[81] B_WL[82] B_WL[83] B_WL[84]
+ B_WL[85] B_WL[86] B_WL[87] B_WL[88] B_WL[89] B_WL[90] B_WL[91] B_WL[92]
+ B_WL[93] B_WL[94] B_WL[95] B_WL[96] B_WL[97] B_WL[98] B_WL[99] B_WL[100]
+ B_WL[101] B_WL[102] B_WL[103] B_WL[104] B_WL[105] B_WL[106] B_WL[107]
+ B_WL[108] B_WL[109] B_WL[110] B_WL[111] B_WL[112] B_WL[113] B_WL[114]
+ B_WL[115] B_WL[116] B_WL[117] B_WL[118] B_WL[119] B_WL[120] B_WL[121]
+ B_WL[122] B_WL[123] B_WL[124] B_WL[125] B_WL[126] B_WL[127] B_WL[128]
+ B_WL[129] B_WL[130] B_WL[131] B_WL[132] B_WL[133] B_WL[134] B_WL[135]
+ B_WL[136] B_WL[137] B_WL[138] B_WL[139] B_WL[140] B_WL[141] B_WL[142]
+ B_WL[143] B_WL[144] B_WL[145] B_WL[146] B_WL[147] B_WL[148] B_WL[149]
+ B_WL[150] B_WL[151] B_WL[152] B_WL[153] B_WL[154] B_WL[155] B_WL[156]
+ B_WL[157] B_WL[158] B_WL[159] B_WL[160] B_WL[161] B_WL[162] B_WL[163]
+ B_WL[164] B_WL[165] B_WL[166] B_WL[167] B_WL[168] B_WL[169] B_WL[170]
+ B_WL[171] B_WL[172] B_WL[173] B_WL[174] B_WL[175] B_WL[176] B_WL[177]
+ B_WL[178] B_WL[179] B_WL[180] B_WL[181] B_WL[182] B_WL[183] B_WL[184]
+ B_WL[185] B_WL[186] B_WL[187] B_WL[188] B_WL[189] B_WL[190] B_WL[191]
+ B_WL[192] B_WL[193] B_WL[194] B_WL[195] B_WL[196] B_WL[197] B_WL[198]
+ B_WL[199] B_WL[200] B_WL[201] B_WL[202] B_WL[203] B_WL[204] B_WL[205]
+ B_WL[206] B_WL[207] B_WL[208] B_WL[209] B_WL[210] B_WL[211] B_WL[212]
+ B_WL[213] B_WL[214] B_WL[215] B_WL[216] B_WL[217] B_WL[218] B_WL[219]
+ B_WL[220] B_WL[221] B_WL[222] B_WL[223] B_WL[224] B_WL[225] B_WL[226]
+ B_WL[227] B_WL[228] B_WL[229] B_WL[230] B_WL[231] B_WL[232] B_WL[233]
+ B_WL[234] B_WL[235] B_WL[236] B_WL[237] B_WL[238] B_WL[239] B_WL[240]
+ B_WL[241] B_WL[242] B_WL[243] B_WL[244] B_WL[245] B_WL[246] B_WL[247]
+ B_WL[248] B_WL[249] B_WL[250] B_WL[251] B_WL[252] B_WL[253] B_WL[254]
+ B_WL[255] A_RDL[0] A_SMPRS_0[3] A_SMPRS_0[2] A_SMPRS_0[1] A_SMPRS_0[0]
+ A_SOE[0] A_WRTL[0] A_YSEL_0[7] A_YSEL_0[6] A_YSEL_0[5] A_YSEL_0[4]
+ A_YSEL_0[3] A_YSEL_0[2] A_YSEL_0[1] A_YSEL_0[0] B_RDL[0] B_SMPRS_0[3]
+ B_SMPRS_0[2] B_SMPRS_0[1] B_SMPRS_0[0] B_SOE[0] B_WRTL[0] B_YSEL_0[7]
+ B_YSEL_0[6] B_YSEL_0[5] B_YSEL_0[4] B_YSEL_0[3] B_YSEL_0[2] B_YSEL_0[1]
+ B_YSEL_0[0] AWTI BWEBA[7] BWEBMA[7] A_CKD DA[7] A_DLRS DMA[7] A_WENB[3]
+ A_WENB[2] A_WENB[1] A_WENB[0] BISTC BISTT BWEBB[7] BWEBMB[7] B_CKD DB[7]
+ B_DLRS DMB[7] B_WENB[3] B_WENB[2] B_WENB[1] B_WENB[0] QA[7] QB[7]
+  SDL400W20S_NBITSLC
XBIT8 A_WL[0] A_WL[1] A_WL[2] A_WL[3] A_WL[4] A_WL[5] A_WL[6] A_WL[7] A_WL[8]
+ A_WL[9] A_WL[10] A_WL[11] A_WL[12] A_WL[13] A_WL[14] A_WL[15] A_WL[16]
+ A_WL[17] A_WL[18] A_WL[19] A_WL[20] A_WL[21] A_WL[22] A_WL[23] A_WL[24]
+ A_WL[25] A_WL[26] A_WL[27] A_WL[28] A_WL[29] A_WL[30] A_WL[31] A_WL[32]
+ A_WL[33] A_WL[34] A_WL[35] A_WL[36] A_WL[37] A_WL[38] A_WL[39] A_WL[40]
+ A_WL[41] A_WL[42] A_WL[43] A_WL[44] A_WL[45] A_WL[46] A_WL[47] A_WL[48]
+ A_WL[49] A_WL[50] A_WL[51] A_WL[52] A_WL[53] A_WL[54] A_WL[55] A_WL[56]
+ A_WL[57] A_WL[58] A_WL[59] A_WL[60] A_WL[61] A_WL[62] A_WL[63] A_WL[64]
+ A_WL[65] A_WL[66] A_WL[67] A_WL[68] A_WL[69] A_WL[70] A_WL[71] A_WL[72]
+ A_WL[73] A_WL[74] A_WL[75] A_WL[76] A_WL[77] A_WL[78] A_WL[79] A_WL[80]
+ A_WL[81] A_WL[82] A_WL[83] A_WL[84] A_WL[85] A_WL[86] A_WL[87] A_WL[88]
+ A_WL[89] A_WL[90] A_WL[91] A_WL[92] A_WL[93] A_WL[94] A_WL[95] A_WL[96]
+ A_WL[97] A_WL[98] A_WL[99] A_WL[100] A_WL[101] A_WL[102] A_WL[103] A_WL[104]
+ A_WL[105] A_WL[106] A_WL[107] A_WL[108] A_WL[109] A_WL[110] A_WL[111]
+ A_WL[112] A_WL[113] A_WL[114] A_WL[115] A_WL[116] A_WL[117] A_WL[118]
+ A_WL[119] A_WL[120] A_WL[121] A_WL[122] A_WL[123] A_WL[124] A_WL[125]
+ A_WL[126] A_WL[127] A_WL[128] A_WL[129] A_WL[130] A_WL[131] A_WL[132]
+ A_WL[133] A_WL[134] A_WL[135] A_WL[136] A_WL[137] A_WL[138] A_WL[139]
+ A_WL[140] A_WL[141] A_WL[142] A_WL[143] A_WL[144] A_WL[145] A_WL[146]
+ A_WL[147] A_WL[148] A_WL[149] A_WL[150] A_WL[151] A_WL[152] A_WL[153]
+ A_WL[154] A_WL[155] A_WL[156] A_WL[157] A_WL[158] A_WL[159] A_WL[160]
+ A_WL[161] A_WL[162] A_WL[163] A_WL[164] A_WL[165] A_WL[166] A_WL[167]
+ A_WL[168] A_WL[169] A_WL[170] A_WL[171] A_WL[172] A_WL[173] A_WL[174]
+ A_WL[175] A_WL[176] A_WL[177] A_WL[178] A_WL[179] A_WL[180] A_WL[181]
+ A_WL[182] A_WL[183] A_WL[184] A_WL[185] A_WL[186] A_WL[187] A_WL[188]
+ A_WL[189] A_WL[190] A_WL[191] A_WL[192] A_WL[193] A_WL[194] A_WL[195]
+ A_WL[196] A_WL[197] A_WL[198] A_WL[199] A_WL[200] A_WL[201] A_WL[202]
+ A_WL[203] A_WL[204] A_WL[205] A_WL[206] A_WL[207] A_WL[208] A_WL[209]
+ A_WL[210] A_WL[211] A_WL[212] A_WL[213] A_WL[214] A_WL[215] A_WL[216]
+ A_WL[217] A_WL[218] A_WL[219] A_WL[220] A_WL[221] A_WL[222] A_WL[223]
+ A_WL[224] A_WL[225] A_WL[226] A_WL[227] A_WL[228] A_WL[229] A_WL[230]
+ A_WL[231] A_WL[232] A_WL[233] A_WL[234] A_WL[235] A_WL[236] A_WL[237]
+ A_WL[238] A_WL[239] A_WL[240] A_WL[241] A_WL[242] A_WL[243] A_WL[244]
+ A_WL[245] A_WL[246] A_WL[247] A_WL[248] A_WL[249] A_WL[250] A_WL[251]
+ A_WL[252] A_WL[253] A_WL[254] A_WL[255] B_WL[0] B_WL[1] B_WL[2] B_WL[3]
+ B_WL[4] B_WL[5] B_WL[6] B_WL[7] B_WL[8] B_WL[9] B_WL[10] B_WL[11] B_WL[12]
+ B_WL[13] B_WL[14] B_WL[15] B_WL[16] B_WL[17] B_WL[18] B_WL[19] B_WL[20]
+ B_WL[21] B_WL[22] B_WL[23] B_WL[24] B_WL[25] B_WL[26] B_WL[27] B_WL[28]
+ B_WL[29] B_WL[30] B_WL[31] B_WL[32] B_WL[33] B_WL[34] B_WL[35] B_WL[36]
+ B_WL[37] B_WL[38] B_WL[39] B_WL[40] B_WL[41] B_WL[42] B_WL[43] B_WL[44]
+ B_WL[45] B_WL[46] B_WL[47] B_WL[48] B_WL[49] B_WL[50] B_WL[51] B_WL[52]
+ B_WL[53] B_WL[54] B_WL[55] B_WL[56] B_WL[57] B_WL[58] B_WL[59] B_WL[60]
+ B_WL[61] B_WL[62] B_WL[63] B_WL[64] B_WL[65] B_WL[66] B_WL[67] B_WL[68]
+ B_WL[69] B_WL[70] B_WL[71] B_WL[72] B_WL[73] B_WL[74] B_WL[75] B_WL[76]
+ B_WL[77] B_WL[78] B_WL[79] B_WL[80] B_WL[81] B_WL[82] B_WL[83] B_WL[84]
+ B_WL[85] B_WL[86] B_WL[87] B_WL[88] B_WL[89] B_WL[90] B_WL[91] B_WL[92]
+ B_WL[93] B_WL[94] B_WL[95] B_WL[96] B_WL[97] B_WL[98] B_WL[99] B_WL[100]
+ B_WL[101] B_WL[102] B_WL[103] B_WL[104] B_WL[105] B_WL[106] B_WL[107]
+ B_WL[108] B_WL[109] B_WL[110] B_WL[111] B_WL[112] B_WL[113] B_WL[114]
+ B_WL[115] B_WL[116] B_WL[117] B_WL[118] B_WL[119] B_WL[120] B_WL[121]
+ B_WL[122] B_WL[123] B_WL[124] B_WL[125] B_WL[126] B_WL[127] B_WL[128]
+ B_WL[129] B_WL[130] B_WL[131] B_WL[132] B_WL[133] B_WL[134] B_WL[135]
+ B_WL[136] B_WL[137] B_WL[138] B_WL[139] B_WL[140] B_WL[141] B_WL[142]
+ B_WL[143] B_WL[144] B_WL[145] B_WL[146] B_WL[147] B_WL[148] B_WL[149]
+ B_WL[150] B_WL[151] B_WL[152] B_WL[153] B_WL[154] B_WL[155] B_WL[156]
+ B_WL[157] B_WL[158] B_WL[159] B_WL[160] B_WL[161] B_WL[162] B_WL[163]
+ B_WL[164] B_WL[165] B_WL[166] B_WL[167] B_WL[168] B_WL[169] B_WL[170]
+ B_WL[171] B_WL[172] B_WL[173] B_WL[174] B_WL[175] B_WL[176] B_WL[177]
+ B_WL[178] B_WL[179] B_WL[180] B_WL[181] B_WL[182] B_WL[183] B_WL[184]
+ B_WL[185] B_WL[186] B_WL[187] B_WL[188] B_WL[189] B_WL[190] B_WL[191]
+ B_WL[192] B_WL[193] B_WL[194] B_WL[195] B_WL[196] B_WL[197] B_WL[198]
+ B_WL[199] B_WL[200] B_WL[201] B_WL[202] B_WL[203] B_WL[204] B_WL[205]
+ B_WL[206] B_WL[207] B_WL[208] B_WL[209] B_WL[210] B_WL[211] B_WL[212]
+ B_WL[213] B_WL[214] B_WL[215] B_WL[216] B_WL[217] B_WL[218] B_WL[219]
+ B_WL[220] B_WL[221] B_WL[222] B_WL[223] B_WL[224] B_WL[225] B_WL[226]
+ B_WL[227] B_WL[228] B_WL[229] B_WL[230] B_WL[231] B_WL[232] B_WL[233]
+ B_WL[234] B_WL[235] B_WL[236] B_WL[237] B_WL[238] B_WL[239] B_WL[240]
+ B_WL[241] B_WL[242] B_WL[243] B_WL[244] B_WL[245] B_WL[246] B_WL[247]
+ B_WL[248] B_WL[249] B_WL[250] B_WL[251] B_WL[252] B_WL[253] B_WL[254]
+ B_WL[255] A_RDL[0] A_SMPRS_0[3] A_SMPRS_0[2] A_SMPRS_0[1] A_SMPRS_0[0]
+ A_SOE[0] A_WRTL[0] A_YSEL_0[7] A_YSEL_0[6] A_YSEL_0[5] A_YSEL_0[4]
+ A_YSEL_0[3] A_YSEL_0[2] A_YSEL_0[1] A_YSEL_0[0] B_RDL[0] B_SMPRS_0[3]
+ B_SMPRS_0[2] B_SMPRS_0[1] B_SMPRS_0[0] B_SOE[0] B_WRTL[0] B_YSEL_0[7]
+ B_YSEL_0[6] B_YSEL_0[5] B_YSEL_0[4] B_YSEL_0[3] B_YSEL_0[2] B_YSEL_0[1]
+ B_YSEL_0[0] AWTI BWEBA[8] BWEBMA[8] A_CKD DA[8] A_DLRS DMA[8] A_WENB[3]
+ A_WENB[2] A_WENB[1] A_WENB[0] BISTC BISTT BWEBB[8] BWEBMB[8] B_CKD DB[8]
+ B_DLRS DMB[8] B_WENB[3] B_WENB[2] B_WENB[1] B_WENB[0] QA[8] QB[8]
+  SDL400W20S_NBITSLC
XBIT9 A_WL[0] A_WL[1] A_WL[2] A_WL[3] A_WL[4] A_WL[5] A_WL[6] A_WL[7] A_WL[8]
+ A_WL[9] A_WL[10] A_WL[11] A_WL[12] A_WL[13] A_WL[14] A_WL[15] A_WL[16]
+ A_WL[17] A_WL[18] A_WL[19] A_WL[20] A_WL[21] A_WL[22] A_WL[23] A_WL[24]
+ A_WL[25] A_WL[26] A_WL[27] A_WL[28] A_WL[29] A_WL[30] A_WL[31] A_WL[32]
+ A_WL[33] A_WL[34] A_WL[35] A_WL[36] A_WL[37] A_WL[38] A_WL[39] A_WL[40]
+ A_WL[41] A_WL[42] A_WL[43] A_WL[44] A_WL[45] A_WL[46] A_WL[47] A_WL[48]
+ A_WL[49] A_WL[50] A_WL[51] A_WL[52] A_WL[53] A_WL[54] A_WL[55] A_WL[56]
+ A_WL[57] A_WL[58] A_WL[59] A_WL[60] A_WL[61] A_WL[62] A_WL[63] A_WL[64]
+ A_WL[65] A_WL[66] A_WL[67] A_WL[68] A_WL[69] A_WL[70] A_WL[71] A_WL[72]
+ A_WL[73] A_WL[74] A_WL[75] A_WL[76] A_WL[77] A_WL[78] A_WL[79] A_WL[80]
+ A_WL[81] A_WL[82] A_WL[83] A_WL[84] A_WL[85] A_WL[86] A_WL[87] A_WL[88]
+ A_WL[89] A_WL[90] A_WL[91] A_WL[92] A_WL[93] A_WL[94] A_WL[95] A_WL[96]
+ A_WL[97] A_WL[98] A_WL[99] A_WL[100] A_WL[101] A_WL[102] A_WL[103] A_WL[104]
+ A_WL[105] A_WL[106] A_WL[107] A_WL[108] A_WL[109] A_WL[110] A_WL[111]
+ A_WL[112] A_WL[113] A_WL[114] A_WL[115] A_WL[116] A_WL[117] A_WL[118]
+ A_WL[119] A_WL[120] A_WL[121] A_WL[122] A_WL[123] A_WL[124] A_WL[125]
+ A_WL[126] A_WL[127] A_WL[128] A_WL[129] A_WL[130] A_WL[131] A_WL[132]
+ A_WL[133] A_WL[134] A_WL[135] A_WL[136] A_WL[137] A_WL[138] A_WL[139]
+ A_WL[140] A_WL[141] A_WL[142] A_WL[143] A_WL[144] A_WL[145] A_WL[146]
+ A_WL[147] A_WL[148] A_WL[149] A_WL[150] A_WL[151] A_WL[152] A_WL[153]
+ A_WL[154] A_WL[155] A_WL[156] A_WL[157] A_WL[158] A_WL[159] A_WL[160]
+ A_WL[161] A_WL[162] A_WL[163] A_WL[164] A_WL[165] A_WL[166] A_WL[167]
+ A_WL[168] A_WL[169] A_WL[170] A_WL[171] A_WL[172] A_WL[173] A_WL[174]
+ A_WL[175] A_WL[176] A_WL[177] A_WL[178] A_WL[179] A_WL[180] A_WL[181]
+ A_WL[182] A_WL[183] A_WL[184] A_WL[185] A_WL[186] A_WL[187] A_WL[188]
+ A_WL[189] A_WL[190] A_WL[191] A_WL[192] A_WL[193] A_WL[194] A_WL[195]
+ A_WL[196] A_WL[197] A_WL[198] A_WL[199] A_WL[200] A_WL[201] A_WL[202]
+ A_WL[203] A_WL[204] A_WL[205] A_WL[206] A_WL[207] A_WL[208] A_WL[209]
+ A_WL[210] A_WL[211] A_WL[212] A_WL[213] A_WL[214] A_WL[215] A_WL[216]
+ A_WL[217] A_WL[218] A_WL[219] A_WL[220] A_WL[221] A_WL[222] A_WL[223]
+ A_WL[224] A_WL[225] A_WL[226] A_WL[227] A_WL[228] A_WL[229] A_WL[230]
+ A_WL[231] A_WL[232] A_WL[233] A_WL[234] A_WL[235] A_WL[236] A_WL[237]
+ A_WL[238] A_WL[239] A_WL[240] A_WL[241] A_WL[242] A_WL[243] A_WL[244]
+ A_WL[245] A_WL[246] A_WL[247] A_WL[248] A_WL[249] A_WL[250] A_WL[251]
+ A_WL[252] A_WL[253] A_WL[254] A_WL[255] B_WL[0] B_WL[1] B_WL[2] B_WL[3]
+ B_WL[4] B_WL[5] B_WL[6] B_WL[7] B_WL[8] B_WL[9] B_WL[10] B_WL[11] B_WL[12]
+ B_WL[13] B_WL[14] B_WL[15] B_WL[16] B_WL[17] B_WL[18] B_WL[19] B_WL[20]
+ B_WL[21] B_WL[22] B_WL[23] B_WL[24] B_WL[25] B_WL[26] B_WL[27] B_WL[28]
+ B_WL[29] B_WL[30] B_WL[31] B_WL[32] B_WL[33] B_WL[34] B_WL[35] B_WL[36]
+ B_WL[37] B_WL[38] B_WL[39] B_WL[40] B_WL[41] B_WL[42] B_WL[43] B_WL[44]
+ B_WL[45] B_WL[46] B_WL[47] B_WL[48] B_WL[49] B_WL[50] B_WL[51] B_WL[52]
+ B_WL[53] B_WL[54] B_WL[55] B_WL[56] B_WL[57] B_WL[58] B_WL[59] B_WL[60]
+ B_WL[61] B_WL[62] B_WL[63] B_WL[64] B_WL[65] B_WL[66] B_WL[67] B_WL[68]
+ B_WL[69] B_WL[70] B_WL[71] B_WL[72] B_WL[73] B_WL[74] B_WL[75] B_WL[76]
+ B_WL[77] B_WL[78] B_WL[79] B_WL[80] B_WL[81] B_WL[82] B_WL[83] B_WL[84]
+ B_WL[85] B_WL[86] B_WL[87] B_WL[88] B_WL[89] B_WL[90] B_WL[91] B_WL[92]
+ B_WL[93] B_WL[94] B_WL[95] B_WL[96] B_WL[97] B_WL[98] B_WL[99] B_WL[100]
+ B_WL[101] B_WL[102] B_WL[103] B_WL[104] B_WL[105] B_WL[106] B_WL[107]
+ B_WL[108] B_WL[109] B_WL[110] B_WL[111] B_WL[112] B_WL[113] B_WL[114]
+ B_WL[115] B_WL[116] B_WL[117] B_WL[118] B_WL[119] B_WL[120] B_WL[121]
+ B_WL[122] B_WL[123] B_WL[124] B_WL[125] B_WL[126] B_WL[127] B_WL[128]
+ B_WL[129] B_WL[130] B_WL[131] B_WL[132] B_WL[133] B_WL[134] B_WL[135]
+ B_WL[136] B_WL[137] B_WL[138] B_WL[139] B_WL[140] B_WL[141] B_WL[142]
+ B_WL[143] B_WL[144] B_WL[145] B_WL[146] B_WL[147] B_WL[148] B_WL[149]
+ B_WL[150] B_WL[151] B_WL[152] B_WL[153] B_WL[154] B_WL[155] B_WL[156]
+ B_WL[157] B_WL[158] B_WL[159] B_WL[160] B_WL[161] B_WL[162] B_WL[163]
+ B_WL[164] B_WL[165] B_WL[166] B_WL[167] B_WL[168] B_WL[169] B_WL[170]
+ B_WL[171] B_WL[172] B_WL[173] B_WL[174] B_WL[175] B_WL[176] B_WL[177]
+ B_WL[178] B_WL[179] B_WL[180] B_WL[181] B_WL[182] B_WL[183] B_WL[184]
+ B_WL[185] B_WL[186] B_WL[187] B_WL[188] B_WL[189] B_WL[190] B_WL[191]
+ B_WL[192] B_WL[193] B_WL[194] B_WL[195] B_WL[196] B_WL[197] B_WL[198]
+ B_WL[199] B_WL[200] B_WL[201] B_WL[202] B_WL[203] B_WL[204] B_WL[205]
+ B_WL[206] B_WL[207] B_WL[208] B_WL[209] B_WL[210] B_WL[211] B_WL[212]
+ B_WL[213] B_WL[214] B_WL[215] B_WL[216] B_WL[217] B_WL[218] B_WL[219]
+ B_WL[220] B_WL[221] B_WL[222] B_WL[223] B_WL[224] B_WL[225] B_WL[226]
+ B_WL[227] B_WL[228] B_WL[229] B_WL[230] B_WL[231] B_WL[232] B_WL[233]
+ B_WL[234] B_WL[235] B_WL[236] B_WL[237] B_WL[238] B_WL[239] B_WL[240]
+ B_WL[241] B_WL[242] B_WL[243] B_WL[244] B_WL[245] B_WL[246] B_WL[247]
+ B_WL[248] B_WL[249] B_WL[250] B_WL[251] B_WL[252] B_WL[253] B_WL[254]
+ B_WL[255] A_RDL[0] A_SMPRS_0[3] A_SMPRS_0[2] A_SMPRS_0[1] A_SMPRS_0[0]
+ A_SOE[0] A_WRTL[0] A_YSEL_0[7] A_YSEL_0[6] A_YSEL_0[5] A_YSEL_0[4]
+ A_YSEL_0[3] A_YSEL_0[2] A_YSEL_0[1] A_YSEL_0[0] B_RDL[0] B_SMPRS_0[3]
+ B_SMPRS_0[2] B_SMPRS_0[1] B_SMPRS_0[0] B_SOE[0] B_WRTL[0] B_YSEL_0[7]
+ B_YSEL_0[6] B_YSEL_0[5] B_YSEL_0[4] B_YSEL_0[3] B_YSEL_0[2] B_YSEL_0[1]
+ B_YSEL_0[0] AWTI BWEBA[9] BWEBMA[9] A_CKD DA[9] A_DLRS DMA[9] A_WENB[3]
+ A_WENB[2] A_WENB[1] A_WENB[0] BISTC BISTT BWEBB[9] BWEBMB[9] B_CKD DB[9]
+ B_DLRS DMB[9] B_WENB[3] B_WENB[2] B_WENB[1] B_WENB[0] QA[9] QB[9]
+  SDL400W20S_NBITSLC
XBIT10 A_WL[0] A_WL[1] A_WL[2] A_WL[3] A_WL[4] A_WL[5] A_WL[6] A_WL[7] A_WL[8]
+ A_WL[9] A_WL[10] A_WL[11] A_WL[12] A_WL[13] A_WL[14] A_WL[15] A_WL[16]
+ A_WL[17] A_WL[18] A_WL[19] A_WL[20] A_WL[21] A_WL[22] A_WL[23] A_WL[24]
+ A_WL[25] A_WL[26] A_WL[27] A_WL[28] A_WL[29] A_WL[30] A_WL[31] A_WL[32]
+ A_WL[33] A_WL[34] A_WL[35] A_WL[36] A_WL[37] A_WL[38] A_WL[39] A_WL[40]
+ A_WL[41] A_WL[42] A_WL[43] A_WL[44] A_WL[45] A_WL[46] A_WL[47] A_WL[48]
+ A_WL[49] A_WL[50] A_WL[51] A_WL[52] A_WL[53] A_WL[54] A_WL[55] A_WL[56]
+ A_WL[57] A_WL[58] A_WL[59] A_WL[60] A_WL[61] A_WL[62] A_WL[63] A_WL[64]
+ A_WL[65] A_WL[66] A_WL[67] A_WL[68] A_WL[69] A_WL[70] A_WL[71] A_WL[72]
+ A_WL[73] A_WL[74] A_WL[75] A_WL[76] A_WL[77] A_WL[78] A_WL[79] A_WL[80]
+ A_WL[81] A_WL[82] A_WL[83] A_WL[84] A_WL[85] A_WL[86] A_WL[87] A_WL[88]
+ A_WL[89] A_WL[90] A_WL[91] A_WL[92] A_WL[93] A_WL[94] A_WL[95] A_WL[96]
+ A_WL[97] A_WL[98] A_WL[99] A_WL[100] A_WL[101] A_WL[102] A_WL[103] A_WL[104]
+ A_WL[105] A_WL[106] A_WL[107] A_WL[108] A_WL[109] A_WL[110] A_WL[111]
+ A_WL[112] A_WL[113] A_WL[114] A_WL[115] A_WL[116] A_WL[117] A_WL[118]
+ A_WL[119] A_WL[120] A_WL[121] A_WL[122] A_WL[123] A_WL[124] A_WL[125]
+ A_WL[126] A_WL[127] A_WL[128] A_WL[129] A_WL[130] A_WL[131] A_WL[132]
+ A_WL[133] A_WL[134] A_WL[135] A_WL[136] A_WL[137] A_WL[138] A_WL[139]
+ A_WL[140] A_WL[141] A_WL[142] A_WL[143] A_WL[144] A_WL[145] A_WL[146]
+ A_WL[147] A_WL[148] A_WL[149] A_WL[150] A_WL[151] A_WL[152] A_WL[153]
+ A_WL[154] A_WL[155] A_WL[156] A_WL[157] A_WL[158] A_WL[159] A_WL[160]
+ A_WL[161] A_WL[162] A_WL[163] A_WL[164] A_WL[165] A_WL[166] A_WL[167]
+ A_WL[168] A_WL[169] A_WL[170] A_WL[171] A_WL[172] A_WL[173] A_WL[174]
+ A_WL[175] A_WL[176] A_WL[177] A_WL[178] A_WL[179] A_WL[180] A_WL[181]
+ A_WL[182] A_WL[183] A_WL[184] A_WL[185] A_WL[186] A_WL[187] A_WL[188]
+ A_WL[189] A_WL[190] A_WL[191] A_WL[192] A_WL[193] A_WL[194] A_WL[195]
+ A_WL[196] A_WL[197] A_WL[198] A_WL[199] A_WL[200] A_WL[201] A_WL[202]
+ A_WL[203] A_WL[204] A_WL[205] A_WL[206] A_WL[207] A_WL[208] A_WL[209]
+ A_WL[210] A_WL[211] A_WL[212] A_WL[213] A_WL[214] A_WL[215] A_WL[216]
+ A_WL[217] A_WL[218] A_WL[219] A_WL[220] A_WL[221] A_WL[222] A_WL[223]
+ A_WL[224] A_WL[225] A_WL[226] A_WL[227] A_WL[228] A_WL[229] A_WL[230]
+ A_WL[231] A_WL[232] A_WL[233] A_WL[234] A_WL[235] A_WL[236] A_WL[237]
+ A_WL[238] A_WL[239] A_WL[240] A_WL[241] A_WL[242] A_WL[243] A_WL[244]
+ A_WL[245] A_WL[246] A_WL[247] A_WL[248] A_WL[249] A_WL[250] A_WL[251]
+ A_WL[252] A_WL[253] A_WL[254] A_WL[255] B_WL[0] B_WL[1] B_WL[2] B_WL[3]
+ B_WL[4] B_WL[5] B_WL[6] B_WL[7] B_WL[8] B_WL[9] B_WL[10] B_WL[11] B_WL[12]
+ B_WL[13] B_WL[14] B_WL[15] B_WL[16] B_WL[17] B_WL[18] B_WL[19] B_WL[20]
+ B_WL[21] B_WL[22] B_WL[23] B_WL[24] B_WL[25] B_WL[26] B_WL[27] B_WL[28]
+ B_WL[29] B_WL[30] B_WL[31] B_WL[32] B_WL[33] B_WL[34] B_WL[35] B_WL[36]
+ B_WL[37] B_WL[38] B_WL[39] B_WL[40] B_WL[41] B_WL[42] B_WL[43] B_WL[44]
+ B_WL[45] B_WL[46] B_WL[47] B_WL[48] B_WL[49] B_WL[50] B_WL[51] B_WL[52]
+ B_WL[53] B_WL[54] B_WL[55] B_WL[56] B_WL[57] B_WL[58] B_WL[59] B_WL[60]
+ B_WL[61] B_WL[62] B_WL[63] B_WL[64] B_WL[65] B_WL[66] B_WL[67] B_WL[68]
+ B_WL[69] B_WL[70] B_WL[71] B_WL[72] B_WL[73] B_WL[74] B_WL[75] B_WL[76]
+ B_WL[77] B_WL[78] B_WL[79] B_WL[80] B_WL[81] B_WL[82] B_WL[83] B_WL[84]
+ B_WL[85] B_WL[86] B_WL[87] B_WL[88] B_WL[89] B_WL[90] B_WL[91] B_WL[92]
+ B_WL[93] B_WL[94] B_WL[95] B_WL[96] B_WL[97] B_WL[98] B_WL[99] B_WL[100]
+ B_WL[101] B_WL[102] B_WL[103] B_WL[104] B_WL[105] B_WL[106] B_WL[107]
+ B_WL[108] B_WL[109] B_WL[110] B_WL[111] B_WL[112] B_WL[113] B_WL[114]
+ B_WL[115] B_WL[116] B_WL[117] B_WL[118] B_WL[119] B_WL[120] B_WL[121]
+ B_WL[122] B_WL[123] B_WL[124] B_WL[125] B_WL[126] B_WL[127] B_WL[128]
+ B_WL[129] B_WL[130] B_WL[131] B_WL[132] B_WL[133] B_WL[134] B_WL[135]
+ B_WL[136] B_WL[137] B_WL[138] B_WL[139] B_WL[140] B_WL[141] B_WL[142]
+ B_WL[143] B_WL[144] B_WL[145] B_WL[146] B_WL[147] B_WL[148] B_WL[149]
+ B_WL[150] B_WL[151] B_WL[152] B_WL[153] B_WL[154] B_WL[155] B_WL[156]
+ B_WL[157] B_WL[158] B_WL[159] B_WL[160] B_WL[161] B_WL[162] B_WL[163]
+ B_WL[164] B_WL[165] B_WL[166] B_WL[167] B_WL[168] B_WL[169] B_WL[170]
+ B_WL[171] B_WL[172] B_WL[173] B_WL[174] B_WL[175] B_WL[176] B_WL[177]
+ B_WL[178] B_WL[179] B_WL[180] B_WL[181] B_WL[182] B_WL[183] B_WL[184]
+ B_WL[185] B_WL[186] B_WL[187] B_WL[188] B_WL[189] B_WL[190] B_WL[191]
+ B_WL[192] B_WL[193] B_WL[194] B_WL[195] B_WL[196] B_WL[197] B_WL[198]
+ B_WL[199] B_WL[200] B_WL[201] B_WL[202] B_WL[203] B_WL[204] B_WL[205]
+ B_WL[206] B_WL[207] B_WL[208] B_WL[209] B_WL[210] B_WL[211] B_WL[212]
+ B_WL[213] B_WL[214] B_WL[215] B_WL[216] B_WL[217] B_WL[218] B_WL[219]
+ B_WL[220] B_WL[221] B_WL[222] B_WL[223] B_WL[224] B_WL[225] B_WL[226]
+ B_WL[227] B_WL[228] B_WL[229] B_WL[230] B_WL[231] B_WL[232] B_WL[233]
+ B_WL[234] B_WL[235] B_WL[236] B_WL[237] B_WL[238] B_WL[239] B_WL[240]
+ B_WL[241] B_WL[242] B_WL[243] B_WL[244] B_WL[245] B_WL[246] B_WL[247]
+ B_WL[248] B_WL[249] B_WL[250] B_WL[251] B_WL[252] B_WL[253] B_WL[254]
+ B_WL[255] A_RDL[0] A_SMPRS_0[3] A_SMPRS_0[2] A_SMPRS_0[1] A_SMPRS_0[0]
+ A_SOE[0] A_WRTL[0] A_YSEL_0[7] A_YSEL_0[6] A_YSEL_0[5] A_YSEL_0[4]
+ A_YSEL_0[3] A_YSEL_0[2] A_YSEL_0[1] A_YSEL_0[0] B_RDL[0] B_SMPRS_0[3]
+ B_SMPRS_0[2] B_SMPRS_0[1] B_SMPRS_0[0] B_SOE[0] B_WRTL[0] B_YSEL_0[7]
+ B_YSEL_0[6] B_YSEL_0[5] B_YSEL_0[4] B_YSEL_0[3] B_YSEL_0[2] B_YSEL_0[1]
+ B_YSEL_0[0] AWTI BWEBA[10] BWEBMA[10] A_CKD DA[10] A_DLRS DMA[10] A_WENB[3]
+ A_WENB[2] A_WENB[1] A_WENB[0] BISTC BISTT BWEBB[10] BWEBMB[10] B_CKD DB[10]
+ B_DLRS DMB[10] B_WENB[3] B_WENB[2] B_WENB[1] B_WENB[0] QA[10] QB[10]
+  SDL400W20S_NBITSLC
XBIT11 A_WL[0] A_WL[1] A_WL[2] A_WL[3] A_WL[4] A_WL[5] A_WL[6] A_WL[7] A_WL[8]
+ A_WL[9] A_WL[10] A_WL[11] A_WL[12] A_WL[13] A_WL[14] A_WL[15] A_WL[16]
+ A_WL[17] A_WL[18] A_WL[19] A_WL[20] A_WL[21] A_WL[22] A_WL[23] A_WL[24]
+ A_WL[25] A_WL[26] A_WL[27] A_WL[28] A_WL[29] A_WL[30] A_WL[31] A_WL[32]
+ A_WL[33] A_WL[34] A_WL[35] A_WL[36] A_WL[37] A_WL[38] A_WL[39] A_WL[40]
+ A_WL[41] A_WL[42] A_WL[43] A_WL[44] A_WL[45] A_WL[46] A_WL[47] A_WL[48]
+ A_WL[49] A_WL[50] A_WL[51] A_WL[52] A_WL[53] A_WL[54] A_WL[55] A_WL[56]
+ A_WL[57] A_WL[58] A_WL[59] A_WL[60] A_WL[61] A_WL[62] A_WL[63] A_WL[64]
+ A_WL[65] A_WL[66] A_WL[67] A_WL[68] A_WL[69] A_WL[70] A_WL[71] A_WL[72]
+ A_WL[73] A_WL[74] A_WL[75] A_WL[76] A_WL[77] A_WL[78] A_WL[79] A_WL[80]
+ A_WL[81] A_WL[82] A_WL[83] A_WL[84] A_WL[85] A_WL[86] A_WL[87] A_WL[88]
+ A_WL[89] A_WL[90] A_WL[91] A_WL[92] A_WL[93] A_WL[94] A_WL[95] A_WL[96]
+ A_WL[97] A_WL[98] A_WL[99] A_WL[100] A_WL[101] A_WL[102] A_WL[103] A_WL[104]
+ A_WL[105] A_WL[106] A_WL[107] A_WL[108] A_WL[109] A_WL[110] A_WL[111]
+ A_WL[112] A_WL[113] A_WL[114] A_WL[115] A_WL[116] A_WL[117] A_WL[118]
+ A_WL[119] A_WL[120] A_WL[121] A_WL[122] A_WL[123] A_WL[124] A_WL[125]
+ A_WL[126] A_WL[127] A_WL[128] A_WL[129] A_WL[130] A_WL[131] A_WL[132]
+ A_WL[133] A_WL[134] A_WL[135] A_WL[136] A_WL[137] A_WL[138] A_WL[139]
+ A_WL[140] A_WL[141] A_WL[142] A_WL[143] A_WL[144] A_WL[145] A_WL[146]
+ A_WL[147] A_WL[148] A_WL[149] A_WL[150] A_WL[151] A_WL[152] A_WL[153]
+ A_WL[154] A_WL[155] A_WL[156] A_WL[157] A_WL[158] A_WL[159] A_WL[160]
+ A_WL[161] A_WL[162] A_WL[163] A_WL[164] A_WL[165] A_WL[166] A_WL[167]
+ A_WL[168] A_WL[169] A_WL[170] A_WL[171] A_WL[172] A_WL[173] A_WL[174]
+ A_WL[175] A_WL[176] A_WL[177] A_WL[178] A_WL[179] A_WL[180] A_WL[181]
+ A_WL[182] A_WL[183] A_WL[184] A_WL[185] A_WL[186] A_WL[187] A_WL[188]
+ A_WL[189] A_WL[190] A_WL[191] A_WL[192] A_WL[193] A_WL[194] A_WL[195]
+ A_WL[196] A_WL[197] A_WL[198] A_WL[199] A_WL[200] A_WL[201] A_WL[202]
+ A_WL[203] A_WL[204] A_WL[205] A_WL[206] A_WL[207] A_WL[208] A_WL[209]
+ A_WL[210] A_WL[211] A_WL[212] A_WL[213] A_WL[214] A_WL[215] A_WL[216]
+ A_WL[217] A_WL[218] A_WL[219] A_WL[220] A_WL[221] A_WL[222] A_WL[223]
+ A_WL[224] A_WL[225] A_WL[226] A_WL[227] A_WL[228] A_WL[229] A_WL[230]
+ A_WL[231] A_WL[232] A_WL[233] A_WL[234] A_WL[235] A_WL[236] A_WL[237]
+ A_WL[238] A_WL[239] A_WL[240] A_WL[241] A_WL[242] A_WL[243] A_WL[244]
+ A_WL[245] A_WL[246] A_WL[247] A_WL[248] A_WL[249] A_WL[250] A_WL[251]
+ A_WL[252] A_WL[253] A_WL[254] A_WL[255] B_WL[0] B_WL[1] B_WL[2] B_WL[3]
+ B_WL[4] B_WL[5] B_WL[6] B_WL[7] B_WL[8] B_WL[9] B_WL[10] B_WL[11] B_WL[12]
+ B_WL[13] B_WL[14] B_WL[15] B_WL[16] B_WL[17] B_WL[18] B_WL[19] B_WL[20]
+ B_WL[21] B_WL[22] B_WL[23] B_WL[24] B_WL[25] B_WL[26] B_WL[27] B_WL[28]
+ B_WL[29] B_WL[30] B_WL[31] B_WL[32] B_WL[33] B_WL[34] B_WL[35] B_WL[36]
+ B_WL[37] B_WL[38] B_WL[39] B_WL[40] B_WL[41] B_WL[42] B_WL[43] B_WL[44]
+ B_WL[45] B_WL[46] B_WL[47] B_WL[48] B_WL[49] B_WL[50] B_WL[51] B_WL[52]
+ B_WL[53] B_WL[54] B_WL[55] B_WL[56] B_WL[57] B_WL[58] B_WL[59] B_WL[60]
+ B_WL[61] B_WL[62] B_WL[63] B_WL[64] B_WL[65] B_WL[66] B_WL[67] B_WL[68]
+ B_WL[69] B_WL[70] B_WL[71] B_WL[72] B_WL[73] B_WL[74] B_WL[75] B_WL[76]
+ B_WL[77] B_WL[78] B_WL[79] B_WL[80] B_WL[81] B_WL[82] B_WL[83] B_WL[84]
+ B_WL[85] B_WL[86] B_WL[87] B_WL[88] B_WL[89] B_WL[90] B_WL[91] B_WL[92]
+ B_WL[93] B_WL[94] B_WL[95] B_WL[96] B_WL[97] B_WL[98] B_WL[99] B_WL[100]
+ B_WL[101] B_WL[102] B_WL[103] B_WL[104] B_WL[105] B_WL[106] B_WL[107]
+ B_WL[108] B_WL[109] B_WL[110] B_WL[111] B_WL[112] B_WL[113] B_WL[114]
+ B_WL[115] B_WL[116] B_WL[117] B_WL[118] B_WL[119] B_WL[120] B_WL[121]
+ B_WL[122] B_WL[123] B_WL[124] B_WL[125] B_WL[126] B_WL[127] B_WL[128]
+ B_WL[129] B_WL[130] B_WL[131] B_WL[132] B_WL[133] B_WL[134] B_WL[135]
+ B_WL[136] B_WL[137] B_WL[138] B_WL[139] B_WL[140] B_WL[141] B_WL[142]
+ B_WL[143] B_WL[144] B_WL[145] B_WL[146] B_WL[147] B_WL[148] B_WL[149]
+ B_WL[150] B_WL[151] B_WL[152] B_WL[153] B_WL[154] B_WL[155] B_WL[156]
+ B_WL[157] B_WL[158] B_WL[159] B_WL[160] B_WL[161] B_WL[162] B_WL[163]
+ B_WL[164] B_WL[165] B_WL[166] B_WL[167] B_WL[168] B_WL[169] B_WL[170]
+ B_WL[171] B_WL[172] B_WL[173] B_WL[174] B_WL[175] B_WL[176] B_WL[177]
+ B_WL[178] B_WL[179] B_WL[180] B_WL[181] B_WL[182] B_WL[183] B_WL[184]
+ B_WL[185] B_WL[186] B_WL[187] B_WL[188] B_WL[189] B_WL[190] B_WL[191]
+ B_WL[192] B_WL[193] B_WL[194] B_WL[195] B_WL[196] B_WL[197] B_WL[198]
+ B_WL[199] B_WL[200] B_WL[201] B_WL[202] B_WL[203] B_WL[204] B_WL[205]
+ B_WL[206] B_WL[207] B_WL[208] B_WL[209] B_WL[210] B_WL[211] B_WL[212]
+ B_WL[213] B_WL[214] B_WL[215] B_WL[216] B_WL[217] B_WL[218] B_WL[219]
+ B_WL[220] B_WL[221] B_WL[222] B_WL[223] B_WL[224] B_WL[225] B_WL[226]
+ B_WL[227] B_WL[228] B_WL[229] B_WL[230] B_WL[231] B_WL[232] B_WL[233]
+ B_WL[234] B_WL[235] B_WL[236] B_WL[237] B_WL[238] B_WL[239] B_WL[240]
+ B_WL[241] B_WL[242] B_WL[243] B_WL[244] B_WL[245] B_WL[246] B_WL[247]
+ B_WL[248] B_WL[249] B_WL[250] B_WL[251] B_WL[252] B_WL[253] B_WL[254]
+ B_WL[255] A_RDL[0] A_SMPRS_0[3] A_SMPRS_0[2] A_SMPRS_0[1] A_SMPRS_0[0]
+ A_SOE[0] A_WRTL[0] A_YSEL_0[7] A_YSEL_0[6] A_YSEL_0[5] A_YSEL_0[4]
+ A_YSEL_0[3] A_YSEL_0[2] A_YSEL_0[1] A_YSEL_0[0] B_RDL[0] B_SMPRS_0[3]
+ B_SMPRS_0[2] B_SMPRS_0[1] B_SMPRS_0[0] B_SOE[0] B_WRTL[0] B_YSEL_0[7]
+ B_YSEL_0[6] B_YSEL_0[5] B_YSEL_0[4] B_YSEL_0[3] B_YSEL_0[2] B_YSEL_0[1]
+ B_YSEL_0[0] AWTI BWEBA[11] BWEBMA[11] A_CKD DA[11] A_DLRS DMA[11] A_WENB[3]
+ A_WENB[2] A_WENB[1] A_WENB[0] BISTC BISTT BWEBB[11] BWEBMB[11] B_CKD DB[11]
+ B_DLRS DMB[11] B_WENB[3] B_WENB[2] B_WENB[1] B_WENB[0] QA[11] QB[11]
+  SDL400W20S_NBITSLC
XBIT12 A_WL[0] A_WL[1] A_WL[2] A_WL[3] A_WL[4] A_WL[5] A_WL[6] A_WL[7] A_WL[8]
+ A_WL[9] A_WL[10] A_WL[11] A_WL[12] A_WL[13] A_WL[14] A_WL[15] A_WL[16]
+ A_WL[17] A_WL[18] A_WL[19] A_WL[20] A_WL[21] A_WL[22] A_WL[23] A_WL[24]
+ A_WL[25] A_WL[26] A_WL[27] A_WL[28] A_WL[29] A_WL[30] A_WL[31] A_WL[32]
+ A_WL[33] A_WL[34] A_WL[35] A_WL[36] A_WL[37] A_WL[38] A_WL[39] A_WL[40]
+ A_WL[41] A_WL[42] A_WL[43] A_WL[44] A_WL[45] A_WL[46] A_WL[47] A_WL[48]
+ A_WL[49] A_WL[50] A_WL[51] A_WL[52] A_WL[53] A_WL[54] A_WL[55] A_WL[56]
+ A_WL[57] A_WL[58] A_WL[59] A_WL[60] A_WL[61] A_WL[62] A_WL[63] A_WL[64]
+ A_WL[65] A_WL[66] A_WL[67] A_WL[68] A_WL[69] A_WL[70] A_WL[71] A_WL[72]
+ A_WL[73] A_WL[74] A_WL[75] A_WL[76] A_WL[77] A_WL[78] A_WL[79] A_WL[80]
+ A_WL[81] A_WL[82] A_WL[83] A_WL[84] A_WL[85] A_WL[86] A_WL[87] A_WL[88]
+ A_WL[89] A_WL[90] A_WL[91] A_WL[92] A_WL[93] A_WL[94] A_WL[95] A_WL[96]
+ A_WL[97] A_WL[98] A_WL[99] A_WL[100] A_WL[101] A_WL[102] A_WL[103] A_WL[104]
+ A_WL[105] A_WL[106] A_WL[107] A_WL[108] A_WL[109] A_WL[110] A_WL[111]
+ A_WL[112] A_WL[113] A_WL[114] A_WL[115] A_WL[116] A_WL[117] A_WL[118]
+ A_WL[119] A_WL[120] A_WL[121] A_WL[122] A_WL[123] A_WL[124] A_WL[125]
+ A_WL[126] A_WL[127] A_WL[128] A_WL[129] A_WL[130] A_WL[131] A_WL[132]
+ A_WL[133] A_WL[134] A_WL[135] A_WL[136] A_WL[137] A_WL[138] A_WL[139]
+ A_WL[140] A_WL[141] A_WL[142] A_WL[143] A_WL[144] A_WL[145] A_WL[146]
+ A_WL[147] A_WL[148] A_WL[149] A_WL[150] A_WL[151] A_WL[152] A_WL[153]
+ A_WL[154] A_WL[155] A_WL[156] A_WL[157] A_WL[158] A_WL[159] A_WL[160]
+ A_WL[161] A_WL[162] A_WL[163] A_WL[164] A_WL[165] A_WL[166] A_WL[167]
+ A_WL[168] A_WL[169] A_WL[170] A_WL[171] A_WL[172] A_WL[173] A_WL[174]
+ A_WL[175] A_WL[176] A_WL[177] A_WL[178] A_WL[179] A_WL[180] A_WL[181]
+ A_WL[182] A_WL[183] A_WL[184] A_WL[185] A_WL[186] A_WL[187] A_WL[188]
+ A_WL[189] A_WL[190] A_WL[191] A_WL[192] A_WL[193] A_WL[194] A_WL[195]
+ A_WL[196] A_WL[197] A_WL[198] A_WL[199] A_WL[200] A_WL[201] A_WL[202]
+ A_WL[203] A_WL[204] A_WL[205] A_WL[206] A_WL[207] A_WL[208] A_WL[209]
+ A_WL[210] A_WL[211] A_WL[212] A_WL[213] A_WL[214] A_WL[215] A_WL[216]
+ A_WL[217] A_WL[218] A_WL[219] A_WL[220] A_WL[221] A_WL[222] A_WL[223]
+ A_WL[224] A_WL[225] A_WL[226] A_WL[227] A_WL[228] A_WL[229] A_WL[230]
+ A_WL[231] A_WL[232] A_WL[233] A_WL[234] A_WL[235] A_WL[236] A_WL[237]
+ A_WL[238] A_WL[239] A_WL[240] A_WL[241] A_WL[242] A_WL[243] A_WL[244]
+ A_WL[245] A_WL[246] A_WL[247] A_WL[248] A_WL[249] A_WL[250] A_WL[251]
+ A_WL[252] A_WL[253] A_WL[254] A_WL[255] B_WL[0] B_WL[1] B_WL[2] B_WL[3]
+ B_WL[4] B_WL[5] B_WL[6] B_WL[7] B_WL[8] B_WL[9] B_WL[10] B_WL[11] B_WL[12]
+ B_WL[13] B_WL[14] B_WL[15] B_WL[16] B_WL[17] B_WL[18] B_WL[19] B_WL[20]
+ B_WL[21] B_WL[22] B_WL[23] B_WL[24] B_WL[25] B_WL[26] B_WL[27] B_WL[28]
+ B_WL[29] B_WL[30] B_WL[31] B_WL[32] B_WL[33] B_WL[34] B_WL[35] B_WL[36]
+ B_WL[37] B_WL[38] B_WL[39] B_WL[40] B_WL[41] B_WL[42] B_WL[43] B_WL[44]
+ B_WL[45] B_WL[46] B_WL[47] B_WL[48] B_WL[49] B_WL[50] B_WL[51] B_WL[52]
+ B_WL[53] B_WL[54] B_WL[55] B_WL[56] B_WL[57] B_WL[58] B_WL[59] B_WL[60]
+ B_WL[61] B_WL[62] B_WL[63] B_WL[64] B_WL[65] B_WL[66] B_WL[67] B_WL[68]
+ B_WL[69] B_WL[70] B_WL[71] B_WL[72] B_WL[73] B_WL[74] B_WL[75] B_WL[76]
+ B_WL[77] B_WL[78] B_WL[79] B_WL[80] B_WL[81] B_WL[82] B_WL[83] B_WL[84]
+ B_WL[85] B_WL[86] B_WL[87] B_WL[88] B_WL[89] B_WL[90] B_WL[91] B_WL[92]
+ B_WL[93] B_WL[94] B_WL[95] B_WL[96] B_WL[97] B_WL[98] B_WL[99] B_WL[100]
+ B_WL[101] B_WL[102] B_WL[103] B_WL[104] B_WL[105] B_WL[106] B_WL[107]
+ B_WL[108] B_WL[109] B_WL[110] B_WL[111] B_WL[112] B_WL[113] B_WL[114]
+ B_WL[115] B_WL[116] B_WL[117] B_WL[118] B_WL[119] B_WL[120] B_WL[121]
+ B_WL[122] B_WL[123] B_WL[124] B_WL[125] B_WL[126] B_WL[127] B_WL[128]
+ B_WL[129] B_WL[130] B_WL[131] B_WL[132] B_WL[133] B_WL[134] B_WL[135]
+ B_WL[136] B_WL[137] B_WL[138] B_WL[139] B_WL[140] B_WL[141] B_WL[142]
+ B_WL[143] B_WL[144] B_WL[145] B_WL[146] B_WL[147] B_WL[148] B_WL[149]
+ B_WL[150] B_WL[151] B_WL[152] B_WL[153] B_WL[154] B_WL[155] B_WL[156]
+ B_WL[157] B_WL[158] B_WL[159] B_WL[160] B_WL[161] B_WL[162] B_WL[163]
+ B_WL[164] B_WL[165] B_WL[166] B_WL[167] B_WL[168] B_WL[169] B_WL[170]
+ B_WL[171] B_WL[172] B_WL[173] B_WL[174] B_WL[175] B_WL[176] B_WL[177]
+ B_WL[178] B_WL[179] B_WL[180] B_WL[181] B_WL[182] B_WL[183] B_WL[184]
+ B_WL[185] B_WL[186] B_WL[187] B_WL[188] B_WL[189] B_WL[190] B_WL[191]
+ B_WL[192] B_WL[193] B_WL[194] B_WL[195] B_WL[196] B_WL[197] B_WL[198]
+ B_WL[199] B_WL[200] B_WL[201] B_WL[202] B_WL[203] B_WL[204] B_WL[205]
+ B_WL[206] B_WL[207] B_WL[208] B_WL[209] B_WL[210] B_WL[211] B_WL[212]
+ B_WL[213] B_WL[214] B_WL[215] B_WL[216] B_WL[217] B_WL[218] B_WL[219]
+ B_WL[220] B_WL[221] B_WL[222] B_WL[223] B_WL[224] B_WL[225] B_WL[226]
+ B_WL[227] B_WL[228] B_WL[229] B_WL[230] B_WL[231] B_WL[232] B_WL[233]
+ B_WL[234] B_WL[235] B_WL[236] B_WL[237] B_WL[238] B_WL[239] B_WL[240]
+ B_WL[241] B_WL[242] B_WL[243] B_WL[244] B_WL[245] B_WL[246] B_WL[247]
+ B_WL[248] B_WL[249] B_WL[250] B_WL[251] B_WL[252] B_WL[253] B_WL[254]
+ B_WL[255] A_RDL[0] A_SMPRS_0[3] A_SMPRS_0[2] A_SMPRS_0[1] A_SMPRS_0[0]
+ A_SOE[0] A_WRTL[0] A_YSEL_0[7] A_YSEL_0[6] A_YSEL_0[5] A_YSEL_0[4]
+ A_YSEL_0[3] A_YSEL_0[2] A_YSEL_0[1] A_YSEL_0[0] B_RDL[0] B_SMPRS_0[3]
+ B_SMPRS_0[2] B_SMPRS_0[1] B_SMPRS_0[0] B_SOE[0] B_WRTL[0] B_YSEL_0[7]
+ B_YSEL_0[6] B_YSEL_0[5] B_YSEL_0[4] B_YSEL_0[3] B_YSEL_0[2] B_YSEL_0[1]
+ B_YSEL_0[0] AWTI BWEBA[12] BWEBMA[12] A_CKD DA[12] A_DLRS DMA[12] A_WENB[3]
+ A_WENB[2] A_WENB[1] A_WENB[0] BISTC BISTT BWEBB[12] BWEBMB[12] B_CKD DB[12]
+ B_DLRS DMB[12] B_WENB[3] B_WENB[2] B_WENB[1] B_WENB[0] QA[12] QB[12]
+  SDL400W20S_NBITSLC
XBIT13 A_WL[0] A_WL[1] A_WL[2] A_WL[3] A_WL[4] A_WL[5] A_WL[6] A_WL[7] A_WL[8]
+ A_WL[9] A_WL[10] A_WL[11] A_WL[12] A_WL[13] A_WL[14] A_WL[15] A_WL[16]
+ A_WL[17] A_WL[18] A_WL[19] A_WL[20] A_WL[21] A_WL[22] A_WL[23] A_WL[24]
+ A_WL[25] A_WL[26] A_WL[27] A_WL[28] A_WL[29] A_WL[30] A_WL[31] A_WL[32]
+ A_WL[33] A_WL[34] A_WL[35] A_WL[36] A_WL[37] A_WL[38] A_WL[39] A_WL[40]
+ A_WL[41] A_WL[42] A_WL[43] A_WL[44] A_WL[45] A_WL[46] A_WL[47] A_WL[48]
+ A_WL[49] A_WL[50] A_WL[51] A_WL[52] A_WL[53] A_WL[54] A_WL[55] A_WL[56]
+ A_WL[57] A_WL[58] A_WL[59] A_WL[60] A_WL[61] A_WL[62] A_WL[63] A_WL[64]
+ A_WL[65] A_WL[66] A_WL[67] A_WL[68] A_WL[69] A_WL[70] A_WL[71] A_WL[72]
+ A_WL[73] A_WL[74] A_WL[75] A_WL[76] A_WL[77] A_WL[78] A_WL[79] A_WL[80]
+ A_WL[81] A_WL[82] A_WL[83] A_WL[84] A_WL[85] A_WL[86] A_WL[87] A_WL[88]
+ A_WL[89] A_WL[90] A_WL[91] A_WL[92] A_WL[93] A_WL[94] A_WL[95] A_WL[96]
+ A_WL[97] A_WL[98] A_WL[99] A_WL[100] A_WL[101] A_WL[102] A_WL[103] A_WL[104]
+ A_WL[105] A_WL[106] A_WL[107] A_WL[108] A_WL[109] A_WL[110] A_WL[111]
+ A_WL[112] A_WL[113] A_WL[114] A_WL[115] A_WL[116] A_WL[117] A_WL[118]
+ A_WL[119] A_WL[120] A_WL[121] A_WL[122] A_WL[123] A_WL[124] A_WL[125]
+ A_WL[126] A_WL[127] A_WL[128] A_WL[129] A_WL[130] A_WL[131] A_WL[132]
+ A_WL[133] A_WL[134] A_WL[135] A_WL[136] A_WL[137] A_WL[138] A_WL[139]
+ A_WL[140] A_WL[141] A_WL[142] A_WL[143] A_WL[144] A_WL[145] A_WL[146]
+ A_WL[147] A_WL[148] A_WL[149] A_WL[150] A_WL[151] A_WL[152] A_WL[153]
+ A_WL[154] A_WL[155] A_WL[156] A_WL[157] A_WL[158] A_WL[159] A_WL[160]
+ A_WL[161] A_WL[162] A_WL[163] A_WL[164] A_WL[165] A_WL[166] A_WL[167]
+ A_WL[168] A_WL[169] A_WL[170] A_WL[171] A_WL[172] A_WL[173] A_WL[174]
+ A_WL[175] A_WL[176] A_WL[177] A_WL[178] A_WL[179] A_WL[180] A_WL[181]
+ A_WL[182] A_WL[183] A_WL[184] A_WL[185] A_WL[186] A_WL[187] A_WL[188]
+ A_WL[189] A_WL[190] A_WL[191] A_WL[192] A_WL[193] A_WL[194] A_WL[195]
+ A_WL[196] A_WL[197] A_WL[198] A_WL[199] A_WL[200] A_WL[201] A_WL[202]
+ A_WL[203] A_WL[204] A_WL[205] A_WL[206] A_WL[207] A_WL[208] A_WL[209]
+ A_WL[210] A_WL[211] A_WL[212] A_WL[213] A_WL[214] A_WL[215] A_WL[216]
+ A_WL[217] A_WL[218] A_WL[219] A_WL[220] A_WL[221] A_WL[222] A_WL[223]
+ A_WL[224] A_WL[225] A_WL[226] A_WL[227] A_WL[228] A_WL[229] A_WL[230]
+ A_WL[231] A_WL[232] A_WL[233] A_WL[234] A_WL[235] A_WL[236] A_WL[237]
+ A_WL[238] A_WL[239] A_WL[240] A_WL[241] A_WL[242] A_WL[243] A_WL[244]
+ A_WL[245] A_WL[246] A_WL[247] A_WL[248] A_WL[249] A_WL[250] A_WL[251]
+ A_WL[252] A_WL[253] A_WL[254] A_WL[255] B_WL[0] B_WL[1] B_WL[2] B_WL[3]
+ B_WL[4] B_WL[5] B_WL[6] B_WL[7] B_WL[8] B_WL[9] B_WL[10] B_WL[11] B_WL[12]
+ B_WL[13] B_WL[14] B_WL[15] B_WL[16] B_WL[17] B_WL[18] B_WL[19] B_WL[20]
+ B_WL[21] B_WL[22] B_WL[23] B_WL[24] B_WL[25] B_WL[26] B_WL[27] B_WL[28]
+ B_WL[29] B_WL[30] B_WL[31] B_WL[32] B_WL[33] B_WL[34] B_WL[35] B_WL[36]
+ B_WL[37] B_WL[38] B_WL[39] B_WL[40] B_WL[41] B_WL[42] B_WL[43] B_WL[44]
+ B_WL[45] B_WL[46] B_WL[47] B_WL[48] B_WL[49] B_WL[50] B_WL[51] B_WL[52]
+ B_WL[53] B_WL[54] B_WL[55] B_WL[56] B_WL[57] B_WL[58] B_WL[59] B_WL[60]
+ B_WL[61] B_WL[62] B_WL[63] B_WL[64] B_WL[65] B_WL[66] B_WL[67] B_WL[68]
+ B_WL[69] B_WL[70] B_WL[71] B_WL[72] B_WL[73] B_WL[74] B_WL[75] B_WL[76]
+ B_WL[77] B_WL[78] B_WL[79] B_WL[80] B_WL[81] B_WL[82] B_WL[83] B_WL[84]
+ B_WL[85] B_WL[86] B_WL[87] B_WL[88] B_WL[89] B_WL[90] B_WL[91] B_WL[92]
+ B_WL[93] B_WL[94] B_WL[95] B_WL[96] B_WL[97] B_WL[98] B_WL[99] B_WL[100]
+ B_WL[101] B_WL[102] B_WL[103] B_WL[104] B_WL[105] B_WL[106] B_WL[107]
+ B_WL[108] B_WL[109] B_WL[110] B_WL[111] B_WL[112] B_WL[113] B_WL[114]
+ B_WL[115] B_WL[116] B_WL[117] B_WL[118] B_WL[119] B_WL[120] B_WL[121]
+ B_WL[122] B_WL[123] B_WL[124] B_WL[125] B_WL[126] B_WL[127] B_WL[128]
+ B_WL[129] B_WL[130] B_WL[131] B_WL[132] B_WL[133] B_WL[134] B_WL[135]
+ B_WL[136] B_WL[137] B_WL[138] B_WL[139] B_WL[140] B_WL[141] B_WL[142]
+ B_WL[143] B_WL[144] B_WL[145] B_WL[146] B_WL[147] B_WL[148] B_WL[149]
+ B_WL[150] B_WL[151] B_WL[152] B_WL[153] B_WL[154] B_WL[155] B_WL[156]
+ B_WL[157] B_WL[158] B_WL[159] B_WL[160] B_WL[161] B_WL[162] B_WL[163]
+ B_WL[164] B_WL[165] B_WL[166] B_WL[167] B_WL[168] B_WL[169] B_WL[170]
+ B_WL[171] B_WL[172] B_WL[173] B_WL[174] B_WL[175] B_WL[176] B_WL[177]
+ B_WL[178] B_WL[179] B_WL[180] B_WL[181] B_WL[182] B_WL[183] B_WL[184]
+ B_WL[185] B_WL[186] B_WL[187] B_WL[188] B_WL[189] B_WL[190] B_WL[191]
+ B_WL[192] B_WL[193] B_WL[194] B_WL[195] B_WL[196] B_WL[197] B_WL[198]
+ B_WL[199] B_WL[200] B_WL[201] B_WL[202] B_WL[203] B_WL[204] B_WL[205]
+ B_WL[206] B_WL[207] B_WL[208] B_WL[209] B_WL[210] B_WL[211] B_WL[212]
+ B_WL[213] B_WL[214] B_WL[215] B_WL[216] B_WL[217] B_WL[218] B_WL[219]
+ B_WL[220] B_WL[221] B_WL[222] B_WL[223] B_WL[224] B_WL[225] B_WL[226]
+ B_WL[227] B_WL[228] B_WL[229] B_WL[230] B_WL[231] B_WL[232] B_WL[233]
+ B_WL[234] B_WL[235] B_WL[236] B_WL[237] B_WL[238] B_WL[239] B_WL[240]
+ B_WL[241] B_WL[242] B_WL[243] B_WL[244] B_WL[245] B_WL[246] B_WL[247]
+ B_WL[248] B_WL[249] B_WL[250] B_WL[251] B_WL[252] B_WL[253] B_WL[254]
+ B_WL[255] A_RDL[0] A_SMPRS_0[3] A_SMPRS_0[2] A_SMPRS_0[1] A_SMPRS_0[0]
+ A_SOE[0] A_WRTL[0] A_YSEL_0[7] A_YSEL_0[6] A_YSEL_0[5] A_YSEL_0[4]
+ A_YSEL_0[3] A_YSEL_0[2] A_YSEL_0[1] A_YSEL_0[0] B_RDL[0] B_SMPRS_0[3]
+ B_SMPRS_0[2] B_SMPRS_0[1] B_SMPRS_0[0] B_SOE[0] B_WRTL[0] B_YSEL_0[7]
+ B_YSEL_0[6] B_YSEL_0[5] B_YSEL_0[4] B_YSEL_0[3] B_YSEL_0[2] B_YSEL_0[1]
+ B_YSEL_0[0] AWTI BWEBA[13] BWEBMA[13] A_CKD DA[13] A_DLRS DMA[13] A_WENB[3]
+ A_WENB[2] A_WENB[1] A_WENB[0] BISTC BISTT BWEBB[13] BWEBMB[13] B_CKD DB[13]
+ B_DLRS DMB[13] B_WENB[3] B_WENB[2] B_WENB[1] B_WENB[0] QA[13] QB[13]
+  SDL400W20S_NBITSLC
XBIT14 A_WL[0] A_WL[1] A_WL[2] A_WL[3] A_WL[4] A_WL[5] A_WL[6] A_WL[7] A_WL[8]
+ A_WL[9] A_WL[10] A_WL[11] A_WL[12] A_WL[13] A_WL[14] A_WL[15] A_WL[16]
+ A_WL[17] A_WL[18] A_WL[19] A_WL[20] A_WL[21] A_WL[22] A_WL[23] A_WL[24]
+ A_WL[25] A_WL[26] A_WL[27] A_WL[28] A_WL[29] A_WL[30] A_WL[31] A_WL[32]
+ A_WL[33] A_WL[34] A_WL[35] A_WL[36] A_WL[37] A_WL[38] A_WL[39] A_WL[40]
+ A_WL[41] A_WL[42] A_WL[43] A_WL[44] A_WL[45] A_WL[46] A_WL[47] A_WL[48]
+ A_WL[49] A_WL[50] A_WL[51] A_WL[52] A_WL[53] A_WL[54] A_WL[55] A_WL[56]
+ A_WL[57] A_WL[58] A_WL[59] A_WL[60] A_WL[61] A_WL[62] A_WL[63] A_WL[64]
+ A_WL[65] A_WL[66] A_WL[67] A_WL[68] A_WL[69] A_WL[70] A_WL[71] A_WL[72]
+ A_WL[73] A_WL[74] A_WL[75] A_WL[76] A_WL[77] A_WL[78] A_WL[79] A_WL[80]
+ A_WL[81] A_WL[82] A_WL[83] A_WL[84] A_WL[85] A_WL[86] A_WL[87] A_WL[88]
+ A_WL[89] A_WL[90] A_WL[91] A_WL[92] A_WL[93] A_WL[94] A_WL[95] A_WL[96]
+ A_WL[97] A_WL[98] A_WL[99] A_WL[100] A_WL[101] A_WL[102] A_WL[103] A_WL[104]
+ A_WL[105] A_WL[106] A_WL[107] A_WL[108] A_WL[109] A_WL[110] A_WL[111]
+ A_WL[112] A_WL[113] A_WL[114] A_WL[115] A_WL[116] A_WL[117] A_WL[118]
+ A_WL[119] A_WL[120] A_WL[121] A_WL[122] A_WL[123] A_WL[124] A_WL[125]
+ A_WL[126] A_WL[127] A_WL[128] A_WL[129] A_WL[130] A_WL[131] A_WL[132]
+ A_WL[133] A_WL[134] A_WL[135] A_WL[136] A_WL[137] A_WL[138] A_WL[139]
+ A_WL[140] A_WL[141] A_WL[142] A_WL[143] A_WL[144] A_WL[145] A_WL[146]
+ A_WL[147] A_WL[148] A_WL[149] A_WL[150] A_WL[151] A_WL[152] A_WL[153]
+ A_WL[154] A_WL[155] A_WL[156] A_WL[157] A_WL[158] A_WL[159] A_WL[160]
+ A_WL[161] A_WL[162] A_WL[163] A_WL[164] A_WL[165] A_WL[166] A_WL[167]
+ A_WL[168] A_WL[169] A_WL[170] A_WL[171] A_WL[172] A_WL[173] A_WL[174]
+ A_WL[175] A_WL[176] A_WL[177] A_WL[178] A_WL[179] A_WL[180] A_WL[181]
+ A_WL[182] A_WL[183] A_WL[184] A_WL[185] A_WL[186] A_WL[187] A_WL[188]
+ A_WL[189] A_WL[190] A_WL[191] A_WL[192] A_WL[193] A_WL[194] A_WL[195]
+ A_WL[196] A_WL[197] A_WL[198] A_WL[199] A_WL[200] A_WL[201] A_WL[202]
+ A_WL[203] A_WL[204] A_WL[205] A_WL[206] A_WL[207] A_WL[208] A_WL[209]
+ A_WL[210] A_WL[211] A_WL[212] A_WL[213] A_WL[214] A_WL[215] A_WL[216]
+ A_WL[217] A_WL[218] A_WL[219] A_WL[220] A_WL[221] A_WL[222] A_WL[223]
+ A_WL[224] A_WL[225] A_WL[226] A_WL[227] A_WL[228] A_WL[229] A_WL[230]
+ A_WL[231] A_WL[232] A_WL[233] A_WL[234] A_WL[235] A_WL[236] A_WL[237]
+ A_WL[238] A_WL[239] A_WL[240] A_WL[241] A_WL[242] A_WL[243] A_WL[244]
+ A_WL[245] A_WL[246] A_WL[247] A_WL[248] A_WL[249] A_WL[250] A_WL[251]
+ A_WL[252] A_WL[253] A_WL[254] A_WL[255] B_WL[0] B_WL[1] B_WL[2] B_WL[3]
+ B_WL[4] B_WL[5] B_WL[6] B_WL[7] B_WL[8] B_WL[9] B_WL[10] B_WL[11] B_WL[12]
+ B_WL[13] B_WL[14] B_WL[15] B_WL[16] B_WL[17] B_WL[18] B_WL[19] B_WL[20]
+ B_WL[21] B_WL[22] B_WL[23] B_WL[24] B_WL[25] B_WL[26] B_WL[27] B_WL[28]
+ B_WL[29] B_WL[30] B_WL[31] B_WL[32] B_WL[33] B_WL[34] B_WL[35] B_WL[36]
+ B_WL[37] B_WL[38] B_WL[39] B_WL[40] B_WL[41] B_WL[42] B_WL[43] B_WL[44]
+ B_WL[45] B_WL[46] B_WL[47] B_WL[48] B_WL[49] B_WL[50] B_WL[51] B_WL[52]
+ B_WL[53] B_WL[54] B_WL[55] B_WL[56] B_WL[57] B_WL[58] B_WL[59] B_WL[60]
+ B_WL[61] B_WL[62] B_WL[63] B_WL[64] B_WL[65] B_WL[66] B_WL[67] B_WL[68]
+ B_WL[69] B_WL[70] B_WL[71] B_WL[72] B_WL[73] B_WL[74] B_WL[75] B_WL[76]
+ B_WL[77] B_WL[78] B_WL[79] B_WL[80] B_WL[81] B_WL[82] B_WL[83] B_WL[84]
+ B_WL[85] B_WL[86] B_WL[87] B_WL[88] B_WL[89] B_WL[90] B_WL[91] B_WL[92]
+ B_WL[93] B_WL[94] B_WL[95] B_WL[96] B_WL[97] B_WL[98] B_WL[99] B_WL[100]
+ B_WL[101] B_WL[102] B_WL[103] B_WL[104] B_WL[105] B_WL[106] B_WL[107]
+ B_WL[108] B_WL[109] B_WL[110] B_WL[111] B_WL[112] B_WL[113] B_WL[114]
+ B_WL[115] B_WL[116] B_WL[117] B_WL[118] B_WL[119] B_WL[120] B_WL[121]
+ B_WL[122] B_WL[123] B_WL[124] B_WL[125] B_WL[126] B_WL[127] B_WL[128]
+ B_WL[129] B_WL[130] B_WL[131] B_WL[132] B_WL[133] B_WL[134] B_WL[135]
+ B_WL[136] B_WL[137] B_WL[138] B_WL[139] B_WL[140] B_WL[141] B_WL[142]
+ B_WL[143] B_WL[144] B_WL[145] B_WL[146] B_WL[147] B_WL[148] B_WL[149]
+ B_WL[150] B_WL[151] B_WL[152] B_WL[153] B_WL[154] B_WL[155] B_WL[156]
+ B_WL[157] B_WL[158] B_WL[159] B_WL[160] B_WL[161] B_WL[162] B_WL[163]
+ B_WL[164] B_WL[165] B_WL[166] B_WL[167] B_WL[168] B_WL[169] B_WL[170]
+ B_WL[171] B_WL[172] B_WL[173] B_WL[174] B_WL[175] B_WL[176] B_WL[177]
+ B_WL[178] B_WL[179] B_WL[180] B_WL[181] B_WL[182] B_WL[183] B_WL[184]
+ B_WL[185] B_WL[186] B_WL[187] B_WL[188] B_WL[189] B_WL[190] B_WL[191]
+ B_WL[192] B_WL[193] B_WL[194] B_WL[195] B_WL[196] B_WL[197] B_WL[198]
+ B_WL[199] B_WL[200] B_WL[201] B_WL[202] B_WL[203] B_WL[204] B_WL[205]
+ B_WL[206] B_WL[207] B_WL[208] B_WL[209] B_WL[210] B_WL[211] B_WL[212]
+ B_WL[213] B_WL[214] B_WL[215] B_WL[216] B_WL[217] B_WL[218] B_WL[219]
+ B_WL[220] B_WL[221] B_WL[222] B_WL[223] B_WL[224] B_WL[225] B_WL[226]
+ B_WL[227] B_WL[228] B_WL[229] B_WL[230] B_WL[231] B_WL[232] B_WL[233]
+ B_WL[234] B_WL[235] B_WL[236] B_WL[237] B_WL[238] B_WL[239] B_WL[240]
+ B_WL[241] B_WL[242] B_WL[243] B_WL[244] B_WL[245] B_WL[246] B_WL[247]
+ B_WL[248] B_WL[249] B_WL[250] B_WL[251] B_WL[252] B_WL[253] B_WL[254]
+ B_WL[255] A_RDL[0] A_SMPRS_0[3] A_SMPRS_0[2] A_SMPRS_0[1] A_SMPRS_0[0]
+ A_SOE[0] A_WRTL[0] A_YSEL_0[7] A_YSEL_0[6] A_YSEL_0[5] A_YSEL_0[4]
+ A_YSEL_0[3] A_YSEL_0[2] A_YSEL_0[1] A_YSEL_0[0] B_RDL[0] B_SMPRS_0[3]
+ B_SMPRS_0[2] B_SMPRS_0[1] B_SMPRS_0[0] B_SOE[0] B_WRTL[0] B_YSEL_0[7]
+ B_YSEL_0[6] B_YSEL_0[5] B_YSEL_0[4] B_YSEL_0[3] B_YSEL_0[2] B_YSEL_0[1]
+ B_YSEL_0[0] AWTI BWEBA[14] BWEBMA[14] A_CKD DA[14] A_DLRS DMA[14] A_WENB[3]
+ A_WENB[2] A_WENB[1] A_WENB[0] BISTC BISTT BWEBB[14] BWEBMB[14] B_CKD DB[14]
+ B_DLRS DMB[14] B_WENB[3] B_WENB[2] B_WENB[1] B_WENB[0] QA[14] QB[14]
+  SDL400W20S_NBITSLC
XBIT15 A_WL[0] A_WL[1] A_WL[2] A_WL[3] A_WL[4] A_WL[5] A_WL[6] A_WL[7] A_WL[8]
+ A_WL[9] A_WL[10] A_WL[11] A_WL[12] A_WL[13] A_WL[14] A_WL[15] A_WL[16]
+ A_WL[17] A_WL[18] A_WL[19] A_WL[20] A_WL[21] A_WL[22] A_WL[23] A_WL[24]
+ A_WL[25] A_WL[26] A_WL[27] A_WL[28] A_WL[29] A_WL[30] A_WL[31] A_WL[32]
+ A_WL[33] A_WL[34] A_WL[35] A_WL[36] A_WL[37] A_WL[38] A_WL[39] A_WL[40]
+ A_WL[41] A_WL[42] A_WL[43] A_WL[44] A_WL[45] A_WL[46] A_WL[47] A_WL[48]
+ A_WL[49] A_WL[50] A_WL[51] A_WL[52] A_WL[53] A_WL[54] A_WL[55] A_WL[56]
+ A_WL[57] A_WL[58] A_WL[59] A_WL[60] A_WL[61] A_WL[62] A_WL[63] A_WL[64]
+ A_WL[65] A_WL[66] A_WL[67] A_WL[68] A_WL[69] A_WL[70] A_WL[71] A_WL[72]
+ A_WL[73] A_WL[74] A_WL[75] A_WL[76] A_WL[77] A_WL[78] A_WL[79] A_WL[80]
+ A_WL[81] A_WL[82] A_WL[83] A_WL[84] A_WL[85] A_WL[86] A_WL[87] A_WL[88]
+ A_WL[89] A_WL[90] A_WL[91] A_WL[92] A_WL[93] A_WL[94] A_WL[95] A_WL[96]
+ A_WL[97] A_WL[98] A_WL[99] A_WL[100] A_WL[101] A_WL[102] A_WL[103] A_WL[104]
+ A_WL[105] A_WL[106] A_WL[107] A_WL[108] A_WL[109] A_WL[110] A_WL[111]
+ A_WL[112] A_WL[113] A_WL[114] A_WL[115] A_WL[116] A_WL[117] A_WL[118]
+ A_WL[119] A_WL[120] A_WL[121] A_WL[122] A_WL[123] A_WL[124] A_WL[125]
+ A_WL[126] A_WL[127] A_WL[128] A_WL[129] A_WL[130] A_WL[131] A_WL[132]
+ A_WL[133] A_WL[134] A_WL[135] A_WL[136] A_WL[137] A_WL[138] A_WL[139]
+ A_WL[140] A_WL[141] A_WL[142] A_WL[143] A_WL[144] A_WL[145] A_WL[146]
+ A_WL[147] A_WL[148] A_WL[149] A_WL[150] A_WL[151] A_WL[152] A_WL[153]
+ A_WL[154] A_WL[155] A_WL[156] A_WL[157] A_WL[158] A_WL[159] A_WL[160]
+ A_WL[161] A_WL[162] A_WL[163] A_WL[164] A_WL[165] A_WL[166] A_WL[167]
+ A_WL[168] A_WL[169] A_WL[170] A_WL[171] A_WL[172] A_WL[173] A_WL[174]
+ A_WL[175] A_WL[176] A_WL[177] A_WL[178] A_WL[179] A_WL[180] A_WL[181]
+ A_WL[182] A_WL[183] A_WL[184] A_WL[185] A_WL[186] A_WL[187] A_WL[188]
+ A_WL[189] A_WL[190] A_WL[191] A_WL[192] A_WL[193] A_WL[194] A_WL[195]
+ A_WL[196] A_WL[197] A_WL[198] A_WL[199] A_WL[200] A_WL[201] A_WL[202]
+ A_WL[203] A_WL[204] A_WL[205] A_WL[206] A_WL[207] A_WL[208] A_WL[209]
+ A_WL[210] A_WL[211] A_WL[212] A_WL[213] A_WL[214] A_WL[215] A_WL[216]
+ A_WL[217] A_WL[218] A_WL[219] A_WL[220] A_WL[221] A_WL[222] A_WL[223]
+ A_WL[224] A_WL[225] A_WL[226] A_WL[227] A_WL[228] A_WL[229] A_WL[230]
+ A_WL[231] A_WL[232] A_WL[233] A_WL[234] A_WL[235] A_WL[236] A_WL[237]
+ A_WL[238] A_WL[239] A_WL[240] A_WL[241] A_WL[242] A_WL[243] A_WL[244]
+ A_WL[245] A_WL[246] A_WL[247] A_WL[248] A_WL[249] A_WL[250] A_WL[251]
+ A_WL[252] A_WL[253] A_WL[254] A_WL[255] B_WL[0] B_WL[1] B_WL[2] B_WL[3]
+ B_WL[4] B_WL[5] B_WL[6] B_WL[7] B_WL[8] B_WL[9] B_WL[10] B_WL[11] B_WL[12]
+ B_WL[13] B_WL[14] B_WL[15] B_WL[16] B_WL[17] B_WL[18] B_WL[19] B_WL[20]
+ B_WL[21] B_WL[22] B_WL[23] B_WL[24] B_WL[25] B_WL[26] B_WL[27] B_WL[28]
+ B_WL[29] B_WL[30] B_WL[31] B_WL[32] B_WL[33] B_WL[34] B_WL[35] B_WL[36]
+ B_WL[37] B_WL[38] B_WL[39] B_WL[40] B_WL[41] B_WL[42] B_WL[43] B_WL[44]
+ B_WL[45] B_WL[46] B_WL[47] B_WL[48] B_WL[49] B_WL[50] B_WL[51] B_WL[52]
+ B_WL[53] B_WL[54] B_WL[55] B_WL[56] B_WL[57] B_WL[58] B_WL[59] B_WL[60]
+ B_WL[61] B_WL[62] B_WL[63] B_WL[64] B_WL[65] B_WL[66] B_WL[67] B_WL[68]
+ B_WL[69] B_WL[70] B_WL[71] B_WL[72] B_WL[73] B_WL[74] B_WL[75] B_WL[76]
+ B_WL[77] B_WL[78] B_WL[79] B_WL[80] B_WL[81] B_WL[82] B_WL[83] B_WL[84]
+ B_WL[85] B_WL[86] B_WL[87] B_WL[88] B_WL[89] B_WL[90] B_WL[91] B_WL[92]
+ B_WL[93] B_WL[94] B_WL[95] B_WL[96] B_WL[97] B_WL[98] B_WL[99] B_WL[100]
+ B_WL[101] B_WL[102] B_WL[103] B_WL[104] B_WL[105] B_WL[106] B_WL[107]
+ B_WL[108] B_WL[109] B_WL[110] B_WL[111] B_WL[112] B_WL[113] B_WL[114]
+ B_WL[115] B_WL[116] B_WL[117] B_WL[118] B_WL[119] B_WL[120] B_WL[121]
+ B_WL[122] B_WL[123] B_WL[124] B_WL[125] B_WL[126] B_WL[127] B_WL[128]
+ B_WL[129] B_WL[130] B_WL[131] B_WL[132] B_WL[133] B_WL[134] B_WL[135]
+ B_WL[136] B_WL[137] B_WL[138] B_WL[139] B_WL[140] B_WL[141] B_WL[142]
+ B_WL[143] B_WL[144] B_WL[145] B_WL[146] B_WL[147] B_WL[148] B_WL[149]
+ B_WL[150] B_WL[151] B_WL[152] B_WL[153] B_WL[154] B_WL[155] B_WL[156]
+ B_WL[157] B_WL[158] B_WL[159] B_WL[160] B_WL[161] B_WL[162] B_WL[163]
+ B_WL[164] B_WL[165] B_WL[166] B_WL[167] B_WL[168] B_WL[169] B_WL[170]
+ B_WL[171] B_WL[172] B_WL[173] B_WL[174] B_WL[175] B_WL[176] B_WL[177]
+ B_WL[178] B_WL[179] B_WL[180] B_WL[181] B_WL[182] B_WL[183] B_WL[184]
+ B_WL[185] B_WL[186] B_WL[187] B_WL[188] B_WL[189] B_WL[190] B_WL[191]
+ B_WL[192] B_WL[193] B_WL[194] B_WL[195] B_WL[196] B_WL[197] B_WL[198]
+ B_WL[199] B_WL[200] B_WL[201] B_WL[202] B_WL[203] B_WL[204] B_WL[205]
+ B_WL[206] B_WL[207] B_WL[208] B_WL[209] B_WL[210] B_WL[211] B_WL[212]
+ B_WL[213] B_WL[214] B_WL[215] B_WL[216] B_WL[217] B_WL[218] B_WL[219]
+ B_WL[220] B_WL[221] B_WL[222] B_WL[223] B_WL[224] B_WL[225] B_WL[226]
+ B_WL[227] B_WL[228] B_WL[229] B_WL[230] B_WL[231] B_WL[232] B_WL[233]
+ B_WL[234] B_WL[235] B_WL[236] B_WL[237] B_WL[238] B_WL[239] B_WL[240]
+ B_WL[241] B_WL[242] B_WL[243] B_WL[244] B_WL[245] B_WL[246] B_WL[247]
+ B_WL[248] B_WL[249] B_WL[250] B_WL[251] B_WL[252] B_WL[253] B_WL[254]
+ B_WL[255] A_RDL[0] A_SMPRS_0[3] A_SMPRS_0[2] A_SMPRS_0[1] A_SMPRS_0[0]
+ A_SOE[0] A_WRTL[0] A_YSEL_0[7] A_YSEL_0[6] A_YSEL_0[5] A_YSEL_0[4]
+ A_YSEL_0[3] A_YSEL_0[2] A_YSEL_0[1] A_YSEL_0[0] B_RDL[0] B_SMPRS_0[3]
+ B_SMPRS_0[2] B_SMPRS_0[1] B_SMPRS_0[0] B_SOE[0] B_WRTL[0] B_YSEL_0[7]
+ B_YSEL_0[6] B_YSEL_0[5] B_YSEL_0[4] B_YSEL_0[3] B_YSEL_0[2] B_YSEL_0[1]
+ B_YSEL_0[0] AWTI BWEBA[15] BWEBMA[15] A_CKD DA[15] A_DLRS DMA[15] A_WENB[3]
+ A_WENB[2] A_WENB[1] A_WENB[0] BISTC BISTT BWEBB[15] BWEBMB[15] B_CKD DB[15]
+ B_DLRS DMB[15] B_WENB[3] B_WENB[2] B_WENB[1] B_WENB[0] QA[15] QB[15]
+  SDL400W20S_NBITSLC
XBIT16 A_WL[0] A_WL[1] A_WL[2] A_WL[3] A_WL[4] A_WL[5] A_WL[6] A_WL[7] A_WL[8]
+ A_WL[9] A_WL[10] A_WL[11] A_WL[12] A_WL[13] A_WL[14] A_WL[15] A_WL[16]
+ A_WL[17] A_WL[18] A_WL[19] A_WL[20] A_WL[21] A_WL[22] A_WL[23] A_WL[24]
+ A_WL[25] A_WL[26] A_WL[27] A_WL[28] A_WL[29] A_WL[30] A_WL[31] A_WL[32]
+ A_WL[33] A_WL[34] A_WL[35] A_WL[36] A_WL[37] A_WL[38] A_WL[39] A_WL[40]
+ A_WL[41] A_WL[42] A_WL[43] A_WL[44] A_WL[45] A_WL[46] A_WL[47] A_WL[48]
+ A_WL[49] A_WL[50] A_WL[51] A_WL[52] A_WL[53] A_WL[54] A_WL[55] A_WL[56]
+ A_WL[57] A_WL[58] A_WL[59] A_WL[60] A_WL[61] A_WL[62] A_WL[63] A_WL[64]
+ A_WL[65] A_WL[66] A_WL[67] A_WL[68] A_WL[69] A_WL[70] A_WL[71] A_WL[72]
+ A_WL[73] A_WL[74] A_WL[75] A_WL[76] A_WL[77] A_WL[78] A_WL[79] A_WL[80]
+ A_WL[81] A_WL[82] A_WL[83] A_WL[84] A_WL[85] A_WL[86] A_WL[87] A_WL[88]
+ A_WL[89] A_WL[90] A_WL[91] A_WL[92] A_WL[93] A_WL[94] A_WL[95] A_WL[96]
+ A_WL[97] A_WL[98] A_WL[99] A_WL[100] A_WL[101] A_WL[102] A_WL[103] A_WL[104]
+ A_WL[105] A_WL[106] A_WL[107] A_WL[108] A_WL[109] A_WL[110] A_WL[111]
+ A_WL[112] A_WL[113] A_WL[114] A_WL[115] A_WL[116] A_WL[117] A_WL[118]
+ A_WL[119] A_WL[120] A_WL[121] A_WL[122] A_WL[123] A_WL[124] A_WL[125]
+ A_WL[126] A_WL[127] A_WL[128] A_WL[129] A_WL[130] A_WL[131] A_WL[132]
+ A_WL[133] A_WL[134] A_WL[135] A_WL[136] A_WL[137] A_WL[138] A_WL[139]
+ A_WL[140] A_WL[141] A_WL[142] A_WL[143] A_WL[144] A_WL[145] A_WL[146]
+ A_WL[147] A_WL[148] A_WL[149] A_WL[150] A_WL[151] A_WL[152] A_WL[153]
+ A_WL[154] A_WL[155] A_WL[156] A_WL[157] A_WL[158] A_WL[159] A_WL[160]
+ A_WL[161] A_WL[162] A_WL[163] A_WL[164] A_WL[165] A_WL[166] A_WL[167]
+ A_WL[168] A_WL[169] A_WL[170] A_WL[171] A_WL[172] A_WL[173] A_WL[174]
+ A_WL[175] A_WL[176] A_WL[177] A_WL[178] A_WL[179] A_WL[180] A_WL[181]
+ A_WL[182] A_WL[183] A_WL[184] A_WL[185] A_WL[186] A_WL[187] A_WL[188]
+ A_WL[189] A_WL[190] A_WL[191] A_WL[192] A_WL[193] A_WL[194] A_WL[195]
+ A_WL[196] A_WL[197] A_WL[198] A_WL[199] A_WL[200] A_WL[201] A_WL[202]
+ A_WL[203] A_WL[204] A_WL[205] A_WL[206] A_WL[207] A_WL[208] A_WL[209]
+ A_WL[210] A_WL[211] A_WL[212] A_WL[213] A_WL[214] A_WL[215] A_WL[216]
+ A_WL[217] A_WL[218] A_WL[219] A_WL[220] A_WL[221] A_WL[222] A_WL[223]
+ A_WL[224] A_WL[225] A_WL[226] A_WL[227] A_WL[228] A_WL[229] A_WL[230]
+ A_WL[231] A_WL[232] A_WL[233] A_WL[234] A_WL[235] A_WL[236] A_WL[237]
+ A_WL[238] A_WL[239] A_WL[240] A_WL[241] A_WL[242] A_WL[243] A_WL[244]
+ A_WL[245] A_WL[246] A_WL[247] A_WL[248] A_WL[249] A_WL[250] A_WL[251]
+ A_WL[252] A_WL[253] A_WL[254] A_WL[255] B_WL[0] B_WL[1] B_WL[2] B_WL[3]
+ B_WL[4] B_WL[5] B_WL[6] B_WL[7] B_WL[8] B_WL[9] B_WL[10] B_WL[11] B_WL[12]
+ B_WL[13] B_WL[14] B_WL[15] B_WL[16] B_WL[17] B_WL[18] B_WL[19] B_WL[20]
+ B_WL[21] B_WL[22] B_WL[23] B_WL[24] B_WL[25] B_WL[26] B_WL[27] B_WL[28]
+ B_WL[29] B_WL[30] B_WL[31] B_WL[32] B_WL[33] B_WL[34] B_WL[35] B_WL[36]
+ B_WL[37] B_WL[38] B_WL[39] B_WL[40] B_WL[41] B_WL[42] B_WL[43] B_WL[44]
+ B_WL[45] B_WL[46] B_WL[47] B_WL[48] B_WL[49] B_WL[50] B_WL[51] B_WL[52]
+ B_WL[53] B_WL[54] B_WL[55] B_WL[56] B_WL[57] B_WL[58] B_WL[59] B_WL[60]
+ B_WL[61] B_WL[62] B_WL[63] B_WL[64] B_WL[65] B_WL[66] B_WL[67] B_WL[68]
+ B_WL[69] B_WL[70] B_WL[71] B_WL[72] B_WL[73] B_WL[74] B_WL[75] B_WL[76]
+ B_WL[77] B_WL[78] B_WL[79] B_WL[80] B_WL[81] B_WL[82] B_WL[83] B_WL[84]
+ B_WL[85] B_WL[86] B_WL[87] B_WL[88] B_WL[89] B_WL[90] B_WL[91] B_WL[92]
+ B_WL[93] B_WL[94] B_WL[95] B_WL[96] B_WL[97] B_WL[98] B_WL[99] B_WL[100]
+ B_WL[101] B_WL[102] B_WL[103] B_WL[104] B_WL[105] B_WL[106] B_WL[107]
+ B_WL[108] B_WL[109] B_WL[110] B_WL[111] B_WL[112] B_WL[113] B_WL[114]
+ B_WL[115] B_WL[116] B_WL[117] B_WL[118] B_WL[119] B_WL[120] B_WL[121]
+ B_WL[122] B_WL[123] B_WL[124] B_WL[125] B_WL[126] B_WL[127] B_WL[128]
+ B_WL[129] B_WL[130] B_WL[131] B_WL[132] B_WL[133] B_WL[134] B_WL[135]
+ B_WL[136] B_WL[137] B_WL[138] B_WL[139] B_WL[140] B_WL[141] B_WL[142]
+ B_WL[143] B_WL[144] B_WL[145] B_WL[146] B_WL[147] B_WL[148] B_WL[149]
+ B_WL[150] B_WL[151] B_WL[152] B_WL[153] B_WL[154] B_WL[155] B_WL[156]
+ B_WL[157] B_WL[158] B_WL[159] B_WL[160] B_WL[161] B_WL[162] B_WL[163]
+ B_WL[164] B_WL[165] B_WL[166] B_WL[167] B_WL[168] B_WL[169] B_WL[170]
+ B_WL[171] B_WL[172] B_WL[173] B_WL[174] B_WL[175] B_WL[176] B_WL[177]
+ B_WL[178] B_WL[179] B_WL[180] B_WL[181] B_WL[182] B_WL[183] B_WL[184]
+ B_WL[185] B_WL[186] B_WL[187] B_WL[188] B_WL[189] B_WL[190] B_WL[191]
+ B_WL[192] B_WL[193] B_WL[194] B_WL[195] B_WL[196] B_WL[197] B_WL[198]
+ B_WL[199] B_WL[200] B_WL[201] B_WL[202] B_WL[203] B_WL[204] B_WL[205]
+ B_WL[206] B_WL[207] B_WL[208] B_WL[209] B_WL[210] B_WL[211] B_WL[212]
+ B_WL[213] B_WL[214] B_WL[215] B_WL[216] B_WL[217] B_WL[218] B_WL[219]
+ B_WL[220] B_WL[221] B_WL[222] B_WL[223] B_WL[224] B_WL[225] B_WL[226]
+ B_WL[227] B_WL[228] B_WL[229] B_WL[230] B_WL[231] B_WL[232] B_WL[233]
+ B_WL[234] B_WL[235] B_WL[236] B_WL[237] B_WL[238] B_WL[239] B_WL[240]
+ B_WL[241] B_WL[242] B_WL[243] B_WL[244] B_WL[245] B_WL[246] B_WL[247]
+ B_WL[248] B_WL[249] B_WL[250] B_WL[251] B_WL[252] B_WL[253] B_WL[254]
+ B_WL[255] A_RDL[0] A_SMPRS_0[3] A_SMPRS_0[2] A_SMPRS_0[1] A_SMPRS_0[0]
+ A_SOE[0] A_WRTL[0] A_YSEL_0[7] A_YSEL_0[6] A_YSEL_0[5] A_YSEL_0[4]
+ A_YSEL_0[3] A_YSEL_0[2] A_YSEL_0[1] A_YSEL_0[0] B_RDL[0] B_SMPRS_0[3]
+ B_SMPRS_0[2] B_SMPRS_0[1] B_SMPRS_0[0] B_SOE[0] B_WRTL[0] B_YSEL_0[7]
+ B_YSEL_0[6] B_YSEL_0[5] B_YSEL_0[4] B_YSEL_0[3] B_YSEL_0[2] B_YSEL_0[1]
+ B_YSEL_0[0] AWTI BWEBA[16] BWEBMA[16] A_CKD DA[16] A_DLRS DMA[16] A_WENB[3]
+ A_WENB[2] A_WENB[1] A_WENB[0] BISTC BISTT BWEBB[16] BWEBMB[16] B_CKD DB[16]
+ B_DLRS DMB[16] B_WENB[3] B_WENB[2] B_WENB[1] B_WENB[0] QA[16] QB[16]
+  SDL400W20S_NBITSLC
XBIT17 A_WL[0] A_WL[1] A_WL[2] A_WL[3] A_WL[4] A_WL[5] A_WL[6] A_WL[7] A_WL[8]
+ A_WL[9] A_WL[10] A_WL[11] A_WL[12] A_WL[13] A_WL[14] A_WL[15] A_WL[16]
+ A_WL[17] A_WL[18] A_WL[19] A_WL[20] A_WL[21] A_WL[22] A_WL[23] A_WL[24]
+ A_WL[25] A_WL[26] A_WL[27] A_WL[28] A_WL[29] A_WL[30] A_WL[31] A_WL[32]
+ A_WL[33] A_WL[34] A_WL[35] A_WL[36] A_WL[37] A_WL[38] A_WL[39] A_WL[40]
+ A_WL[41] A_WL[42] A_WL[43] A_WL[44] A_WL[45] A_WL[46] A_WL[47] A_WL[48]
+ A_WL[49] A_WL[50] A_WL[51] A_WL[52] A_WL[53] A_WL[54] A_WL[55] A_WL[56]
+ A_WL[57] A_WL[58] A_WL[59] A_WL[60] A_WL[61] A_WL[62] A_WL[63] A_WL[64]
+ A_WL[65] A_WL[66] A_WL[67] A_WL[68] A_WL[69] A_WL[70] A_WL[71] A_WL[72]
+ A_WL[73] A_WL[74] A_WL[75] A_WL[76] A_WL[77] A_WL[78] A_WL[79] A_WL[80]
+ A_WL[81] A_WL[82] A_WL[83] A_WL[84] A_WL[85] A_WL[86] A_WL[87] A_WL[88]
+ A_WL[89] A_WL[90] A_WL[91] A_WL[92] A_WL[93] A_WL[94] A_WL[95] A_WL[96]
+ A_WL[97] A_WL[98] A_WL[99] A_WL[100] A_WL[101] A_WL[102] A_WL[103] A_WL[104]
+ A_WL[105] A_WL[106] A_WL[107] A_WL[108] A_WL[109] A_WL[110] A_WL[111]
+ A_WL[112] A_WL[113] A_WL[114] A_WL[115] A_WL[116] A_WL[117] A_WL[118]
+ A_WL[119] A_WL[120] A_WL[121] A_WL[122] A_WL[123] A_WL[124] A_WL[125]
+ A_WL[126] A_WL[127] A_WL[128] A_WL[129] A_WL[130] A_WL[131] A_WL[132]
+ A_WL[133] A_WL[134] A_WL[135] A_WL[136] A_WL[137] A_WL[138] A_WL[139]
+ A_WL[140] A_WL[141] A_WL[142] A_WL[143] A_WL[144] A_WL[145] A_WL[146]
+ A_WL[147] A_WL[148] A_WL[149] A_WL[150] A_WL[151] A_WL[152] A_WL[153]
+ A_WL[154] A_WL[155] A_WL[156] A_WL[157] A_WL[158] A_WL[159] A_WL[160]
+ A_WL[161] A_WL[162] A_WL[163] A_WL[164] A_WL[165] A_WL[166] A_WL[167]
+ A_WL[168] A_WL[169] A_WL[170] A_WL[171] A_WL[172] A_WL[173] A_WL[174]
+ A_WL[175] A_WL[176] A_WL[177] A_WL[178] A_WL[179] A_WL[180] A_WL[181]
+ A_WL[182] A_WL[183] A_WL[184] A_WL[185] A_WL[186] A_WL[187] A_WL[188]
+ A_WL[189] A_WL[190] A_WL[191] A_WL[192] A_WL[193] A_WL[194] A_WL[195]
+ A_WL[196] A_WL[197] A_WL[198] A_WL[199] A_WL[200] A_WL[201] A_WL[202]
+ A_WL[203] A_WL[204] A_WL[205] A_WL[206] A_WL[207] A_WL[208] A_WL[209]
+ A_WL[210] A_WL[211] A_WL[212] A_WL[213] A_WL[214] A_WL[215] A_WL[216]
+ A_WL[217] A_WL[218] A_WL[219] A_WL[220] A_WL[221] A_WL[222] A_WL[223]
+ A_WL[224] A_WL[225] A_WL[226] A_WL[227] A_WL[228] A_WL[229] A_WL[230]
+ A_WL[231] A_WL[232] A_WL[233] A_WL[234] A_WL[235] A_WL[236] A_WL[237]
+ A_WL[238] A_WL[239] A_WL[240] A_WL[241] A_WL[242] A_WL[243] A_WL[244]
+ A_WL[245] A_WL[246] A_WL[247] A_WL[248] A_WL[249] A_WL[250] A_WL[251]
+ A_WL[252] A_WL[253] A_WL[254] A_WL[255] B_WL[0] B_WL[1] B_WL[2] B_WL[3]
+ B_WL[4] B_WL[5] B_WL[6] B_WL[7] B_WL[8] B_WL[9] B_WL[10] B_WL[11] B_WL[12]
+ B_WL[13] B_WL[14] B_WL[15] B_WL[16] B_WL[17] B_WL[18] B_WL[19] B_WL[20]
+ B_WL[21] B_WL[22] B_WL[23] B_WL[24] B_WL[25] B_WL[26] B_WL[27] B_WL[28]
+ B_WL[29] B_WL[30] B_WL[31] B_WL[32] B_WL[33] B_WL[34] B_WL[35] B_WL[36]
+ B_WL[37] B_WL[38] B_WL[39] B_WL[40] B_WL[41] B_WL[42] B_WL[43] B_WL[44]
+ B_WL[45] B_WL[46] B_WL[47] B_WL[48] B_WL[49] B_WL[50] B_WL[51] B_WL[52]
+ B_WL[53] B_WL[54] B_WL[55] B_WL[56] B_WL[57] B_WL[58] B_WL[59] B_WL[60]
+ B_WL[61] B_WL[62] B_WL[63] B_WL[64] B_WL[65] B_WL[66] B_WL[67] B_WL[68]
+ B_WL[69] B_WL[70] B_WL[71] B_WL[72] B_WL[73] B_WL[74] B_WL[75] B_WL[76]
+ B_WL[77] B_WL[78] B_WL[79] B_WL[80] B_WL[81] B_WL[82] B_WL[83] B_WL[84]
+ B_WL[85] B_WL[86] B_WL[87] B_WL[88] B_WL[89] B_WL[90] B_WL[91] B_WL[92]
+ B_WL[93] B_WL[94] B_WL[95] B_WL[96] B_WL[97] B_WL[98] B_WL[99] B_WL[100]
+ B_WL[101] B_WL[102] B_WL[103] B_WL[104] B_WL[105] B_WL[106] B_WL[107]
+ B_WL[108] B_WL[109] B_WL[110] B_WL[111] B_WL[112] B_WL[113] B_WL[114]
+ B_WL[115] B_WL[116] B_WL[117] B_WL[118] B_WL[119] B_WL[120] B_WL[121]
+ B_WL[122] B_WL[123] B_WL[124] B_WL[125] B_WL[126] B_WL[127] B_WL[128]
+ B_WL[129] B_WL[130] B_WL[131] B_WL[132] B_WL[133] B_WL[134] B_WL[135]
+ B_WL[136] B_WL[137] B_WL[138] B_WL[139] B_WL[140] B_WL[141] B_WL[142]
+ B_WL[143] B_WL[144] B_WL[145] B_WL[146] B_WL[147] B_WL[148] B_WL[149]
+ B_WL[150] B_WL[151] B_WL[152] B_WL[153] B_WL[154] B_WL[155] B_WL[156]
+ B_WL[157] B_WL[158] B_WL[159] B_WL[160] B_WL[161] B_WL[162] B_WL[163]
+ B_WL[164] B_WL[165] B_WL[166] B_WL[167] B_WL[168] B_WL[169] B_WL[170]
+ B_WL[171] B_WL[172] B_WL[173] B_WL[174] B_WL[175] B_WL[176] B_WL[177]
+ B_WL[178] B_WL[179] B_WL[180] B_WL[181] B_WL[182] B_WL[183] B_WL[184]
+ B_WL[185] B_WL[186] B_WL[187] B_WL[188] B_WL[189] B_WL[190] B_WL[191]
+ B_WL[192] B_WL[193] B_WL[194] B_WL[195] B_WL[196] B_WL[197] B_WL[198]
+ B_WL[199] B_WL[200] B_WL[201] B_WL[202] B_WL[203] B_WL[204] B_WL[205]
+ B_WL[206] B_WL[207] B_WL[208] B_WL[209] B_WL[210] B_WL[211] B_WL[212]
+ B_WL[213] B_WL[214] B_WL[215] B_WL[216] B_WL[217] B_WL[218] B_WL[219]
+ B_WL[220] B_WL[221] B_WL[222] B_WL[223] B_WL[224] B_WL[225] B_WL[226]
+ B_WL[227] B_WL[228] B_WL[229] B_WL[230] B_WL[231] B_WL[232] B_WL[233]
+ B_WL[234] B_WL[235] B_WL[236] B_WL[237] B_WL[238] B_WL[239] B_WL[240]
+ B_WL[241] B_WL[242] B_WL[243] B_WL[244] B_WL[245] B_WL[246] B_WL[247]
+ B_WL[248] B_WL[249] B_WL[250] B_WL[251] B_WL[252] B_WL[253] B_WL[254]
+ B_WL[255] A_RDL[0] A_SMPRS_0[3] A_SMPRS_0[2] A_SMPRS_0[1] A_SMPRS_0[0]
+ A_SOE[0] A_WRTL[0] A_YSEL_0[7] A_YSEL_0[6] A_YSEL_0[5] A_YSEL_0[4]
+ A_YSEL_0[3] A_YSEL_0[2] A_YSEL_0[1] A_YSEL_0[0] B_RDL[0] B_SMPRS_0[3]
+ B_SMPRS_0[2] B_SMPRS_0[1] B_SMPRS_0[0] B_SOE[0] B_WRTL[0] B_YSEL_0[7]
+ B_YSEL_0[6] B_YSEL_0[5] B_YSEL_0[4] B_YSEL_0[3] B_YSEL_0[2] B_YSEL_0[1]
+ B_YSEL_0[0] AWTI BWEBA[17] BWEBMA[17] A_CKD DA[17] A_DLRS DMA[17] A_WENB[3]
+ A_WENB[2] A_WENB[1] A_WENB[0] BISTC BISTT BWEBB[17] BWEBMB[17] B_CKD DB[17]
+ B_DLRS DMB[17] B_WENB[3] B_WENB[2] B_WENB[1] B_WENB[0] QA[17] QB[17]
+  SDL400W20S_NBITSLC
XBIT18 A_WL[0] A_WL[1] A_WL[2] A_WL[3] A_WL[4] A_WL[5] A_WL[6] A_WL[7] A_WL[8]
+ A_WL[9] A_WL[10] A_WL[11] A_WL[12] A_WL[13] A_WL[14] A_WL[15] A_WL[16]
+ A_WL[17] A_WL[18] A_WL[19] A_WL[20] A_WL[21] A_WL[22] A_WL[23] A_WL[24]
+ A_WL[25] A_WL[26] A_WL[27] A_WL[28] A_WL[29] A_WL[30] A_WL[31] A_WL[32]
+ A_WL[33] A_WL[34] A_WL[35] A_WL[36] A_WL[37] A_WL[38] A_WL[39] A_WL[40]
+ A_WL[41] A_WL[42] A_WL[43] A_WL[44] A_WL[45] A_WL[46] A_WL[47] A_WL[48]
+ A_WL[49] A_WL[50] A_WL[51] A_WL[52] A_WL[53] A_WL[54] A_WL[55] A_WL[56]
+ A_WL[57] A_WL[58] A_WL[59] A_WL[60] A_WL[61] A_WL[62] A_WL[63] A_WL[64]
+ A_WL[65] A_WL[66] A_WL[67] A_WL[68] A_WL[69] A_WL[70] A_WL[71] A_WL[72]
+ A_WL[73] A_WL[74] A_WL[75] A_WL[76] A_WL[77] A_WL[78] A_WL[79] A_WL[80]
+ A_WL[81] A_WL[82] A_WL[83] A_WL[84] A_WL[85] A_WL[86] A_WL[87] A_WL[88]
+ A_WL[89] A_WL[90] A_WL[91] A_WL[92] A_WL[93] A_WL[94] A_WL[95] A_WL[96]
+ A_WL[97] A_WL[98] A_WL[99] A_WL[100] A_WL[101] A_WL[102] A_WL[103] A_WL[104]
+ A_WL[105] A_WL[106] A_WL[107] A_WL[108] A_WL[109] A_WL[110] A_WL[111]
+ A_WL[112] A_WL[113] A_WL[114] A_WL[115] A_WL[116] A_WL[117] A_WL[118]
+ A_WL[119] A_WL[120] A_WL[121] A_WL[122] A_WL[123] A_WL[124] A_WL[125]
+ A_WL[126] A_WL[127] A_WL[128] A_WL[129] A_WL[130] A_WL[131] A_WL[132]
+ A_WL[133] A_WL[134] A_WL[135] A_WL[136] A_WL[137] A_WL[138] A_WL[139]
+ A_WL[140] A_WL[141] A_WL[142] A_WL[143] A_WL[144] A_WL[145] A_WL[146]
+ A_WL[147] A_WL[148] A_WL[149] A_WL[150] A_WL[151] A_WL[152] A_WL[153]
+ A_WL[154] A_WL[155] A_WL[156] A_WL[157] A_WL[158] A_WL[159] A_WL[160]
+ A_WL[161] A_WL[162] A_WL[163] A_WL[164] A_WL[165] A_WL[166] A_WL[167]
+ A_WL[168] A_WL[169] A_WL[170] A_WL[171] A_WL[172] A_WL[173] A_WL[174]
+ A_WL[175] A_WL[176] A_WL[177] A_WL[178] A_WL[179] A_WL[180] A_WL[181]
+ A_WL[182] A_WL[183] A_WL[184] A_WL[185] A_WL[186] A_WL[187] A_WL[188]
+ A_WL[189] A_WL[190] A_WL[191] A_WL[192] A_WL[193] A_WL[194] A_WL[195]
+ A_WL[196] A_WL[197] A_WL[198] A_WL[199] A_WL[200] A_WL[201] A_WL[202]
+ A_WL[203] A_WL[204] A_WL[205] A_WL[206] A_WL[207] A_WL[208] A_WL[209]
+ A_WL[210] A_WL[211] A_WL[212] A_WL[213] A_WL[214] A_WL[215] A_WL[216]
+ A_WL[217] A_WL[218] A_WL[219] A_WL[220] A_WL[221] A_WL[222] A_WL[223]
+ A_WL[224] A_WL[225] A_WL[226] A_WL[227] A_WL[228] A_WL[229] A_WL[230]
+ A_WL[231] A_WL[232] A_WL[233] A_WL[234] A_WL[235] A_WL[236] A_WL[237]
+ A_WL[238] A_WL[239] A_WL[240] A_WL[241] A_WL[242] A_WL[243] A_WL[244]
+ A_WL[245] A_WL[246] A_WL[247] A_WL[248] A_WL[249] A_WL[250] A_WL[251]
+ A_WL[252] A_WL[253] A_WL[254] A_WL[255] B_WL[0] B_WL[1] B_WL[2] B_WL[3]
+ B_WL[4] B_WL[5] B_WL[6] B_WL[7] B_WL[8] B_WL[9] B_WL[10] B_WL[11] B_WL[12]
+ B_WL[13] B_WL[14] B_WL[15] B_WL[16] B_WL[17] B_WL[18] B_WL[19] B_WL[20]
+ B_WL[21] B_WL[22] B_WL[23] B_WL[24] B_WL[25] B_WL[26] B_WL[27] B_WL[28]
+ B_WL[29] B_WL[30] B_WL[31] B_WL[32] B_WL[33] B_WL[34] B_WL[35] B_WL[36]
+ B_WL[37] B_WL[38] B_WL[39] B_WL[40] B_WL[41] B_WL[42] B_WL[43] B_WL[44]
+ B_WL[45] B_WL[46] B_WL[47] B_WL[48] B_WL[49] B_WL[50] B_WL[51] B_WL[52]
+ B_WL[53] B_WL[54] B_WL[55] B_WL[56] B_WL[57] B_WL[58] B_WL[59] B_WL[60]
+ B_WL[61] B_WL[62] B_WL[63] B_WL[64] B_WL[65] B_WL[66] B_WL[67] B_WL[68]
+ B_WL[69] B_WL[70] B_WL[71] B_WL[72] B_WL[73] B_WL[74] B_WL[75] B_WL[76]
+ B_WL[77] B_WL[78] B_WL[79] B_WL[80] B_WL[81] B_WL[82] B_WL[83] B_WL[84]
+ B_WL[85] B_WL[86] B_WL[87] B_WL[88] B_WL[89] B_WL[90] B_WL[91] B_WL[92]
+ B_WL[93] B_WL[94] B_WL[95] B_WL[96] B_WL[97] B_WL[98] B_WL[99] B_WL[100]
+ B_WL[101] B_WL[102] B_WL[103] B_WL[104] B_WL[105] B_WL[106] B_WL[107]
+ B_WL[108] B_WL[109] B_WL[110] B_WL[111] B_WL[112] B_WL[113] B_WL[114]
+ B_WL[115] B_WL[116] B_WL[117] B_WL[118] B_WL[119] B_WL[120] B_WL[121]
+ B_WL[122] B_WL[123] B_WL[124] B_WL[125] B_WL[126] B_WL[127] B_WL[128]
+ B_WL[129] B_WL[130] B_WL[131] B_WL[132] B_WL[133] B_WL[134] B_WL[135]
+ B_WL[136] B_WL[137] B_WL[138] B_WL[139] B_WL[140] B_WL[141] B_WL[142]
+ B_WL[143] B_WL[144] B_WL[145] B_WL[146] B_WL[147] B_WL[148] B_WL[149]
+ B_WL[150] B_WL[151] B_WL[152] B_WL[153] B_WL[154] B_WL[155] B_WL[156]
+ B_WL[157] B_WL[158] B_WL[159] B_WL[160] B_WL[161] B_WL[162] B_WL[163]
+ B_WL[164] B_WL[165] B_WL[166] B_WL[167] B_WL[168] B_WL[169] B_WL[170]
+ B_WL[171] B_WL[172] B_WL[173] B_WL[174] B_WL[175] B_WL[176] B_WL[177]
+ B_WL[178] B_WL[179] B_WL[180] B_WL[181] B_WL[182] B_WL[183] B_WL[184]
+ B_WL[185] B_WL[186] B_WL[187] B_WL[188] B_WL[189] B_WL[190] B_WL[191]
+ B_WL[192] B_WL[193] B_WL[194] B_WL[195] B_WL[196] B_WL[197] B_WL[198]
+ B_WL[199] B_WL[200] B_WL[201] B_WL[202] B_WL[203] B_WL[204] B_WL[205]
+ B_WL[206] B_WL[207] B_WL[208] B_WL[209] B_WL[210] B_WL[211] B_WL[212]
+ B_WL[213] B_WL[214] B_WL[215] B_WL[216] B_WL[217] B_WL[218] B_WL[219]
+ B_WL[220] B_WL[221] B_WL[222] B_WL[223] B_WL[224] B_WL[225] B_WL[226]
+ B_WL[227] B_WL[228] B_WL[229] B_WL[230] B_WL[231] B_WL[232] B_WL[233]
+ B_WL[234] B_WL[235] B_WL[236] B_WL[237] B_WL[238] B_WL[239] B_WL[240]
+ B_WL[241] B_WL[242] B_WL[243] B_WL[244] B_WL[245] B_WL[246] B_WL[247]
+ B_WL[248] B_WL[249] B_WL[250] B_WL[251] B_WL[252] B_WL[253] B_WL[254]
+ B_WL[255] A_RDL[0] A_SMPRS_0[3] A_SMPRS_0[2] A_SMPRS_0[1] A_SMPRS_0[0]
+ A_SOE[0] A_WRTL[0] A_YSEL_0[7] A_YSEL_0[6] A_YSEL_0[5] A_YSEL_0[4]
+ A_YSEL_0[3] A_YSEL_0[2] A_YSEL_0[1] A_YSEL_0[0] B_RDL[0] B_SMPRS_0[3]
+ B_SMPRS_0[2] B_SMPRS_0[1] B_SMPRS_0[0] B_SOE[0] B_WRTL[0] B_YSEL_0[7]
+ B_YSEL_0[6] B_YSEL_0[5] B_YSEL_0[4] B_YSEL_0[3] B_YSEL_0[2] B_YSEL_0[1]
+ B_YSEL_0[0] AWTI BWEBA[18] BWEBMA[18] A_CKD DA[18] A_DLRS DMA[18] A_WENB[3]
+ A_WENB[2] A_WENB[1] A_WENB[0] BISTC BISTT BWEBB[18] BWEBMB[18] B_CKD DB[18]
+ B_DLRS DMB[18] B_WENB[3] B_WENB[2] B_WENB[1] B_WENB[0] QA[18] QB[18]
+  SDL400W20S_NBITSLC
XBIT19 A_WL[0] A_WL[1] A_WL[2] A_WL[3] A_WL[4] A_WL[5] A_WL[6] A_WL[7] A_WL[8]
+ A_WL[9] A_WL[10] A_WL[11] A_WL[12] A_WL[13] A_WL[14] A_WL[15] A_WL[16]
+ A_WL[17] A_WL[18] A_WL[19] A_WL[20] A_WL[21] A_WL[22] A_WL[23] A_WL[24]
+ A_WL[25] A_WL[26] A_WL[27] A_WL[28] A_WL[29] A_WL[30] A_WL[31] A_WL[32]
+ A_WL[33] A_WL[34] A_WL[35] A_WL[36] A_WL[37] A_WL[38] A_WL[39] A_WL[40]
+ A_WL[41] A_WL[42] A_WL[43] A_WL[44] A_WL[45] A_WL[46] A_WL[47] A_WL[48]
+ A_WL[49] A_WL[50] A_WL[51] A_WL[52] A_WL[53] A_WL[54] A_WL[55] A_WL[56]
+ A_WL[57] A_WL[58] A_WL[59] A_WL[60] A_WL[61] A_WL[62] A_WL[63] A_WL[64]
+ A_WL[65] A_WL[66] A_WL[67] A_WL[68] A_WL[69] A_WL[70] A_WL[71] A_WL[72]
+ A_WL[73] A_WL[74] A_WL[75] A_WL[76] A_WL[77] A_WL[78] A_WL[79] A_WL[80]
+ A_WL[81] A_WL[82] A_WL[83] A_WL[84] A_WL[85] A_WL[86] A_WL[87] A_WL[88]
+ A_WL[89] A_WL[90] A_WL[91] A_WL[92] A_WL[93] A_WL[94] A_WL[95] A_WL[96]
+ A_WL[97] A_WL[98] A_WL[99] A_WL[100] A_WL[101] A_WL[102] A_WL[103] A_WL[104]
+ A_WL[105] A_WL[106] A_WL[107] A_WL[108] A_WL[109] A_WL[110] A_WL[111]
+ A_WL[112] A_WL[113] A_WL[114] A_WL[115] A_WL[116] A_WL[117] A_WL[118]
+ A_WL[119] A_WL[120] A_WL[121] A_WL[122] A_WL[123] A_WL[124] A_WL[125]
+ A_WL[126] A_WL[127] A_WL[128] A_WL[129] A_WL[130] A_WL[131] A_WL[132]
+ A_WL[133] A_WL[134] A_WL[135] A_WL[136] A_WL[137] A_WL[138] A_WL[139]
+ A_WL[140] A_WL[141] A_WL[142] A_WL[143] A_WL[144] A_WL[145] A_WL[146]
+ A_WL[147] A_WL[148] A_WL[149] A_WL[150] A_WL[151] A_WL[152] A_WL[153]
+ A_WL[154] A_WL[155] A_WL[156] A_WL[157] A_WL[158] A_WL[159] A_WL[160]
+ A_WL[161] A_WL[162] A_WL[163] A_WL[164] A_WL[165] A_WL[166] A_WL[167]
+ A_WL[168] A_WL[169] A_WL[170] A_WL[171] A_WL[172] A_WL[173] A_WL[174]
+ A_WL[175] A_WL[176] A_WL[177] A_WL[178] A_WL[179] A_WL[180] A_WL[181]
+ A_WL[182] A_WL[183] A_WL[184] A_WL[185] A_WL[186] A_WL[187] A_WL[188]
+ A_WL[189] A_WL[190] A_WL[191] A_WL[192] A_WL[193] A_WL[194] A_WL[195]
+ A_WL[196] A_WL[197] A_WL[198] A_WL[199] A_WL[200] A_WL[201] A_WL[202]
+ A_WL[203] A_WL[204] A_WL[205] A_WL[206] A_WL[207] A_WL[208] A_WL[209]
+ A_WL[210] A_WL[211] A_WL[212] A_WL[213] A_WL[214] A_WL[215] A_WL[216]
+ A_WL[217] A_WL[218] A_WL[219] A_WL[220] A_WL[221] A_WL[222] A_WL[223]
+ A_WL[224] A_WL[225] A_WL[226] A_WL[227] A_WL[228] A_WL[229] A_WL[230]
+ A_WL[231] A_WL[232] A_WL[233] A_WL[234] A_WL[235] A_WL[236] A_WL[237]
+ A_WL[238] A_WL[239] A_WL[240] A_WL[241] A_WL[242] A_WL[243] A_WL[244]
+ A_WL[245] A_WL[246] A_WL[247] A_WL[248] A_WL[249] A_WL[250] A_WL[251]
+ A_WL[252] A_WL[253] A_WL[254] A_WL[255] B_WL[0] B_WL[1] B_WL[2] B_WL[3]
+ B_WL[4] B_WL[5] B_WL[6] B_WL[7] B_WL[8] B_WL[9] B_WL[10] B_WL[11] B_WL[12]
+ B_WL[13] B_WL[14] B_WL[15] B_WL[16] B_WL[17] B_WL[18] B_WL[19] B_WL[20]
+ B_WL[21] B_WL[22] B_WL[23] B_WL[24] B_WL[25] B_WL[26] B_WL[27] B_WL[28]
+ B_WL[29] B_WL[30] B_WL[31] B_WL[32] B_WL[33] B_WL[34] B_WL[35] B_WL[36]
+ B_WL[37] B_WL[38] B_WL[39] B_WL[40] B_WL[41] B_WL[42] B_WL[43] B_WL[44]
+ B_WL[45] B_WL[46] B_WL[47] B_WL[48] B_WL[49] B_WL[50] B_WL[51] B_WL[52]
+ B_WL[53] B_WL[54] B_WL[55] B_WL[56] B_WL[57] B_WL[58] B_WL[59] B_WL[60]
+ B_WL[61] B_WL[62] B_WL[63] B_WL[64] B_WL[65] B_WL[66] B_WL[67] B_WL[68]
+ B_WL[69] B_WL[70] B_WL[71] B_WL[72] B_WL[73] B_WL[74] B_WL[75] B_WL[76]
+ B_WL[77] B_WL[78] B_WL[79] B_WL[80] B_WL[81] B_WL[82] B_WL[83] B_WL[84]
+ B_WL[85] B_WL[86] B_WL[87] B_WL[88] B_WL[89] B_WL[90] B_WL[91] B_WL[92]
+ B_WL[93] B_WL[94] B_WL[95] B_WL[96] B_WL[97] B_WL[98] B_WL[99] B_WL[100]
+ B_WL[101] B_WL[102] B_WL[103] B_WL[104] B_WL[105] B_WL[106] B_WL[107]
+ B_WL[108] B_WL[109] B_WL[110] B_WL[111] B_WL[112] B_WL[113] B_WL[114]
+ B_WL[115] B_WL[116] B_WL[117] B_WL[118] B_WL[119] B_WL[120] B_WL[121]
+ B_WL[122] B_WL[123] B_WL[124] B_WL[125] B_WL[126] B_WL[127] B_WL[128]
+ B_WL[129] B_WL[130] B_WL[131] B_WL[132] B_WL[133] B_WL[134] B_WL[135]
+ B_WL[136] B_WL[137] B_WL[138] B_WL[139] B_WL[140] B_WL[141] B_WL[142]
+ B_WL[143] B_WL[144] B_WL[145] B_WL[146] B_WL[147] B_WL[148] B_WL[149]
+ B_WL[150] B_WL[151] B_WL[152] B_WL[153] B_WL[154] B_WL[155] B_WL[156]
+ B_WL[157] B_WL[158] B_WL[159] B_WL[160] B_WL[161] B_WL[162] B_WL[163]
+ B_WL[164] B_WL[165] B_WL[166] B_WL[167] B_WL[168] B_WL[169] B_WL[170]
+ B_WL[171] B_WL[172] B_WL[173] B_WL[174] B_WL[175] B_WL[176] B_WL[177]
+ B_WL[178] B_WL[179] B_WL[180] B_WL[181] B_WL[182] B_WL[183] B_WL[184]
+ B_WL[185] B_WL[186] B_WL[187] B_WL[188] B_WL[189] B_WL[190] B_WL[191]
+ B_WL[192] B_WL[193] B_WL[194] B_WL[195] B_WL[196] B_WL[197] B_WL[198]
+ B_WL[199] B_WL[200] B_WL[201] B_WL[202] B_WL[203] B_WL[204] B_WL[205]
+ B_WL[206] B_WL[207] B_WL[208] B_WL[209] B_WL[210] B_WL[211] B_WL[212]
+ B_WL[213] B_WL[214] B_WL[215] B_WL[216] B_WL[217] B_WL[218] B_WL[219]
+ B_WL[220] B_WL[221] B_WL[222] B_WL[223] B_WL[224] B_WL[225] B_WL[226]
+ B_WL[227] B_WL[228] B_WL[229] B_WL[230] B_WL[231] B_WL[232] B_WL[233]
+ B_WL[234] B_WL[235] B_WL[236] B_WL[237] B_WL[238] B_WL[239] B_WL[240]
+ B_WL[241] B_WL[242] B_WL[243] B_WL[244] B_WL[245] B_WL[246] B_WL[247]
+ B_WL[248] B_WL[249] B_WL[250] B_WL[251] B_WL[252] B_WL[253] B_WL[254]
+ B_WL[255] A_RDL[0] A_SMPRS_0[3] A_SMPRS_0[2] A_SMPRS_0[1] A_SMPRS_0[0]
+ A_SOE[0] A_WRTL[0] A_YSEL_0[7] A_YSEL_0[6] A_YSEL_0[5] A_YSEL_0[4]
+ A_YSEL_0[3] A_YSEL_0[2] A_YSEL_0[1] A_YSEL_0[0] B_RDL[0] B_SMPRS_0[3]
+ B_SMPRS_0[2] B_SMPRS_0[1] B_SMPRS_0[0] B_SOE[0] B_WRTL[0] B_YSEL_0[7]
+ B_YSEL_0[6] B_YSEL_0[5] B_YSEL_0[4] B_YSEL_0[3] B_YSEL_0[2] B_YSEL_0[1]
+ B_YSEL_0[0] AWTI BWEBA[19] BWEBMA[19] A_CKD DA[19] A_DLRS DMA[19] A_WENB[3]
+ A_WENB[2] A_WENB[1] A_WENB[0] BISTC BISTT BWEBB[19] BWEBMB[19] B_CKD DB[19]
+ B_DLRS DMB[19] B_WENB[3] B_WENB[2] B_WENB[1] B_WENB[0] QA[19] QB[19]
+  SDL400W20S_NBITSLC
XBIT20 A_WL[0] A_WL[1] A_WL[2] A_WL[3] A_WL[4] A_WL[5] A_WL[6] A_WL[7] A_WL[8]
+ A_WL[9] A_WL[10] A_WL[11] A_WL[12] A_WL[13] A_WL[14] A_WL[15] A_WL[16]
+ A_WL[17] A_WL[18] A_WL[19] A_WL[20] A_WL[21] A_WL[22] A_WL[23] A_WL[24]
+ A_WL[25] A_WL[26] A_WL[27] A_WL[28] A_WL[29] A_WL[30] A_WL[31] A_WL[32]
+ A_WL[33] A_WL[34] A_WL[35] A_WL[36] A_WL[37] A_WL[38] A_WL[39] A_WL[40]
+ A_WL[41] A_WL[42] A_WL[43] A_WL[44] A_WL[45] A_WL[46] A_WL[47] A_WL[48]
+ A_WL[49] A_WL[50] A_WL[51] A_WL[52] A_WL[53] A_WL[54] A_WL[55] A_WL[56]
+ A_WL[57] A_WL[58] A_WL[59] A_WL[60] A_WL[61] A_WL[62] A_WL[63] A_WL[64]
+ A_WL[65] A_WL[66] A_WL[67] A_WL[68] A_WL[69] A_WL[70] A_WL[71] A_WL[72]
+ A_WL[73] A_WL[74] A_WL[75] A_WL[76] A_WL[77] A_WL[78] A_WL[79] A_WL[80]
+ A_WL[81] A_WL[82] A_WL[83] A_WL[84] A_WL[85] A_WL[86] A_WL[87] A_WL[88]
+ A_WL[89] A_WL[90] A_WL[91] A_WL[92] A_WL[93] A_WL[94] A_WL[95] A_WL[96]
+ A_WL[97] A_WL[98] A_WL[99] A_WL[100] A_WL[101] A_WL[102] A_WL[103] A_WL[104]
+ A_WL[105] A_WL[106] A_WL[107] A_WL[108] A_WL[109] A_WL[110] A_WL[111]
+ A_WL[112] A_WL[113] A_WL[114] A_WL[115] A_WL[116] A_WL[117] A_WL[118]
+ A_WL[119] A_WL[120] A_WL[121] A_WL[122] A_WL[123] A_WL[124] A_WL[125]
+ A_WL[126] A_WL[127] A_WL[128] A_WL[129] A_WL[130] A_WL[131] A_WL[132]
+ A_WL[133] A_WL[134] A_WL[135] A_WL[136] A_WL[137] A_WL[138] A_WL[139]
+ A_WL[140] A_WL[141] A_WL[142] A_WL[143] A_WL[144] A_WL[145] A_WL[146]
+ A_WL[147] A_WL[148] A_WL[149] A_WL[150] A_WL[151] A_WL[152] A_WL[153]
+ A_WL[154] A_WL[155] A_WL[156] A_WL[157] A_WL[158] A_WL[159] A_WL[160]
+ A_WL[161] A_WL[162] A_WL[163] A_WL[164] A_WL[165] A_WL[166] A_WL[167]
+ A_WL[168] A_WL[169] A_WL[170] A_WL[171] A_WL[172] A_WL[173] A_WL[174]
+ A_WL[175] A_WL[176] A_WL[177] A_WL[178] A_WL[179] A_WL[180] A_WL[181]
+ A_WL[182] A_WL[183] A_WL[184] A_WL[185] A_WL[186] A_WL[187] A_WL[188]
+ A_WL[189] A_WL[190] A_WL[191] A_WL[192] A_WL[193] A_WL[194] A_WL[195]
+ A_WL[196] A_WL[197] A_WL[198] A_WL[199] A_WL[200] A_WL[201] A_WL[202]
+ A_WL[203] A_WL[204] A_WL[205] A_WL[206] A_WL[207] A_WL[208] A_WL[209]
+ A_WL[210] A_WL[211] A_WL[212] A_WL[213] A_WL[214] A_WL[215] A_WL[216]
+ A_WL[217] A_WL[218] A_WL[219] A_WL[220] A_WL[221] A_WL[222] A_WL[223]
+ A_WL[224] A_WL[225] A_WL[226] A_WL[227] A_WL[228] A_WL[229] A_WL[230]
+ A_WL[231] A_WL[232] A_WL[233] A_WL[234] A_WL[235] A_WL[236] A_WL[237]
+ A_WL[238] A_WL[239] A_WL[240] A_WL[241] A_WL[242] A_WL[243] A_WL[244]
+ A_WL[245] A_WL[246] A_WL[247] A_WL[248] A_WL[249] A_WL[250] A_WL[251]
+ A_WL[252] A_WL[253] A_WL[254] A_WL[255] B_WL[0] B_WL[1] B_WL[2] B_WL[3]
+ B_WL[4] B_WL[5] B_WL[6] B_WL[7] B_WL[8] B_WL[9] B_WL[10] B_WL[11] B_WL[12]
+ B_WL[13] B_WL[14] B_WL[15] B_WL[16] B_WL[17] B_WL[18] B_WL[19] B_WL[20]
+ B_WL[21] B_WL[22] B_WL[23] B_WL[24] B_WL[25] B_WL[26] B_WL[27] B_WL[28]
+ B_WL[29] B_WL[30] B_WL[31] B_WL[32] B_WL[33] B_WL[34] B_WL[35] B_WL[36]
+ B_WL[37] B_WL[38] B_WL[39] B_WL[40] B_WL[41] B_WL[42] B_WL[43] B_WL[44]
+ B_WL[45] B_WL[46] B_WL[47] B_WL[48] B_WL[49] B_WL[50] B_WL[51] B_WL[52]
+ B_WL[53] B_WL[54] B_WL[55] B_WL[56] B_WL[57] B_WL[58] B_WL[59] B_WL[60]
+ B_WL[61] B_WL[62] B_WL[63] B_WL[64] B_WL[65] B_WL[66] B_WL[67] B_WL[68]
+ B_WL[69] B_WL[70] B_WL[71] B_WL[72] B_WL[73] B_WL[74] B_WL[75] B_WL[76]
+ B_WL[77] B_WL[78] B_WL[79] B_WL[80] B_WL[81] B_WL[82] B_WL[83] B_WL[84]
+ B_WL[85] B_WL[86] B_WL[87] B_WL[88] B_WL[89] B_WL[90] B_WL[91] B_WL[92]
+ B_WL[93] B_WL[94] B_WL[95] B_WL[96] B_WL[97] B_WL[98] B_WL[99] B_WL[100]
+ B_WL[101] B_WL[102] B_WL[103] B_WL[104] B_WL[105] B_WL[106] B_WL[107]
+ B_WL[108] B_WL[109] B_WL[110] B_WL[111] B_WL[112] B_WL[113] B_WL[114]
+ B_WL[115] B_WL[116] B_WL[117] B_WL[118] B_WL[119] B_WL[120] B_WL[121]
+ B_WL[122] B_WL[123] B_WL[124] B_WL[125] B_WL[126] B_WL[127] B_WL[128]
+ B_WL[129] B_WL[130] B_WL[131] B_WL[132] B_WL[133] B_WL[134] B_WL[135]
+ B_WL[136] B_WL[137] B_WL[138] B_WL[139] B_WL[140] B_WL[141] B_WL[142]
+ B_WL[143] B_WL[144] B_WL[145] B_WL[146] B_WL[147] B_WL[148] B_WL[149]
+ B_WL[150] B_WL[151] B_WL[152] B_WL[153] B_WL[154] B_WL[155] B_WL[156]
+ B_WL[157] B_WL[158] B_WL[159] B_WL[160] B_WL[161] B_WL[162] B_WL[163]
+ B_WL[164] B_WL[165] B_WL[166] B_WL[167] B_WL[168] B_WL[169] B_WL[170]
+ B_WL[171] B_WL[172] B_WL[173] B_WL[174] B_WL[175] B_WL[176] B_WL[177]
+ B_WL[178] B_WL[179] B_WL[180] B_WL[181] B_WL[182] B_WL[183] B_WL[184]
+ B_WL[185] B_WL[186] B_WL[187] B_WL[188] B_WL[189] B_WL[190] B_WL[191]
+ B_WL[192] B_WL[193] B_WL[194] B_WL[195] B_WL[196] B_WL[197] B_WL[198]
+ B_WL[199] B_WL[200] B_WL[201] B_WL[202] B_WL[203] B_WL[204] B_WL[205]
+ B_WL[206] B_WL[207] B_WL[208] B_WL[209] B_WL[210] B_WL[211] B_WL[212]
+ B_WL[213] B_WL[214] B_WL[215] B_WL[216] B_WL[217] B_WL[218] B_WL[219]
+ B_WL[220] B_WL[221] B_WL[222] B_WL[223] B_WL[224] B_WL[225] B_WL[226]
+ B_WL[227] B_WL[228] B_WL[229] B_WL[230] B_WL[231] B_WL[232] B_WL[233]
+ B_WL[234] B_WL[235] B_WL[236] B_WL[237] B_WL[238] B_WL[239] B_WL[240]
+ B_WL[241] B_WL[242] B_WL[243] B_WL[244] B_WL[245] B_WL[246] B_WL[247]
+ B_WL[248] B_WL[249] B_WL[250] B_WL[251] B_WL[252] B_WL[253] B_WL[254]
+ B_WL[255] A_RDL[0] A_SMPRS_0[3] A_SMPRS_0[2] A_SMPRS_0[1] A_SMPRS_0[0]
+ A_SOE[0] A_WRTL[0] A_YSEL_0[7] A_YSEL_0[6] A_YSEL_0[5] A_YSEL_0[4]
+ A_YSEL_0[3] A_YSEL_0[2] A_YSEL_0[1] A_YSEL_0[0] B_RDL[0] B_SMPRS_0[3]
+ B_SMPRS_0[2] B_SMPRS_0[1] B_SMPRS_0[0] B_SOE[0] B_WRTL[0] B_YSEL_0[7]
+ B_YSEL_0[6] B_YSEL_0[5] B_YSEL_0[4] B_YSEL_0[3] B_YSEL_0[2] B_YSEL_0[1]
+ B_YSEL_0[0] AWTI BWEBA[20] BWEBMA[20] A_CKD DA[20] A_DLRS DMA[20] A_WENB[3]
+ A_WENB[2] A_WENB[1] A_WENB[0] BISTC BISTT BWEBB[20] BWEBMB[20] B_CKD DB[20]
+ B_DLRS DMB[20] B_WENB[3] B_WENB[2] B_WENB[1] B_WENB[0] QA[20] QB[20]
+  SDL400W20S_NBITSLC
XBIT21 A_WL[0] A_WL[1] A_WL[2] A_WL[3] A_WL[4] A_WL[5] A_WL[6] A_WL[7] A_WL[8]
+ A_WL[9] A_WL[10] A_WL[11] A_WL[12] A_WL[13] A_WL[14] A_WL[15] A_WL[16]
+ A_WL[17] A_WL[18] A_WL[19] A_WL[20] A_WL[21] A_WL[22] A_WL[23] A_WL[24]
+ A_WL[25] A_WL[26] A_WL[27] A_WL[28] A_WL[29] A_WL[30] A_WL[31] A_WL[32]
+ A_WL[33] A_WL[34] A_WL[35] A_WL[36] A_WL[37] A_WL[38] A_WL[39] A_WL[40]
+ A_WL[41] A_WL[42] A_WL[43] A_WL[44] A_WL[45] A_WL[46] A_WL[47] A_WL[48]
+ A_WL[49] A_WL[50] A_WL[51] A_WL[52] A_WL[53] A_WL[54] A_WL[55] A_WL[56]
+ A_WL[57] A_WL[58] A_WL[59] A_WL[60] A_WL[61] A_WL[62] A_WL[63] A_WL[64]
+ A_WL[65] A_WL[66] A_WL[67] A_WL[68] A_WL[69] A_WL[70] A_WL[71] A_WL[72]
+ A_WL[73] A_WL[74] A_WL[75] A_WL[76] A_WL[77] A_WL[78] A_WL[79] A_WL[80]
+ A_WL[81] A_WL[82] A_WL[83] A_WL[84] A_WL[85] A_WL[86] A_WL[87] A_WL[88]
+ A_WL[89] A_WL[90] A_WL[91] A_WL[92] A_WL[93] A_WL[94] A_WL[95] A_WL[96]
+ A_WL[97] A_WL[98] A_WL[99] A_WL[100] A_WL[101] A_WL[102] A_WL[103] A_WL[104]
+ A_WL[105] A_WL[106] A_WL[107] A_WL[108] A_WL[109] A_WL[110] A_WL[111]
+ A_WL[112] A_WL[113] A_WL[114] A_WL[115] A_WL[116] A_WL[117] A_WL[118]
+ A_WL[119] A_WL[120] A_WL[121] A_WL[122] A_WL[123] A_WL[124] A_WL[125]
+ A_WL[126] A_WL[127] A_WL[128] A_WL[129] A_WL[130] A_WL[131] A_WL[132]
+ A_WL[133] A_WL[134] A_WL[135] A_WL[136] A_WL[137] A_WL[138] A_WL[139]
+ A_WL[140] A_WL[141] A_WL[142] A_WL[143] A_WL[144] A_WL[145] A_WL[146]
+ A_WL[147] A_WL[148] A_WL[149] A_WL[150] A_WL[151] A_WL[152] A_WL[153]
+ A_WL[154] A_WL[155] A_WL[156] A_WL[157] A_WL[158] A_WL[159] A_WL[160]
+ A_WL[161] A_WL[162] A_WL[163] A_WL[164] A_WL[165] A_WL[166] A_WL[167]
+ A_WL[168] A_WL[169] A_WL[170] A_WL[171] A_WL[172] A_WL[173] A_WL[174]
+ A_WL[175] A_WL[176] A_WL[177] A_WL[178] A_WL[179] A_WL[180] A_WL[181]
+ A_WL[182] A_WL[183] A_WL[184] A_WL[185] A_WL[186] A_WL[187] A_WL[188]
+ A_WL[189] A_WL[190] A_WL[191] A_WL[192] A_WL[193] A_WL[194] A_WL[195]
+ A_WL[196] A_WL[197] A_WL[198] A_WL[199] A_WL[200] A_WL[201] A_WL[202]
+ A_WL[203] A_WL[204] A_WL[205] A_WL[206] A_WL[207] A_WL[208] A_WL[209]
+ A_WL[210] A_WL[211] A_WL[212] A_WL[213] A_WL[214] A_WL[215] A_WL[216]
+ A_WL[217] A_WL[218] A_WL[219] A_WL[220] A_WL[221] A_WL[222] A_WL[223]
+ A_WL[224] A_WL[225] A_WL[226] A_WL[227] A_WL[228] A_WL[229] A_WL[230]
+ A_WL[231] A_WL[232] A_WL[233] A_WL[234] A_WL[235] A_WL[236] A_WL[237]
+ A_WL[238] A_WL[239] A_WL[240] A_WL[241] A_WL[242] A_WL[243] A_WL[244]
+ A_WL[245] A_WL[246] A_WL[247] A_WL[248] A_WL[249] A_WL[250] A_WL[251]
+ A_WL[252] A_WL[253] A_WL[254] A_WL[255] B_WL[0] B_WL[1] B_WL[2] B_WL[3]
+ B_WL[4] B_WL[5] B_WL[6] B_WL[7] B_WL[8] B_WL[9] B_WL[10] B_WL[11] B_WL[12]
+ B_WL[13] B_WL[14] B_WL[15] B_WL[16] B_WL[17] B_WL[18] B_WL[19] B_WL[20]
+ B_WL[21] B_WL[22] B_WL[23] B_WL[24] B_WL[25] B_WL[26] B_WL[27] B_WL[28]
+ B_WL[29] B_WL[30] B_WL[31] B_WL[32] B_WL[33] B_WL[34] B_WL[35] B_WL[36]
+ B_WL[37] B_WL[38] B_WL[39] B_WL[40] B_WL[41] B_WL[42] B_WL[43] B_WL[44]
+ B_WL[45] B_WL[46] B_WL[47] B_WL[48] B_WL[49] B_WL[50] B_WL[51] B_WL[52]
+ B_WL[53] B_WL[54] B_WL[55] B_WL[56] B_WL[57] B_WL[58] B_WL[59] B_WL[60]
+ B_WL[61] B_WL[62] B_WL[63] B_WL[64] B_WL[65] B_WL[66] B_WL[67] B_WL[68]
+ B_WL[69] B_WL[70] B_WL[71] B_WL[72] B_WL[73] B_WL[74] B_WL[75] B_WL[76]
+ B_WL[77] B_WL[78] B_WL[79] B_WL[80] B_WL[81] B_WL[82] B_WL[83] B_WL[84]
+ B_WL[85] B_WL[86] B_WL[87] B_WL[88] B_WL[89] B_WL[90] B_WL[91] B_WL[92]
+ B_WL[93] B_WL[94] B_WL[95] B_WL[96] B_WL[97] B_WL[98] B_WL[99] B_WL[100]
+ B_WL[101] B_WL[102] B_WL[103] B_WL[104] B_WL[105] B_WL[106] B_WL[107]
+ B_WL[108] B_WL[109] B_WL[110] B_WL[111] B_WL[112] B_WL[113] B_WL[114]
+ B_WL[115] B_WL[116] B_WL[117] B_WL[118] B_WL[119] B_WL[120] B_WL[121]
+ B_WL[122] B_WL[123] B_WL[124] B_WL[125] B_WL[126] B_WL[127] B_WL[128]
+ B_WL[129] B_WL[130] B_WL[131] B_WL[132] B_WL[133] B_WL[134] B_WL[135]
+ B_WL[136] B_WL[137] B_WL[138] B_WL[139] B_WL[140] B_WL[141] B_WL[142]
+ B_WL[143] B_WL[144] B_WL[145] B_WL[146] B_WL[147] B_WL[148] B_WL[149]
+ B_WL[150] B_WL[151] B_WL[152] B_WL[153] B_WL[154] B_WL[155] B_WL[156]
+ B_WL[157] B_WL[158] B_WL[159] B_WL[160] B_WL[161] B_WL[162] B_WL[163]
+ B_WL[164] B_WL[165] B_WL[166] B_WL[167] B_WL[168] B_WL[169] B_WL[170]
+ B_WL[171] B_WL[172] B_WL[173] B_WL[174] B_WL[175] B_WL[176] B_WL[177]
+ B_WL[178] B_WL[179] B_WL[180] B_WL[181] B_WL[182] B_WL[183] B_WL[184]
+ B_WL[185] B_WL[186] B_WL[187] B_WL[188] B_WL[189] B_WL[190] B_WL[191]
+ B_WL[192] B_WL[193] B_WL[194] B_WL[195] B_WL[196] B_WL[197] B_WL[198]
+ B_WL[199] B_WL[200] B_WL[201] B_WL[202] B_WL[203] B_WL[204] B_WL[205]
+ B_WL[206] B_WL[207] B_WL[208] B_WL[209] B_WL[210] B_WL[211] B_WL[212]
+ B_WL[213] B_WL[214] B_WL[215] B_WL[216] B_WL[217] B_WL[218] B_WL[219]
+ B_WL[220] B_WL[221] B_WL[222] B_WL[223] B_WL[224] B_WL[225] B_WL[226]
+ B_WL[227] B_WL[228] B_WL[229] B_WL[230] B_WL[231] B_WL[232] B_WL[233]
+ B_WL[234] B_WL[235] B_WL[236] B_WL[237] B_WL[238] B_WL[239] B_WL[240]
+ B_WL[241] B_WL[242] B_WL[243] B_WL[244] B_WL[245] B_WL[246] B_WL[247]
+ B_WL[248] B_WL[249] B_WL[250] B_WL[251] B_WL[252] B_WL[253] B_WL[254]
+ B_WL[255] A_RDL[0] A_SMPRS_0[3] A_SMPRS_0[2] A_SMPRS_0[1] A_SMPRS_0[0]
+ A_SOE[0] A_WRTL[0] A_YSEL_0[7] A_YSEL_0[6] A_YSEL_0[5] A_YSEL_0[4]
+ A_YSEL_0[3] A_YSEL_0[2] A_YSEL_0[1] A_YSEL_0[0] B_RDL[0] B_SMPRS_0[3]
+ B_SMPRS_0[2] B_SMPRS_0[1] B_SMPRS_0[0] B_SOE[0] B_WRTL[0] B_YSEL_0[7]
+ B_YSEL_0[6] B_YSEL_0[5] B_YSEL_0[4] B_YSEL_0[3] B_YSEL_0[2] B_YSEL_0[1]
+ B_YSEL_0[0] AWTI BWEBA[21] BWEBMA[21] A_CKD DA[21] A_DLRS DMA[21] A_WENB[3]
+ A_WENB[2] A_WENB[1] A_WENB[0] BISTC BISTT BWEBB[21] BWEBMB[21] B_CKD DB[21]
+ B_DLRS DMB[21] B_WENB[3] B_WENB[2] B_WENB[1] B_WENB[0] QA[21] QB[21]
+  SDL400W20S_NBITSLC
XBIT22 A_WL[0] A_WL[1] A_WL[2] A_WL[3] A_WL[4] A_WL[5] A_WL[6] A_WL[7] A_WL[8]
+ A_WL[9] A_WL[10] A_WL[11] A_WL[12] A_WL[13] A_WL[14] A_WL[15] A_WL[16]
+ A_WL[17] A_WL[18] A_WL[19] A_WL[20] A_WL[21] A_WL[22] A_WL[23] A_WL[24]
+ A_WL[25] A_WL[26] A_WL[27] A_WL[28] A_WL[29] A_WL[30] A_WL[31] A_WL[32]
+ A_WL[33] A_WL[34] A_WL[35] A_WL[36] A_WL[37] A_WL[38] A_WL[39] A_WL[40]
+ A_WL[41] A_WL[42] A_WL[43] A_WL[44] A_WL[45] A_WL[46] A_WL[47] A_WL[48]
+ A_WL[49] A_WL[50] A_WL[51] A_WL[52] A_WL[53] A_WL[54] A_WL[55] A_WL[56]
+ A_WL[57] A_WL[58] A_WL[59] A_WL[60] A_WL[61] A_WL[62] A_WL[63] A_WL[64]
+ A_WL[65] A_WL[66] A_WL[67] A_WL[68] A_WL[69] A_WL[70] A_WL[71] A_WL[72]
+ A_WL[73] A_WL[74] A_WL[75] A_WL[76] A_WL[77] A_WL[78] A_WL[79] A_WL[80]
+ A_WL[81] A_WL[82] A_WL[83] A_WL[84] A_WL[85] A_WL[86] A_WL[87] A_WL[88]
+ A_WL[89] A_WL[90] A_WL[91] A_WL[92] A_WL[93] A_WL[94] A_WL[95] A_WL[96]
+ A_WL[97] A_WL[98] A_WL[99] A_WL[100] A_WL[101] A_WL[102] A_WL[103] A_WL[104]
+ A_WL[105] A_WL[106] A_WL[107] A_WL[108] A_WL[109] A_WL[110] A_WL[111]
+ A_WL[112] A_WL[113] A_WL[114] A_WL[115] A_WL[116] A_WL[117] A_WL[118]
+ A_WL[119] A_WL[120] A_WL[121] A_WL[122] A_WL[123] A_WL[124] A_WL[125]
+ A_WL[126] A_WL[127] A_WL[128] A_WL[129] A_WL[130] A_WL[131] A_WL[132]
+ A_WL[133] A_WL[134] A_WL[135] A_WL[136] A_WL[137] A_WL[138] A_WL[139]
+ A_WL[140] A_WL[141] A_WL[142] A_WL[143] A_WL[144] A_WL[145] A_WL[146]
+ A_WL[147] A_WL[148] A_WL[149] A_WL[150] A_WL[151] A_WL[152] A_WL[153]
+ A_WL[154] A_WL[155] A_WL[156] A_WL[157] A_WL[158] A_WL[159] A_WL[160]
+ A_WL[161] A_WL[162] A_WL[163] A_WL[164] A_WL[165] A_WL[166] A_WL[167]
+ A_WL[168] A_WL[169] A_WL[170] A_WL[171] A_WL[172] A_WL[173] A_WL[174]
+ A_WL[175] A_WL[176] A_WL[177] A_WL[178] A_WL[179] A_WL[180] A_WL[181]
+ A_WL[182] A_WL[183] A_WL[184] A_WL[185] A_WL[186] A_WL[187] A_WL[188]
+ A_WL[189] A_WL[190] A_WL[191] A_WL[192] A_WL[193] A_WL[194] A_WL[195]
+ A_WL[196] A_WL[197] A_WL[198] A_WL[199] A_WL[200] A_WL[201] A_WL[202]
+ A_WL[203] A_WL[204] A_WL[205] A_WL[206] A_WL[207] A_WL[208] A_WL[209]
+ A_WL[210] A_WL[211] A_WL[212] A_WL[213] A_WL[214] A_WL[215] A_WL[216]
+ A_WL[217] A_WL[218] A_WL[219] A_WL[220] A_WL[221] A_WL[222] A_WL[223]
+ A_WL[224] A_WL[225] A_WL[226] A_WL[227] A_WL[228] A_WL[229] A_WL[230]
+ A_WL[231] A_WL[232] A_WL[233] A_WL[234] A_WL[235] A_WL[236] A_WL[237]
+ A_WL[238] A_WL[239] A_WL[240] A_WL[241] A_WL[242] A_WL[243] A_WL[244]
+ A_WL[245] A_WL[246] A_WL[247] A_WL[248] A_WL[249] A_WL[250] A_WL[251]
+ A_WL[252] A_WL[253] A_WL[254] A_WL[255] B_WL[0] B_WL[1] B_WL[2] B_WL[3]
+ B_WL[4] B_WL[5] B_WL[6] B_WL[7] B_WL[8] B_WL[9] B_WL[10] B_WL[11] B_WL[12]
+ B_WL[13] B_WL[14] B_WL[15] B_WL[16] B_WL[17] B_WL[18] B_WL[19] B_WL[20]
+ B_WL[21] B_WL[22] B_WL[23] B_WL[24] B_WL[25] B_WL[26] B_WL[27] B_WL[28]
+ B_WL[29] B_WL[30] B_WL[31] B_WL[32] B_WL[33] B_WL[34] B_WL[35] B_WL[36]
+ B_WL[37] B_WL[38] B_WL[39] B_WL[40] B_WL[41] B_WL[42] B_WL[43] B_WL[44]
+ B_WL[45] B_WL[46] B_WL[47] B_WL[48] B_WL[49] B_WL[50] B_WL[51] B_WL[52]
+ B_WL[53] B_WL[54] B_WL[55] B_WL[56] B_WL[57] B_WL[58] B_WL[59] B_WL[60]
+ B_WL[61] B_WL[62] B_WL[63] B_WL[64] B_WL[65] B_WL[66] B_WL[67] B_WL[68]
+ B_WL[69] B_WL[70] B_WL[71] B_WL[72] B_WL[73] B_WL[74] B_WL[75] B_WL[76]
+ B_WL[77] B_WL[78] B_WL[79] B_WL[80] B_WL[81] B_WL[82] B_WL[83] B_WL[84]
+ B_WL[85] B_WL[86] B_WL[87] B_WL[88] B_WL[89] B_WL[90] B_WL[91] B_WL[92]
+ B_WL[93] B_WL[94] B_WL[95] B_WL[96] B_WL[97] B_WL[98] B_WL[99] B_WL[100]
+ B_WL[101] B_WL[102] B_WL[103] B_WL[104] B_WL[105] B_WL[106] B_WL[107]
+ B_WL[108] B_WL[109] B_WL[110] B_WL[111] B_WL[112] B_WL[113] B_WL[114]
+ B_WL[115] B_WL[116] B_WL[117] B_WL[118] B_WL[119] B_WL[120] B_WL[121]
+ B_WL[122] B_WL[123] B_WL[124] B_WL[125] B_WL[126] B_WL[127] B_WL[128]
+ B_WL[129] B_WL[130] B_WL[131] B_WL[132] B_WL[133] B_WL[134] B_WL[135]
+ B_WL[136] B_WL[137] B_WL[138] B_WL[139] B_WL[140] B_WL[141] B_WL[142]
+ B_WL[143] B_WL[144] B_WL[145] B_WL[146] B_WL[147] B_WL[148] B_WL[149]
+ B_WL[150] B_WL[151] B_WL[152] B_WL[153] B_WL[154] B_WL[155] B_WL[156]
+ B_WL[157] B_WL[158] B_WL[159] B_WL[160] B_WL[161] B_WL[162] B_WL[163]
+ B_WL[164] B_WL[165] B_WL[166] B_WL[167] B_WL[168] B_WL[169] B_WL[170]
+ B_WL[171] B_WL[172] B_WL[173] B_WL[174] B_WL[175] B_WL[176] B_WL[177]
+ B_WL[178] B_WL[179] B_WL[180] B_WL[181] B_WL[182] B_WL[183] B_WL[184]
+ B_WL[185] B_WL[186] B_WL[187] B_WL[188] B_WL[189] B_WL[190] B_WL[191]
+ B_WL[192] B_WL[193] B_WL[194] B_WL[195] B_WL[196] B_WL[197] B_WL[198]
+ B_WL[199] B_WL[200] B_WL[201] B_WL[202] B_WL[203] B_WL[204] B_WL[205]
+ B_WL[206] B_WL[207] B_WL[208] B_WL[209] B_WL[210] B_WL[211] B_WL[212]
+ B_WL[213] B_WL[214] B_WL[215] B_WL[216] B_WL[217] B_WL[218] B_WL[219]
+ B_WL[220] B_WL[221] B_WL[222] B_WL[223] B_WL[224] B_WL[225] B_WL[226]
+ B_WL[227] B_WL[228] B_WL[229] B_WL[230] B_WL[231] B_WL[232] B_WL[233]
+ B_WL[234] B_WL[235] B_WL[236] B_WL[237] B_WL[238] B_WL[239] B_WL[240]
+ B_WL[241] B_WL[242] B_WL[243] B_WL[244] B_WL[245] B_WL[246] B_WL[247]
+ B_WL[248] B_WL[249] B_WL[250] B_WL[251] B_WL[252] B_WL[253] B_WL[254]
+ B_WL[255] A_RDL[0] A_SMPRS_0[3] A_SMPRS_0[2] A_SMPRS_0[1] A_SMPRS_0[0]
+ A_SOE[0] A_WRTL[0] A_YSEL_0[7] A_YSEL_0[6] A_YSEL_0[5] A_YSEL_0[4]
+ A_YSEL_0[3] A_YSEL_0[2] A_YSEL_0[1] A_YSEL_0[0] B_RDL[0] B_SMPRS_0[3]
+ B_SMPRS_0[2] B_SMPRS_0[1] B_SMPRS_0[0] B_SOE[0] B_WRTL[0] B_YSEL_0[7]
+ B_YSEL_0[6] B_YSEL_0[5] B_YSEL_0[4] B_YSEL_0[3] B_YSEL_0[2] B_YSEL_0[1]
+ B_YSEL_0[0] AWTI BWEBA[22] BWEBMA[22] A_CKD DA[22] A_DLRS DMA[22] A_WENB[3]
+ A_WENB[2] A_WENB[1] A_WENB[0] BISTC BISTT BWEBB[22] BWEBMB[22] B_CKD DB[22]
+ B_DLRS DMB[22] B_WENB[3] B_WENB[2] B_WENB[1] B_WENB[0] QA[22] QB[22]
+  SDL400W20S_NBITSLC
XBIT23 A_WL[0] A_WL[1] A_WL[2] A_WL[3] A_WL[4] A_WL[5] A_WL[6] A_WL[7] A_WL[8]
+ A_WL[9] A_WL[10] A_WL[11] A_WL[12] A_WL[13] A_WL[14] A_WL[15] A_WL[16]
+ A_WL[17] A_WL[18] A_WL[19] A_WL[20] A_WL[21] A_WL[22] A_WL[23] A_WL[24]
+ A_WL[25] A_WL[26] A_WL[27] A_WL[28] A_WL[29] A_WL[30] A_WL[31] A_WL[32]
+ A_WL[33] A_WL[34] A_WL[35] A_WL[36] A_WL[37] A_WL[38] A_WL[39] A_WL[40]
+ A_WL[41] A_WL[42] A_WL[43] A_WL[44] A_WL[45] A_WL[46] A_WL[47] A_WL[48]
+ A_WL[49] A_WL[50] A_WL[51] A_WL[52] A_WL[53] A_WL[54] A_WL[55] A_WL[56]
+ A_WL[57] A_WL[58] A_WL[59] A_WL[60] A_WL[61] A_WL[62] A_WL[63] A_WL[64]
+ A_WL[65] A_WL[66] A_WL[67] A_WL[68] A_WL[69] A_WL[70] A_WL[71] A_WL[72]
+ A_WL[73] A_WL[74] A_WL[75] A_WL[76] A_WL[77] A_WL[78] A_WL[79] A_WL[80]
+ A_WL[81] A_WL[82] A_WL[83] A_WL[84] A_WL[85] A_WL[86] A_WL[87] A_WL[88]
+ A_WL[89] A_WL[90] A_WL[91] A_WL[92] A_WL[93] A_WL[94] A_WL[95] A_WL[96]
+ A_WL[97] A_WL[98] A_WL[99] A_WL[100] A_WL[101] A_WL[102] A_WL[103] A_WL[104]
+ A_WL[105] A_WL[106] A_WL[107] A_WL[108] A_WL[109] A_WL[110] A_WL[111]
+ A_WL[112] A_WL[113] A_WL[114] A_WL[115] A_WL[116] A_WL[117] A_WL[118]
+ A_WL[119] A_WL[120] A_WL[121] A_WL[122] A_WL[123] A_WL[124] A_WL[125]
+ A_WL[126] A_WL[127] A_WL[128] A_WL[129] A_WL[130] A_WL[131] A_WL[132]
+ A_WL[133] A_WL[134] A_WL[135] A_WL[136] A_WL[137] A_WL[138] A_WL[139]
+ A_WL[140] A_WL[141] A_WL[142] A_WL[143] A_WL[144] A_WL[145] A_WL[146]
+ A_WL[147] A_WL[148] A_WL[149] A_WL[150] A_WL[151] A_WL[152] A_WL[153]
+ A_WL[154] A_WL[155] A_WL[156] A_WL[157] A_WL[158] A_WL[159] A_WL[160]
+ A_WL[161] A_WL[162] A_WL[163] A_WL[164] A_WL[165] A_WL[166] A_WL[167]
+ A_WL[168] A_WL[169] A_WL[170] A_WL[171] A_WL[172] A_WL[173] A_WL[174]
+ A_WL[175] A_WL[176] A_WL[177] A_WL[178] A_WL[179] A_WL[180] A_WL[181]
+ A_WL[182] A_WL[183] A_WL[184] A_WL[185] A_WL[186] A_WL[187] A_WL[188]
+ A_WL[189] A_WL[190] A_WL[191] A_WL[192] A_WL[193] A_WL[194] A_WL[195]
+ A_WL[196] A_WL[197] A_WL[198] A_WL[199] A_WL[200] A_WL[201] A_WL[202]
+ A_WL[203] A_WL[204] A_WL[205] A_WL[206] A_WL[207] A_WL[208] A_WL[209]
+ A_WL[210] A_WL[211] A_WL[212] A_WL[213] A_WL[214] A_WL[215] A_WL[216]
+ A_WL[217] A_WL[218] A_WL[219] A_WL[220] A_WL[221] A_WL[222] A_WL[223]
+ A_WL[224] A_WL[225] A_WL[226] A_WL[227] A_WL[228] A_WL[229] A_WL[230]
+ A_WL[231] A_WL[232] A_WL[233] A_WL[234] A_WL[235] A_WL[236] A_WL[237]
+ A_WL[238] A_WL[239] A_WL[240] A_WL[241] A_WL[242] A_WL[243] A_WL[244]
+ A_WL[245] A_WL[246] A_WL[247] A_WL[248] A_WL[249] A_WL[250] A_WL[251]
+ A_WL[252] A_WL[253] A_WL[254] A_WL[255] B_WL[0] B_WL[1] B_WL[2] B_WL[3]
+ B_WL[4] B_WL[5] B_WL[6] B_WL[7] B_WL[8] B_WL[9] B_WL[10] B_WL[11] B_WL[12]
+ B_WL[13] B_WL[14] B_WL[15] B_WL[16] B_WL[17] B_WL[18] B_WL[19] B_WL[20]
+ B_WL[21] B_WL[22] B_WL[23] B_WL[24] B_WL[25] B_WL[26] B_WL[27] B_WL[28]
+ B_WL[29] B_WL[30] B_WL[31] B_WL[32] B_WL[33] B_WL[34] B_WL[35] B_WL[36]
+ B_WL[37] B_WL[38] B_WL[39] B_WL[40] B_WL[41] B_WL[42] B_WL[43] B_WL[44]
+ B_WL[45] B_WL[46] B_WL[47] B_WL[48] B_WL[49] B_WL[50] B_WL[51] B_WL[52]
+ B_WL[53] B_WL[54] B_WL[55] B_WL[56] B_WL[57] B_WL[58] B_WL[59] B_WL[60]
+ B_WL[61] B_WL[62] B_WL[63] B_WL[64] B_WL[65] B_WL[66] B_WL[67] B_WL[68]
+ B_WL[69] B_WL[70] B_WL[71] B_WL[72] B_WL[73] B_WL[74] B_WL[75] B_WL[76]
+ B_WL[77] B_WL[78] B_WL[79] B_WL[80] B_WL[81] B_WL[82] B_WL[83] B_WL[84]
+ B_WL[85] B_WL[86] B_WL[87] B_WL[88] B_WL[89] B_WL[90] B_WL[91] B_WL[92]
+ B_WL[93] B_WL[94] B_WL[95] B_WL[96] B_WL[97] B_WL[98] B_WL[99] B_WL[100]
+ B_WL[101] B_WL[102] B_WL[103] B_WL[104] B_WL[105] B_WL[106] B_WL[107]
+ B_WL[108] B_WL[109] B_WL[110] B_WL[111] B_WL[112] B_WL[113] B_WL[114]
+ B_WL[115] B_WL[116] B_WL[117] B_WL[118] B_WL[119] B_WL[120] B_WL[121]
+ B_WL[122] B_WL[123] B_WL[124] B_WL[125] B_WL[126] B_WL[127] B_WL[128]
+ B_WL[129] B_WL[130] B_WL[131] B_WL[132] B_WL[133] B_WL[134] B_WL[135]
+ B_WL[136] B_WL[137] B_WL[138] B_WL[139] B_WL[140] B_WL[141] B_WL[142]
+ B_WL[143] B_WL[144] B_WL[145] B_WL[146] B_WL[147] B_WL[148] B_WL[149]
+ B_WL[150] B_WL[151] B_WL[152] B_WL[153] B_WL[154] B_WL[155] B_WL[156]
+ B_WL[157] B_WL[158] B_WL[159] B_WL[160] B_WL[161] B_WL[162] B_WL[163]
+ B_WL[164] B_WL[165] B_WL[166] B_WL[167] B_WL[168] B_WL[169] B_WL[170]
+ B_WL[171] B_WL[172] B_WL[173] B_WL[174] B_WL[175] B_WL[176] B_WL[177]
+ B_WL[178] B_WL[179] B_WL[180] B_WL[181] B_WL[182] B_WL[183] B_WL[184]
+ B_WL[185] B_WL[186] B_WL[187] B_WL[188] B_WL[189] B_WL[190] B_WL[191]
+ B_WL[192] B_WL[193] B_WL[194] B_WL[195] B_WL[196] B_WL[197] B_WL[198]
+ B_WL[199] B_WL[200] B_WL[201] B_WL[202] B_WL[203] B_WL[204] B_WL[205]
+ B_WL[206] B_WL[207] B_WL[208] B_WL[209] B_WL[210] B_WL[211] B_WL[212]
+ B_WL[213] B_WL[214] B_WL[215] B_WL[216] B_WL[217] B_WL[218] B_WL[219]
+ B_WL[220] B_WL[221] B_WL[222] B_WL[223] B_WL[224] B_WL[225] B_WL[226]
+ B_WL[227] B_WL[228] B_WL[229] B_WL[230] B_WL[231] B_WL[232] B_WL[233]
+ B_WL[234] B_WL[235] B_WL[236] B_WL[237] B_WL[238] B_WL[239] B_WL[240]
+ B_WL[241] B_WL[242] B_WL[243] B_WL[244] B_WL[245] B_WL[246] B_WL[247]
+ B_WL[248] B_WL[249] B_WL[250] B_WL[251] B_WL[252] B_WL[253] B_WL[254]
+ B_WL[255] A_RDL[0] A_SMPRS_0[3] A_SMPRS_0[2] A_SMPRS_0[1] A_SMPRS_0[0]
+ A_SOE[0] A_WRTL[0] A_YSEL_0[7] A_YSEL_0[6] A_YSEL_0[5] A_YSEL_0[4]
+ A_YSEL_0[3] A_YSEL_0[2] A_YSEL_0[1] A_YSEL_0[0] B_RDL[0] B_SMPRS_0[3]
+ B_SMPRS_0[2] B_SMPRS_0[1] B_SMPRS_0[0] B_SOE[0] B_WRTL[0] B_YSEL_0[7]
+ B_YSEL_0[6] B_YSEL_0[5] B_YSEL_0[4] B_YSEL_0[3] B_YSEL_0[2] B_YSEL_0[1]
+ B_YSEL_0[0] AWTI BWEBA[23] BWEBMA[23] A_CKD DA[23] A_DLRS DMA[23] A_WENB[3]
+ A_WENB[2] A_WENB[1] A_WENB[0] BISTC BISTT BWEBB[23] BWEBMB[23] B_CKD DB[23]
+ B_DLRS DMB[23] B_WENB[3] B_WENB[2] B_WENB[1] B_WENB[0] QA[23] QB[23]
+  SDL400W20S_NBITSLC
XBIT24 A_WL[0] A_WL[1] A_WL[2] A_WL[3] A_WL[4] A_WL[5] A_WL[6] A_WL[7] A_WL[8]
+ A_WL[9] A_WL[10] A_WL[11] A_WL[12] A_WL[13] A_WL[14] A_WL[15] A_WL[16]
+ A_WL[17] A_WL[18] A_WL[19] A_WL[20] A_WL[21] A_WL[22] A_WL[23] A_WL[24]
+ A_WL[25] A_WL[26] A_WL[27] A_WL[28] A_WL[29] A_WL[30] A_WL[31] A_WL[32]
+ A_WL[33] A_WL[34] A_WL[35] A_WL[36] A_WL[37] A_WL[38] A_WL[39] A_WL[40]
+ A_WL[41] A_WL[42] A_WL[43] A_WL[44] A_WL[45] A_WL[46] A_WL[47] A_WL[48]
+ A_WL[49] A_WL[50] A_WL[51] A_WL[52] A_WL[53] A_WL[54] A_WL[55] A_WL[56]
+ A_WL[57] A_WL[58] A_WL[59] A_WL[60] A_WL[61] A_WL[62] A_WL[63] A_WL[64]
+ A_WL[65] A_WL[66] A_WL[67] A_WL[68] A_WL[69] A_WL[70] A_WL[71] A_WL[72]
+ A_WL[73] A_WL[74] A_WL[75] A_WL[76] A_WL[77] A_WL[78] A_WL[79] A_WL[80]
+ A_WL[81] A_WL[82] A_WL[83] A_WL[84] A_WL[85] A_WL[86] A_WL[87] A_WL[88]
+ A_WL[89] A_WL[90] A_WL[91] A_WL[92] A_WL[93] A_WL[94] A_WL[95] A_WL[96]
+ A_WL[97] A_WL[98] A_WL[99] A_WL[100] A_WL[101] A_WL[102] A_WL[103] A_WL[104]
+ A_WL[105] A_WL[106] A_WL[107] A_WL[108] A_WL[109] A_WL[110] A_WL[111]
+ A_WL[112] A_WL[113] A_WL[114] A_WL[115] A_WL[116] A_WL[117] A_WL[118]
+ A_WL[119] A_WL[120] A_WL[121] A_WL[122] A_WL[123] A_WL[124] A_WL[125]
+ A_WL[126] A_WL[127] A_WL[128] A_WL[129] A_WL[130] A_WL[131] A_WL[132]
+ A_WL[133] A_WL[134] A_WL[135] A_WL[136] A_WL[137] A_WL[138] A_WL[139]
+ A_WL[140] A_WL[141] A_WL[142] A_WL[143] A_WL[144] A_WL[145] A_WL[146]
+ A_WL[147] A_WL[148] A_WL[149] A_WL[150] A_WL[151] A_WL[152] A_WL[153]
+ A_WL[154] A_WL[155] A_WL[156] A_WL[157] A_WL[158] A_WL[159] A_WL[160]
+ A_WL[161] A_WL[162] A_WL[163] A_WL[164] A_WL[165] A_WL[166] A_WL[167]
+ A_WL[168] A_WL[169] A_WL[170] A_WL[171] A_WL[172] A_WL[173] A_WL[174]
+ A_WL[175] A_WL[176] A_WL[177] A_WL[178] A_WL[179] A_WL[180] A_WL[181]
+ A_WL[182] A_WL[183] A_WL[184] A_WL[185] A_WL[186] A_WL[187] A_WL[188]
+ A_WL[189] A_WL[190] A_WL[191] A_WL[192] A_WL[193] A_WL[194] A_WL[195]
+ A_WL[196] A_WL[197] A_WL[198] A_WL[199] A_WL[200] A_WL[201] A_WL[202]
+ A_WL[203] A_WL[204] A_WL[205] A_WL[206] A_WL[207] A_WL[208] A_WL[209]
+ A_WL[210] A_WL[211] A_WL[212] A_WL[213] A_WL[214] A_WL[215] A_WL[216]
+ A_WL[217] A_WL[218] A_WL[219] A_WL[220] A_WL[221] A_WL[222] A_WL[223]
+ A_WL[224] A_WL[225] A_WL[226] A_WL[227] A_WL[228] A_WL[229] A_WL[230]
+ A_WL[231] A_WL[232] A_WL[233] A_WL[234] A_WL[235] A_WL[236] A_WL[237]
+ A_WL[238] A_WL[239] A_WL[240] A_WL[241] A_WL[242] A_WL[243] A_WL[244]
+ A_WL[245] A_WL[246] A_WL[247] A_WL[248] A_WL[249] A_WL[250] A_WL[251]
+ A_WL[252] A_WL[253] A_WL[254] A_WL[255] B_WL[0] B_WL[1] B_WL[2] B_WL[3]
+ B_WL[4] B_WL[5] B_WL[6] B_WL[7] B_WL[8] B_WL[9] B_WL[10] B_WL[11] B_WL[12]
+ B_WL[13] B_WL[14] B_WL[15] B_WL[16] B_WL[17] B_WL[18] B_WL[19] B_WL[20]
+ B_WL[21] B_WL[22] B_WL[23] B_WL[24] B_WL[25] B_WL[26] B_WL[27] B_WL[28]
+ B_WL[29] B_WL[30] B_WL[31] B_WL[32] B_WL[33] B_WL[34] B_WL[35] B_WL[36]
+ B_WL[37] B_WL[38] B_WL[39] B_WL[40] B_WL[41] B_WL[42] B_WL[43] B_WL[44]
+ B_WL[45] B_WL[46] B_WL[47] B_WL[48] B_WL[49] B_WL[50] B_WL[51] B_WL[52]
+ B_WL[53] B_WL[54] B_WL[55] B_WL[56] B_WL[57] B_WL[58] B_WL[59] B_WL[60]
+ B_WL[61] B_WL[62] B_WL[63] B_WL[64] B_WL[65] B_WL[66] B_WL[67] B_WL[68]
+ B_WL[69] B_WL[70] B_WL[71] B_WL[72] B_WL[73] B_WL[74] B_WL[75] B_WL[76]
+ B_WL[77] B_WL[78] B_WL[79] B_WL[80] B_WL[81] B_WL[82] B_WL[83] B_WL[84]
+ B_WL[85] B_WL[86] B_WL[87] B_WL[88] B_WL[89] B_WL[90] B_WL[91] B_WL[92]
+ B_WL[93] B_WL[94] B_WL[95] B_WL[96] B_WL[97] B_WL[98] B_WL[99] B_WL[100]
+ B_WL[101] B_WL[102] B_WL[103] B_WL[104] B_WL[105] B_WL[106] B_WL[107]
+ B_WL[108] B_WL[109] B_WL[110] B_WL[111] B_WL[112] B_WL[113] B_WL[114]
+ B_WL[115] B_WL[116] B_WL[117] B_WL[118] B_WL[119] B_WL[120] B_WL[121]
+ B_WL[122] B_WL[123] B_WL[124] B_WL[125] B_WL[126] B_WL[127] B_WL[128]
+ B_WL[129] B_WL[130] B_WL[131] B_WL[132] B_WL[133] B_WL[134] B_WL[135]
+ B_WL[136] B_WL[137] B_WL[138] B_WL[139] B_WL[140] B_WL[141] B_WL[142]
+ B_WL[143] B_WL[144] B_WL[145] B_WL[146] B_WL[147] B_WL[148] B_WL[149]
+ B_WL[150] B_WL[151] B_WL[152] B_WL[153] B_WL[154] B_WL[155] B_WL[156]
+ B_WL[157] B_WL[158] B_WL[159] B_WL[160] B_WL[161] B_WL[162] B_WL[163]
+ B_WL[164] B_WL[165] B_WL[166] B_WL[167] B_WL[168] B_WL[169] B_WL[170]
+ B_WL[171] B_WL[172] B_WL[173] B_WL[174] B_WL[175] B_WL[176] B_WL[177]
+ B_WL[178] B_WL[179] B_WL[180] B_WL[181] B_WL[182] B_WL[183] B_WL[184]
+ B_WL[185] B_WL[186] B_WL[187] B_WL[188] B_WL[189] B_WL[190] B_WL[191]
+ B_WL[192] B_WL[193] B_WL[194] B_WL[195] B_WL[196] B_WL[197] B_WL[198]
+ B_WL[199] B_WL[200] B_WL[201] B_WL[202] B_WL[203] B_WL[204] B_WL[205]
+ B_WL[206] B_WL[207] B_WL[208] B_WL[209] B_WL[210] B_WL[211] B_WL[212]
+ B_WL[213] B_WL[214] B_WL[215] B_WL[216] B_WL[217] B_WL[218] B_WL[219]
+ B_WL[220] B_WL[221] B_WL[222] B_WL[223] B_WL[224] B_WL[225] B_WL[226]
+ B_WL[227] B_WL[228] B_WL[229] B_WL[230] B_WL[231] B_WL[232] B_WL[233]
+ B_WL[234] B_WL[235] B_WL[236] B_WL[237] B_WL[238] B_WL[239] B_WL[240]
+ B_WL[241] B_WL[242] B_WL[243] B_WL[244] B_WL[245] B_WL[246] B_WL[247]
+ B_WL[248] B_WL[249] B_WL[250] B_WL[251] B_WL[252] B_WL[253] B_WL[254]
+ B_WL[255] A_RDL[0] A_SMPRS_0[3] A_SMPRS_0[2] A_SMPRS_0[1] A_SMPRS_0[0]
+ A_SOE[0] A_WRTL[0] A_YSEL_0[7] A_YSEL_0[6] A_YSEL_0[5] A_YSEL_0[4]
+ A_YSEL_0[3] A_YSEL_0[2] A_YSEL_0[1] A_YSEL_0[0] B_RDL[0] B_SMPRS_0[3]
+ B_SMPRS_0[2] B_SMPRS_0[1] B_SMPRS_0[0] B_SOE[0] B_WRTL[0] B_YSEL_0[7]
+ B_YSEL_0[6] B_YSEL_0[5] B_YSEL_0[4] B_YSEL_0[3] B_YSEL_0[2] B_YSEL_0[1]
+ B_YSEL_0[0] AWTI BWEBA[24] BWEBMA[24] A_CKD DA[24] A_DLRS DMA[24] A_WENB[3]
+ A_WENB[2] A_WENB[1] A_WENB[0] BISTC BISTT BWEBB[24] BWEBMB[24] B_CKD DB[24]
+ B_DLRS DMB[24] B_WENB[3] B_WENB[2] B_WENB[1] B_WENB[0] QA[24] QB[24]
+  SDL400W20S_NBITSLC
XBIT25 A_WL[0] A_WL[1] A_WL[2] A_WL[3] A_WL[4] A_WL[5] A_WL[6] A_WL[7] A_WL[8]
+ A_WL[9] A_WL[10] A_WL[11] A_WL[12] A_WL[13] A_WL[14] A_WL[15] A_WL[16]
+ A_WL[17] A_WL[18] A_WL[19] A_WL[20] A_WL[21] A_WL[22] A_WL[23] A_WL[24]
+ A_WL[25] A_WL[26] A_WL[27] A_WL[28] A_WL[29] A_WL[30] A_WL[31] A_WL[32]
+ A_WL[33] A_WL[34] A_WL[35] A_WL[36] A_WL[37] A_WL[38] A_WL[39] A_WL[40]
+ A_WL[41] A_WL[42] A_WL[43] A_WL[44] A_WL[45] A_WL[46] A_WL[47] A_WL[48]
+ A_WL[49] A_WL[50] A_WL[51] A_WL[52] A_WL[53] A_WL[54] A_WL[55] A_WL[56]
+ A_WL[57] A_WL[58] A_WL[59] A_WL[60] A_WL[61] A_WL[62] A_WL[63] A_WL[64]
+ A_WL[65] A_WL[66] A_WL[67] A_WL[68] A_WL[69] A_WL[70] A_WL[71] A_WL[72]
+ A_WL[73] A_WL[74] A_WL[75] A_WL[76] A_WL[77] A_WL[78] A_WL[79] A_WL[80]
+ A_WL[81] A_WL[82] A_WL[83] A_WL[84] A_WL[85] A_WL[86] A_WL[87] A_WL[88]
+ A_WL[89] A_WL[90] A_WL[91] A_WL[92] A_WL[93] A_WL[94] A_WL[95] A_WL[96]
+ A_WL[97] A_WL[98] A_WL[99] A_WL[100] A_WL[101] A_WL[102] A_WL[103] A_WL[104]
+ A_WL[105] A_WL[106] A_WL[107] A_WL[108] A_WL[109] A_WL[110] A_WL[111]
+ A_WL[112] A_WL[113] A_WL[114] A_WL[115] A_WL[116] A_WL[117] A_WL[118]
+ A_WL[119] A_WL[120] A_WL[121] A_WL[122] A_WL[123] A_WL[124] A_WL[125]
+ A_WL[126] A_WL[127] A_WL[128] A_WL[129] A_WL[130] A_WL[131] A_WL[132]
+ A_WL[133] A_WL[134] A_WL[135] A_WL[136] A_WL[137] A_WL[138] A_WL[139]
+ A_WL[140] A_WL[141] A_WL[142] A_WL[143] A_WL[144] A_WL[145] A_WL[146]
+ A_WL[147] A_WL[148] A_WL[149] A_WL[150] A_WL[151] A_WL[152] A_WL[153]
+ A_WL[154] A_WL[155] A_WL[156] A_WL[157] A_WL[158] A_WL[159] A_WL[160]
+ A_WL[161] A_WL[162] A_WL[163] A_WL[164] A_WL[165] A_WL[166] A_WL[167]
+ A_WL[168] A_WL[169] A_WL[170] A_WL[171] A_WL[172] A_WL[173] A_WL[174]
+ A_WL[175] A_WL[176] A_WL[177] A_WL[178] A_WL[179] A_WL[180] A_WL[181]
+ A_WL[182] A_WL[183] A_WL[184] A_WL[185] A_WL[186] A_WL[187] A_WL[188]
+ A_WL[189] A_WL[190] A_WL[191] A_WL[192] A_WL[193] A_WL[194] A_WL[195]
+ A_WL[196] A_WL[197] A_WL[198] A_WL[199] A_WL[200] A_WL[201] A_WL[202]
+ A_WL[203] A_WL[204] A_WL[205] A_WL[206] A_WL[207] A_WL[208] A_WL[209]
+ A_WL[210] A_WL[211] A_WL[212] A_WL[213] A_WL[214] A_WL[215] A_WL[216]
+ A_WL[217] A_WL[218] A_WL[219] A_WL[220] A_WL[221] A_WL[222] A_WL[223]
+ A_WL[224] A_WL[225] A_WL[226] A_WL[227] A_WL[228] A_WL[229] A_WL[230]
+ A_WL[231] A_WL[232] A_WL[233] A_WL[234] A_WL[235] A_WL[236] A_WL[237]
+ A_WL[238] A_WL[239] A_WL[240] A_WL[241] A_WL[242] A_WL[243] A_WL[244]
+ A_WL[245] A_WL[246] A_WL[247] A_WL[248] A_WL[249] A_WL[250] A_WL[251]
+ A_WL[252] A_WL[253] A_WL[254] A_WL[255] B_WL[0] B_WL[1] B_WL[2] B_WL[3]
+ B_WL[4] B_WL[5] B_WL[6] B_WL[7] B_WL[8] B_WL[9] B_WL[10] B_WL[11] B_WL[12]
+ B_WL[13] B_WL[14] B_WL[15] B_WL[16] B_WL[17] B_WL[18] B_WL[19] B_WL[20]
+ B_WL[21] B_WL[22] B_WL[23] B_WL[24] B_WL[25] B_WL[26] B_WL[27] B_WL[28]
+ B_WL[29] B_WL[30] B_WL[31] B_WL[32] B_WL[33] B_WL[34] B_WL[35] B_WL[36]
+ B_WL[37] B_WL[38] B_WL[39] B_WL[40] B_WL[41] B_WL[42] B_WL[43] B_WL[44]
+ B_WL[45] B_WL[46] B_WL[47] B_WL[48] B_WL[49] B_WL[50] B_WL[51] B_WL[52]
+ B_WL[53] B_WL[54] B_WL[55] B_WL[56] B_WL[57] B_WL[58] B_WL[59] B_WL[60]
+ B_WL[61] B_WL[62] B_WL[63] B_WL[64] B_WL[65] B_WL[66] B_WL[67] B_WL[68]
+ B_WL[69] B_WL[70] B_WL[71] B_WL[72] B_WL[73] B_WL[74] B_WL[75] B_WL[76]
+ B_WL[77] B_WL[78] B_WL[79] B_WL[80] B_WL[81] B_WL[82] B_WL[83] B_WL[84]
+ B_WL[85] B_WL[86] B_WL[87] B_WL[88] B_WL[89] B_WL[90] B_WL[91] B_WL[92]
+ B_WL[93] B_WL[94] B_WL[95] B_WL[96] B_WL[97] B_WL[98] B_WL[99] B_WL[100]
+ B_WL[101] B_WL[102] B_WL[103] B_WL[104] B_WL[105] B_WL[106] B_WL[107]
+ B_WL[108] B_WL[109] B_WL[110] B_WL[111] B_WL[112] B_WL[113] B_WL[114]
+ B_WL[115] B_WL[116] B_WL[117] B_WL[118] B_WL[119] B_WL[120] B_WL[121]
+ B_WL[122] B_WL[123] B_WL[124] B_WL[125] B_WL[126] B_WL[127] B_WL[128]
+ B_WL[129] B_WL[130] B_WL[131] B_WL[132] B_WL[133] B_WL[134] B_WL[135]
+ B_WL[136] B_WL[137] B_WL[138] B_WL[139] B_WL[140] B_WL[141] B_WL[142]
+ B_WL[143] B_WL[144] B_WL[145] B_WL[146] B_WL[147] B_WL[148] B_WL[149]
+ B_WL[150] B_WL[151] B_WL[152] B_WL[153] B_WL[154] B_WL[155] B_WL[156]
+ B_WL[157] B_WL[158] B_WL[159] B_WL[160] B_WL[161] B_WL[162] B_WL[163]
+ B_WL[164] B_WL[165] B_WL[166] B_WL[167] B_WL[168] B_WL[169] B_WL[170]
+ B_WL[171] B_WL[172] B_WL[173] B_WL[174] B_WL[175] B_WL[176] B_WL[177]
+ B_WL[178] B_WL[179] B_WL[180] B_WL[181] B_WL[182] B_WL[183] B_WL[184]
+ B_WL[185] B_WL[186] B_WL[187] B_WL[188] B_WL[189] B_WL[190] B_WL[191]
+ B_WL[192] B_WL[193] B_WL[194] B_WL[195] B_WL[196] B_WL[197] B_WL[198]
+ B_WL[199] B_WL[200] B_WL[201] B_WL[202] B_WL[203] B_WL[204] B_WL[205]
+ B_WL[206] B_WL[207] B_WL[208] B_WL[209] B_WL[210] B_WL[211] B_WL[212]
+ B_WL[213] B_WL[214] B_WL[215] B_WL[216] B_WL[217] B_WL[218] B_WL[219]
+ B_WL[220] B_WL[221] B_WL[222] B_WL[223] B_WL[224] B_WL[225] B_WL[226]
+ B_WL[227] B_WL[228] B_WL[229] B_WL[230] B_WL[231] B_WL[232] B_WL[233]
+ B_WL[234] B_WL[235] B_WL[236] B_WL[237] B_WL[238] B_WL[239] B_WL[240]
+ B_WL[241] B_WL[242] B_WL[243] B_WL[244] B_WL[245] B_WL[246] B_WL[247]
+ B_WL[248] B_WL[249] B_WL[250] B_WL[251] B_WL[252] B_WL[253] B_WL[254]
+ B_WL[255] A_RDL[0] A_SMPRS_0[3] A_SMPRS_0[2] A_SMPRS_0[1] A_SMPRS_0[0]
+ A_SOE[0] A_WRTL[0] A_YSEL_0[7] A_YSEL_0[6] A_YSEL_0[5] A_YSEL_0[4]
+ A_YSEL_0[3] A_YSEL_0[2] A_YSEL_0[1] A_YSEL_0[0] B_RDL[0] B_SMPRS_0[3]
+ B_SMPRS_0[2] B_SMPRS_0[1] B_SMPRS_0[0] B_SOE[0] B_WRTL[0] B_YSEL_0[7]
+ B_YSEL_0[6] B_YSEL_0[5] B_YSEL_0[4] B_YSEL_0[3] B_YSEL_0[2] B_YSEL_0[1]
+ B_YSEL_0[0] AWTI BWEBA[25] BWEBMA[25] A_CKD DA[25] A_DLRS DMA[25] A_WENB[3]
+ A_WENB[2] A_WENB[1] A_WENB[0] BISTC BISTT BWEBB[25] BWEBMB[25] B_CKD DB[25]
+ B_DLRS DMB[25] B_WENB[3] B_WENB[2] B_WENB[1] B_WENB[0] QA[25] QB[25]
+  SDL400W20S_NBITSLC
XBIT26 A_WL[0] A_WL[1] A_WL[2] A_WL[3] A_WL[4] A_WL[5] A_WL[6] A_WL[7] A_WL[8]
+ A_WL[9] A_WL[10] A_WL[11] A_WL[12] A_WL[13] A_WL[14] A_WL[15] A_WL[16]
+ A_WL[17] A_WL[18] A_WL[19] A_WL[20] A_WL[21] A_WL[22] A_WL[23] A_WL[24]
+ A_WL[25] A_WL[26] A_WL[27] A_WL[28] A_WL[29] A_WL[30] A_WL[31] A_WL[32]
+ A_WL[33] A_WL[34] A_WL[35] A_WL[36] A_WL[37] A_WL[38] A_WL[39] A_WL[40]
+ A_WL[41] A_WL[42] A_WL[43] A_WL[44] A_WL[45] A_WL[46] A_WL[47] A_WL[48]
+ A_WL[49] A_WL[50] A_WL[51] A_WL[52] A_WL[53] A_WL[54] A_WL[55] A_WL[56]
+ A_WL[57] A_WL[58] A_WL[59] A_WL[60] A_WL[61] A_WL[62] A_WL[63] A_WL[64]
+ A_WL[65] A_WL[66] A_WL[67] A_WL[68] A_WL[69] A_WL[70] A_WL[71] A_WL[72]
+ A_WL[73] A_WL[74] A_WL[75] A_WL[76] A_WL[77] A_WL[78] A_WL[79] A_WL[80]
+ A_WL[81] A_WL[82] A_WL[83] A_WL[84] A_WL[85] A_WL[86] A_WL[87] A_WL[88]
+ A_WL[89] A_WL[90] A_WL[91] A_WL[92] A_WL[93] A_WL[94] A_WL[95] A_WL[96]
+ A_WL[97] A_WL[98] A_WL[99] A_WL[100] A_WL[101] A_WL[102] A_WL[103] A_WL[104]
+ A_WL[105] A_WL[106] A_WL[107] A_WL[108] A_WL[109] A_WL[110] A_WL[111]
+ A_WL[112] A_WL[113] A_WL[114] A_WL[115] A_WL[116] A_WL[117] A_WL[118]
+ A_WL[119] A_WL[120] A_WL[121] A_WL[122] A_WL[123] A_WL[124] A_WL[125]
+ A_WL[126] A_WL[127] A_WL[128] A_WL[129] A_WL[130] A_WL[131] A_WL[132]
+ A_WL[133] A_WL[134] A_WL[135] A_WL[136] A_WL[137] A_WL[138] A_WL[139]
+ A_WL[140] A_WL[141] A_WL[142] A_WL[143] A_WL[144] A_WL[145] A_WL[146]
+ A_WL[147] A_WL[148] A_WL[149] A_WL[150] A_WL[151] A_WL[152] A_WL[153]
+ A_WL[154] A_WL[155] A_WL[156] A_WL[157] A_WL[158] A_WL[159] A_WL[160]
+ A_WL[161] A_WL[162] A_WL[163] A_WL[164] A_WL[165] A_WL[166] A_WL[167]
+ A_WL[168] A_WL[169] A_WL[170] A_WL[171] A_WL[172] A_WL[173] A_WL[174]
+ A_WL[175] A_WL[176] A_WL[177] A_WL[178] A_WL[179] A_WL[180] A_WL[181]
+ A_WL[182] A_WL[183] A_WL[184] A_WL[185] A_WL[186] A_WL[187] A_WL[188]
+ A_WL[189] A_WL[190] A_WL[191] A_WL[192] A_WL[193] A_WL[194] A_WL[195]
+ A_WL[196] A_WL[197] A_WL[198] A_WL[199] A_WL[200] A_WL[201] A_WL[202]
+ A_WL[203] A_WL[204] A_WL[205] A_WL[206] A_WL[207] A_WL[208] A_WL[209]
+ A_WL[210] A_WL[211] A_WL[212] A_WL[213] A_WL[214] A_WL[215] A_WL[216]
+ A_WL[217] A_WL[218] A_WL[219] A_WL[220] A_WL[221] A_WL[222] A_WL[223]
+ A_WL[224] A_WL[225] A_WL[226] A_WL[227] A_WL[228] A_WL[229] A_WL[230]
+ A_WL[231] A_WL[232] A_WL[233] A_WL[234] A_WL[235] A_WL[236] A_WL[237]
+ A_WL[238] A_WL[239] A_WL[240] A_WL[241] A_WL[242] A_WL[243] A_WL[244]
+ A_WL[245] A_WL[246] A_WL[247] A_WL[248] A_WL[249] A_WL[250] A_WL[251]
+ A_WL[252] A_WL[253] A_WL[254] A_WL[255] B_WL[0] B_WL[1] B_WL[2] B_WL[3]
+ B_WL[4] B_WL[5] B_WL[6] B_WL[7] B_WL[8] B_WL[9] B_WL[10] B_WL[11] B_WL[12]
+ B_WL[13] B_WL[14] B_WL[15] B_WL[16] B_WL[17] B_WL[18] B_WL[19] B_WL[20]
+ B_WL[21] B_WL[22] B_WL[23] B_WL[24] B_WL[25] B_WL[26] B_WL[27] B_WL[28]
+ B_WL[29] B_WL[30] B_WL[31] B_WL[32] B_WL[33] B_WL[34] B_WL[35] B_WL[36]
+ B_WL[37] B_WL[38] B_WL[39] B_WL[40] B_WL[41] B_WL[42] B_WL[43] B_WL[44]
+ B_WL[45] B_WL[46] B_WL[47] B_WL[48] B_WL[49] B_WL[50] B_WL[51] B_WL[52]
+ B_WL[53] B_WL[54] B_WL[55] B_WL[56] B_WL[57] B_WL[58] B_WL[59] B_WL[60]
+ B_WL[61] B_WL[62] B_WL[63] B_WL[64] B_WL[65] B_WL[66] B_WL[67] B_WL[68]
+ B_WL[69] B_WL[70] B_WL[71] B_WL[72] B_WL[73] B_WL[74] B_WL[75] B_WL[76]
+ B_WL[77] B_WL[78] B_WL[79] B_WL[80] B_WL[81] B_WL[82] B_WL[83] B_WL[84]
+ B_WL[85] B_WL[86] B_WL[87] B_WL[88] B_WL[89] B_WL[90] B_WL[91] B_WL[92]
+ B_WL[93] B_WL[94] B_WL[95] B_WL[96] B_WL[97] B_WL[98] B_WL[99] B_WL[100]
+ B_WL[101] B_WL[102] B_WL[103] B_WL[104] B_WL[105] B_WL[106] B_WL[107]
+ B_WL[108] B_WL[109] B_WL[110] B_WL[111] B_WL[112] B_WL[113] B_WL[114]
+ B_WL[115] B_WL[116] B_WL[117] B_WL[118] B_WL[119] B_WL[120] B_WL[121]
+ B_WL[122] B_WL[123] B_WL[124] B_WL[125] B_WL[126] B_WL[127] B_WL[128]
+ B_WL[129] B_WL[130] B_WL[131] B_WL[132] B_WL[133] B_WL[134] B_WL[135]
+ B_WL[136] B_WL[137] B_WL[138] B_WL[139] B_WL[140] B_WL[141] B_WL[142]
+ B_WL[143] B_WL[144] B_WL[145] B_WL[146] B_WL[147] B_WL[148] B_WL[149]
+ B_WL[150] B_WL[151] B_WL[152] B_WL[153] B_WL[154] B_WL[155] B_WL[156]
+ B_WL[157] B_WL[158] B_WL[159] B_WL[160] B_WL[161] B_WL[162] B_WL[163]
+ B_WL[164] B_WL[165] B_WL[166] B_WL[167] B_WL[168] B_WL[169] B_WL[170]
+ B_WL[171] B_WL[172] B_WL[173] B_WL[174] B_WL[175] B_WL[176] B_WL[177]
+ B_WL[178] B_WL[179] B_WL[180] B_WL[181] B_WL[182] B_WL[183] B_WL[184]
+ B_WL[185] B_WL[186] B_WL[187] B_WL[188] B_WL[189] B_WL[190] B_WL[191]
+ B_WL[192] B_WL[193] B_WL[194] B_WL[195] B_WL[196] B_WL[197] B_WL[198]
+ B_WL[199] B_WL[200] B_WL[201] B_WL[202] B_WL[203] B_WL[204] B_WL[205]
+ B_WL[206] B_WL[207] B_WL[208] B_WL[209] B_WL[210] B_WL[211] B_WL[212]
+ B_WL[213] B_WL[214] B_WL[215] B_WL[216] B_WL[217] B_WL[218] B_WL[219]
+ B_WL[220] B_WL[221] B_WL[222] B_WL[223] B_WL[224] B_WL[225] B_WL[226]
+ B_WL[227] B_WL[228] B_WL[229] B_WL[230] B_WL[231] B_WL[232] B_WL[233]
+ B_WL[234] B_WL[235] B_WL[236] B_WL[237] B_WL[238] B_WL[239] B_WL[240]
+ B_WL[241] B_WL[242] B_WL[243] B_WL[244] B_WL[245] B_WL[246] B_WL[247]
+ B_WL[248] B_WL[249] B_WL[250] B_WL[251] B_WL[252] B_WL[253] B_WL[254]
+ B_WL[255] A_RDL[0] A_SMPRS_0[3] A_SMPRS_0[2] A_SMPRS_0[1] A_SMPRS_0[0]
+ A_SOE[0] A_WRTL[0] A_YSEL_0[7] A_YSEL_0[6] A_YSEL_0[5] A_YSEL_0[4]
+ A_YSEL_0[3] A_YSEL_0[2] A_YSEL_0[1] A_YSEL_0[0] B_RDL[0] B_SMPRS_0[3]
+ B_SMPRS_0[2] B_SMPRS_0[1] B_SMPRS_0[0] B_SOE[0] B_WRTL[0] B_YSEL_0[7]
+ B_YSEL_0[6] B_YSEL_0[5] B_YSEL_0[4] B_YSEL_0[3] B_YSEL_0[2] B_YSEL_0[1]
+ B_YSEL_0[0] AWTI BWEBA[26] BWEBMA[26] A_CKD DA[26] A_DLRS DMA[26] A_WENB[3]
+ A_WENB[2] A_WENB[1] A_WENB[0] BISTC BISTT BWEBB[26] BWEBMB[26] B_CKD DB[26]
+ B_DLRS DMB[26] B_WENB[3] B_WENB[2] B_WENB[1] B_WENB[0] QA[26] QB[26]
+  SDL400W20S_NBITSLC
XBIT27 A_WL[0] A_WL[1] A_WL[2] A_WL[3] A_WL[4] A_WL[5] A_WL[6] A_WL[7] A_WL[8]
+ A_WL[9] A_WL[10] A_WL[11] A_WL[12] A_WL[13] A_WL[14] A_WL[15] A_WL[16]
+ A_WL[17] A_WL[18] A_WL[19] A_WL[20] A_WL[21] A_WL[22] A_WL[23] A_WL[24]
+ A_WL[25] A_WL[26] A_WL[27] A_WL[28] A_WL[29] A_WL[30] A_WL[31] A_WL[32]
+ A_WL[33] A_WL[34] A_WL[35] A_WL[36] A_WL[37] A_WL[38] A_WL[39] A_WL[40]
+ A_WL[41] A_WL[42] A_WL[43] A_WL[44] A_WL[45] A_WL[46] A_WL[47] A_WL[48]
+ A_WL[49] A_WL[50] A_WL[51] A_WL[52] A_WL[53] A_WL[54] A_WL[55] A_WL[56]
+ A_WL[57] A_WL[58] A_WL[59] A_WL[60] A_WL[61] A_WL[62] A_WL[63] A_WL[64]
+ A_WL[65] A_WL[66] A_WL[67] A_WL[68] A_WL[69] A_WL[70] A_WL[71] A_WL[72]
+ A_WL[73] A_WL[74] A_WL[75] A_WL[76] A_WL[77] A_WL[78] A_WL[79] A_WL[80]
+ A_WL[81] A_WL[82] A_WL[83] A_WL[84] A_WL[85] A_WL[86] A_WL[87] A_WL[88]
+ A_WL[89] A_WL[90] A_WL[91] A_WL[92] A_WL[93] A_WL[94] A_WL[95] A_WL[96]
+ A_WL[97] A_WL[98] A_WL[99] A_WL[100] A_WL[101] A_WL[102] A_WL[103] A_WL[104]
+ A_WL[105] A_WL[106] A_WL[107] A_WL[108] A_WL[109] A_WL[110] A_WL[111]
+ A_WL[112] A_WL[113] A_WL[114] A_WL[115] A_WL[116] A_WL[117] A_WL[118]
+ A_WL[119] A_WL[120] A_WL[121] A_WL[122] A_WL[123] A_WL[124] A_WL[125]
+ A_WL[126] A_WL[127] A_WL[128] A_WL[129] A_WL[130] A_WL[131] A_WL[132]
+ A_WL[133] A_WL[134] A_WL[135] A_WL[136] A_WL[137] A_WL[138] A_WL[139]
+ A_WL[140] A_WL[141] A_WL[142] A_WL[143] A_WL[144] A_WL[145] A_WL[146]
+ A_WL[147] A_WL[148] A_WL[149] A_WL[150] A_WL[151] A_WL[152] A_WL[153]
+ A_WL[154] A_WL[155] A_WL[156] A_WL[157] A_WL[158] A_WL[159] A_WL[160]
+ A_WL[161] A_WL[162] A_WL[163] A_WL[164] A_WL[165] A_WL[166] A_WL[167]
+ A_WL[168] A_WL[169] A_WL[170] A_WL[171] A_WL[172] A_WL[173] A_WL[174]
+ A_WL[175] A_WL[176] A_WL[177] A_WL[178] A_WL[179] A_WL[180] A_WL[181]
+ A_WL[182] A_WL[183] A_WL[184] A_WL[185] A_WL[186] A_WL[187] A_WL[188]
+ A_WL[189] A_WL[190] A_WL[191] A_WL[192] A_WL[193] A_WL[194] A_WL[195]
+ A_WL[196] A_WL[197] A_WL[198] A_WL[199] A_WL[200] A_WL[201] A_WL[202]
+ A_WL[203] A_WL[204] A_WL[205] A_WL[206] A_WL[207] A_WL[208] A_WL[209]
+ A_WL[210] A_WL[211] A_WL[212] A_WL[213] A_WL[214] A_WL[215] A_WL[216]
+ A_WL[217] A_WL[218] A_WL[219] A_WL[220] A_WL[221] A_WL[222] A_WL[223]
+ A_WL[224] A_WL[225] A_WL[226] A_WL[227] A_WL[228] A_WL[229] A_WL[230]
+ A_WL[231] A_WL[232] A_WL[233] A_WL[234] A_WL[235] A_WL[236] A_WL[237]
+ A_WL[238] A_WL[239] A_WL[240] A_WL[241] A_WL[242] A_WL[243] A_WL[244]
+ A_WL[245] A_WL[246] A_WL[247] A_WL[248] A_WL[249] A_WL[250] A_WL[251]
+ A_WL[252] A_WL[253] A_WL[254] A_WL[255] B_WL[0] B_WL[1] B_WL[2] B_WL[3]
+ B_WL[4] B_WL[5] B_WL[6] B_WL[7] B_WL[8] B_WL[9] B_WL[10] B_WL[11] B_WL[12]
+ B_WL[13] B_WL[14] B_WL[15] B_WL[16] B_WL[17] B_WL[18] B_WL[19] B_WL[20]
+ B_WL[21] B_WL[22] B_WL[23] B_WL[24] B_WL[25] B_WL[26] B_WL[27] B_WL[28]
+ B_WL[29] B_WL[30] B_WL[31] B_WL[32] B_WL[33] B_WL[34] B_WL[35] B_WL[36]
+ B_WL[37] B_WL[38] B_WL[39] B_WL[40] B_WL[41] B_WL[42] B_WL[43] B_WL[44]
+ B_WL[45] B_WL[46] B_WL[47] B_WL[48] B_WL[49] B_WL[50] B_WL[51] B_WL[52]
+ B_WL[53] B_WL[54] B_WL[55] B_WL[56] B_WL[57] B_WL[58] B_WL[59] B_WL[60]
+ B_WL[61] B_WL[62] B_WL[63] B_WL[64] B_WL[65] B_WL[66] B_WL[67] B_WL[68]
+ B_WL[69] B_WL[70] B_WL[71] B_WL[72] B_WL[73] B_WL[74] B_WL[75] B_WL[76]
+ B_WL[77] B_WL[78] B_WL[79] B_WL[80] B_WL[81] B_WL[82] B_WL[83] B_WL[84]
+ B_WL[85] B_WL[86] B_WL[87] B_WL[88] B_WL[89] B_WL[90] B_WL[91] B_WL[92]
+ B_WL[93] B_WL[94] B_WL[95] B_WL[96] B_WL[97] B_WL[98] B_WL[99] B_WL[100]
+ B_WL[101] B_WL[102] B_WL[103] B_WL[104] B_WL[105] B_WL[106] B_WL[107]
+ B_WL[108] B_WL[109] B_WL[110] B_WL[111] B_WL[112] B_WL[113] B_WL[114]
+ B_WL[115] B_WL[116] B_WL[117] B_WL[118] B_WL[119] B_WL[120] B_WL[121]
+ B_WL[122] B_WL[123] B_WL[124] B_WL[125] B_WL[126] B_WL[127] B_WL[128]
+ B_WL[129] B_WL[130] B_WL[131] B_WL[132] B_WL[133] B_WL[134] B_WL[135]
+ B_WL[136] B_WL[137] B_WL[138] B_WL[139] B_WL[140] B_WL[141] B_WL[142]
+ B_WL[143] B_WL[144] B_WL[145] B_WL[146] B_WL[147] B_WL[148] B_WL[149]
+ B_WL[150] B_WL[151] B_WL[152] B_WL[153] B_WL[154] B_WL[155] B_WL[156]
+ B_WL[157] B_WL[158] B_WL[159] B_WL[160] B_WL[161] B_WL[162] B_WL[163]
+ B_WL[164] B_WL[165] B_WL[166] B_WL[167] B_WL[168] B_WL[169] B_WL[170]
+ B_WL[171] B_WL[172] B_WL[173] B_WL[174] B_WL[175] B_WL[176] B_WL[177]
+ B_WL[178] B_WL[179] B_WL[180] B_WL[181] B_WL[182] B_WL[183] B_WL[184]
+ B_WL[185] B_WL[186] B_WL[187] B_WL[188] B_WL[189] B_WL[190] B_WL[191]
+ B_WL[192] B_WL[193] B_WL[194] B_WL[195] B_WL[196] B_WL[197] B_WL[198]
+ B_WL[199] B_WL[200] B_WL[201] B_WL[202] B_WL[203] B_WL[204] B_WL[205]
+ B_WL[206] B_WL[207] B_WL[208] B_WL[209] B_WL[210] B_WL[211] B_WL[212]
+ B_WL[213] B_WL[214] B_WL[215] B_WL[216] B_WL[217] B_WL[218] B_WL[219]
+ B_WL[220] B_WL[221] B_WL[222] B_WL[223] B_WL[224] B_WL[225] B_WL[226]
+ B_WL[227] B_WL[228] B_WL[229] B_WL[230] B_WL[231] B_WL[232] B_WL[233]
+ B_WL[234] B_WL[235] B_WL[236] B_WL[237] B_WL[238] B_WL[239] B_WL[240]
+ B_WL[241] B_WL[242] B_WL[243] B_WL[244] B_WL[245] B_WL[246] B_WL[247]
+ B_WL[248] B_WL[249] B_WL[250] B_WL[251] B_WL[252] B_WL[253] B_WL[254]
+ B_WL[255] A_RDL[0] A_SMPRS_0[3] A_SMPRS_0[2] A_SMPRS_0[1] A_SMPRS_0[0]
+ A_SOE[0] A_WRTL[0] A_YSEL_0[7] A_YSEL_0[6] A_YSEL_0[5] A_YSEL_0[4]
+ A_YSEL_0[3] A_YSEL_0[2] A_YSEL_0[1] A_YSEL_0[0] B_RDL[0] B_SMPRS_0[3]
+ B_SMPRS_0[2] B_SMPRS_0[1] B_SMPRS_0[0] B_SOE[0] B_WRTL[0] B_YSEL_0[7]
+ B_YSEL_0[6] B_YSEL_0[5] B_YSEL_0[4] B_YSEL_0[3] B_YSEL_0[2] B_YSEL_0[1]
+ B_YSEL_0[0] AWTI BWEBA[27] BWEBMA[27] A_CKD DA[27] A_DLRS DMA[27] A_WENB[3]
+ A_WENB[2] A_WENB[1] A_WENB[0] BISTC BISTT BWEBB[27] BWEBMB[27] B_CKD DB[27]
+ B_DLRS DMB[27] B_WENB[3] B_WENB[2] B_WENB[1] B_WENB[0] QA[27] QB[27]
+  SDL400W20S_NBITSLC
XBIT28 A_WL[0] A_WL[1] A_WL[2] A_WL[3] A_WL[4] A_WL[5] A_WL[6] A_WL[7] A_WL[8]
+ A_WL[9] A_WL[10] A_WL[11] A_WL[12] A_WL[13] A_WL[14] A_WL[15] A_WL[16]
+ A_WL[17] A_WL[18] A_WL[19] A_WL[20] A_WL[21] A_WL[22] A_WL[23] A_WL[24]
+ A_WL[25] A_WL[26] A_WL[27] A_WL[28] A_WL[29] A_WL[30] A_WL[31] A_WL[32]
+ A_WL[33] A_WL[34] A_WL[35] A_WL[36] A_WL[37] A_WL[38] A_WL[39] A_WL[40]
+ A_WL[41] A_WL[42] A_WL[43] A_WL[44] A_WL[45] A_WL[46] A_WL[47] A_WL[48]
+ A_WL[49] A_WL[50] A_WL[51] A_WL[52] A_WL[53] A_WL[54] A_WL[55] A_WL[56]
+ A_WL[57] A_WL[58] A_WL[59] A_WL[60] A_WL[61] A_WL[62] A_WL[63] A_WL[64]
+ A_WL[65] A_WL[66] A_WL[67] A_WL[68] A_WL[69] A_WL[70] A_WL[71] A_WL[72]
+ A_WL[73] A_WL[74] A_WL[75] A_WL[76] A_WL[77] A_WL[78] A_WL[79] A_WL[80]
+ A_WL[81] A_WL[82] A_WL[83] A_WL[84] A_WL[85] A_WL[86] A_WL[87] A_WL[88]
+ A_WL[89] A_WL[90] A_WL[91] A_WL[92] A_WL[93] A_WL[94] A_WL[95] A_WL[96]
+ A_WL[97] A_WL[98] A_WL[99] A_WL[100] A_WL[101] A_WL[102] A_WL[103] A_WL[104]
+ A_WL[105] A_WL[106] A_WL[107] A_WL[108] A_WL[109] A_WL[110] A_WL[111]
+ A_WL[112] A_WL[113] A_WL[114] A_WL[115] A_WL[116] A_WL[117] A_WL[118]
+ A_WL[119] A_WL[120] A_WL[121] A_WL[122] A_WL[123] A_WL[124] A_WL[125]
+ A_WL[126] A_WL[127] A_WL[128] A_WL[129] A_WL[130] A_WL[131] A_WL[132]
+ A_WL[133] A_WL[134] A_WL[135] A_WL[136] A_WL[137] A_WL[138] A_WL[139]
+ A_WL[140] A_WL[141] A_WL[142] A_WL[143] A_WL[144] A_WL[145] A_WL[146]
+ A_WL[147] A_WL[148] A_WL[149] A_WL[150] A_WL[151] A_WL[152] A_WL[153]
+ A_WL[154] A_WL[155] A_WL[156] A_WL[157] A_WL[158] A_WL[159] A_WL[160]
+ A_WL[161] A_WL[162] A_WL[163] A_WL[164] A_WL[165] A_WL[166] A_WL[167]
+ A_WL[168] A_WL[169] A_WL[170] A_WL[171] A_WL[172] A_WL[173] A_WL[174]
+ A_WL[175] A_WL[176] A_WL[177] A_WL[178] A_WL[179] A_WL[180] A_WL[181]
+ A_WL[182] A_WL[183] A_WL[184] A_WL[185] A_WL[186] A_WL[187] A_WL[188]
+ A_WL[189] A_WL[190] A_WL[191] A_WL[192] A_WL[193] A_WL[194] A_WL[195]
+ A_WL[196] A_WL[197] A_WL[198] A_WL[199] A_WL[200] A_WL[201] A_WL[202]
+ A_WL[203] A_WL[204] A_WL[205] A_WL[206] A_WL[207] A_WL[208] A_WL[209]
+ A_WL[210] A_WL[211] A_WL[212] A_WL[213] A_WL[214] A_WL[215] A_WL[216]
+ A_WL[217] A_WL[218] A_WL[219] A_WL[220] A_WL[221] A_WL[222] A_WL[223]
+ A_WL[224] A_WL[225] A_WL[226] A_WL[227] A_WL[228] A_WL[229] A_WL[230]
+ A_WL[231] A_WL[232] A_WL[233] A_WL[234] A_WL[235] A_WL[236] A_WL[237]
+ A_WL[238] A_WL[239] A_WL[240] A_WL[241] A_WL[242] A_WL[243] A_WL[244]
+ A_WL[245] A_WL[246] A_WL[247] A_WL[248] A_WL[249] A_WL[250] A_WL[251]
+ A_WL[252] A_WL[253] A_WL[254] A_WL[255] B_WL[0] B_WL[1] B_WL[2] B_WL[3]
+ B_WL[4] B_WL[5] B_WL[6] B_WL[7] B_WL[8] B_WL[9] B_WL[10] B_WL[11] B_WL[12]
+ B_WL[13] B_WL[14] B_WL[15] B_WL[16] B_WL[17] B_WL[18] B_WL[19] B_WL[20]
+ B_WL[21] B_WL[22] B_WL[23] B_WL[24] B_WL[25] B_WL[26] B_WL[27] B_WL[28]
+ B_WL[29] B_WL[30] B_WL[31] B_WL[32] B_WL[33] B_WL[34] B_WL[35] B_WL[36]
+ B_WL[37] B_WL[38] B_WL[39] B_WL[40] B_WL[41] B_WL[42] B_WL[43] B_WL[44]
+ B_WL[45] B_WL[46] B_WL[47] B_WL[48] B_WL[49] B_WL[50] B_WL[51] B_WL[52]
+ B_WL[53] B_WL[54] B_WL[55] B_WL[56] B_WL[57] B_WL[58] B_WL[59] B_WL[60]
+ B_WL[61] B_WL[62] B_WL[63] B_WL[64] B_WL[65] B_WL[66] B_WL[67] B_WL[68]
+ B_WL[69] B_WL[70] B_WL[71] B_WL[72] B_WL[73] B_WL[74] B_WL[75] B_WL[76]
+ B_WL[77] B_WL[78] B_WL[79] B_WL[80] B_WL[81] B_WL[82] B_WL[83] B_WL[84]
+ B_WL[85] B_WL[86] B_WL[87] B_WL[88] B_WL[89] B_WL[90] B_WL[91] B_WL[92]
+ B_WL[93] B_WL[94] B_WL[95] B_WL[96] B_WL[97] B_WL[98] B_WL[99] B_WL[100]
+ B_WL[101] B_WL[102] B_WL[103] B_WL[104] B_WL[105] B_WL[106] B_WL[107]
+ B_WL[108] B_WL[109] B_WL[110] B_WL[111] B_WL[112] B_WL[113] B_WL[114]
+ B_WL[115] B_WL[116] B_WL[117] B_WL[118] B_WL[119] B_WL[120] B_WL[121]
+ B_WL[122] B_WL[123] B_WL[124] B_WL[125] B_WL[126] B_WL[127] B_WL[128]
+ B_WL[129] B_WL[130] B_WL[131] B_WL[132] B_WL[133] B_WL[134] B_WL[135]
+ B_WL[136] B_WL[137] B_WL[138] B_WL[139] B_WL[140] B_WL[141] B_WL[142]
+ B_WL[143] B_WL[144] B_WL[145] B_WL[146] B_WL[147] B_WL[148] B_WL[149]
+ B_WL[150] B_WL[151] B_WL[152] B_WL[153] B_WL[154] B_WL[155] B_WL[156]
+ B_WL[157] B_WL[158] B_WL[159] B_WL[160] B_WL[161] B_WL[162] B_WL[163]
+ B_WL[164] B_WL[165] B_WL[166] B_WL[167] B_WL[168] B_WL[169] B_WL[170]
+ B_WL[171] B_WL[172] B_WL[173] B_WL[174] B_WL[175] B_WL[176] B_WL[177]
+ B_WL[178] B_WL[179] B_WL[180] B_WL[181] B_WL[182] B_WL[183] B_WL[184]
+ B_WL[185] B_WL[186] B_WL[187] B_WL[188] B_WL[189] B_WL[190] B_WL[191]
+ B_WL[192] B_WL[193] B_WL[194] B_WL[195] B_WL[196] B_WL[197] B_WL[198]
+ B_WL[199] B_WL[200] B_WL[201] B_WL[202] B_WL[203] B_WL[204] B_WL[205]
+ B_WL[206] B_WL[207] B_WL[208] B_WL[209] B_WL[210] B_WL[211] B_WL[212]
+ B_WL[213] B_WL[214] B_WL[215] B_WL[216] B_WL[217] B_WL[218] B_WL[219]
+ B_WL[220] B_WL[221] B_WL[222] B_WL[223] B_WL[224] B_WL[225] B_WL[226]
+ B_WL[227] B_WL[228] B_WL[229] B_WL[230] B_WL[231] B_WL[232] B_WL[233]
+ B_WL[234] B_WL[235] B_WL[236] B_WL[237] B_WL[238] B_WL[239] B_WL[240]
+ B_WL[241] B_WL[242] B_WL[243] B_WL[244] B_WL[245] B_WL[246] B_WL[247]
+ B_WL[248] B_WL[249] B_WL[250] B_WL[251] B_WL[252] B_WL[253] B_WL[254]
+ B_WL[255] A_RDL[0] A_SMPRS_0[3] A_SMPRS_0[2] A_SMPRS_0[1] A_SMPRS_0[0]
+ A_SOE[0] A_WRTL[0] A_YSEL_0[7] A_YSEL_0[6] A_YSEL_0[5] A_YSEL_0[4]
+ A_YSEL_0[3] A_YSEL_0[2] A_YSEL_0[1] A_YSEL_0[0] B_RDL[0] B_SMPRS_0[3]
+ B_SMPRS_0[2] B_SMPRS_0[1] B_SMPRS_0[0] B_SOE[0] B_WRTL[0] B_YSEL_0[7]
+ B_YSEL_0[6] B_YSEL_0[5] B_YSEL_0[4] B_YSEL_0[3] B_YSEL_0[2] B_YSEL_0[1]
+ B_YSEL_0[0] AWTI BWEBA[28] BWEBMA[28] A_CKD DA[28] A_DLRS DMA[28] A_WENB[3]
+ A_WENB[2] A_WENB[1] A_WENB[0] BISTC BISTT BWEBB[28] BWEBMB[28] B_CKD DB[28]
+ B_DLRS DMB[28] B_WENB[3] B_WENB[2] B_WENB[1] B_WENB[0] QA[28] QB[28]
+  SDL400W20S_NBITSLC
XBIT29 A_WL[0] A_WL[1] A_WL[2] A_WL[3] A_WL[4] A_WL[5] A_WL[6] A_WL[7] A_WL[8]
+ A_WL[9] A_WL[10] A_WL[11] A_WL[12] A_WL[13] A_WL[14] A_WL[15] A_WL[16]
+ A_WL[17] A_WL[18] A_WL[19] A_WL[20] A_WL[21] A_WL[22] A_WL[23] A_WL[24]
+ A_WL[25] A_WL[26] A_WL[27] A_WL[28] A_WL[29] A_WL[30] A_WL[31] A_WL[32]
+ A_WL[33] A_WL[34] A_WL[35] A_WL[36] A_WL[37] A_WL[38] A_WL[39] A_WL[40]
+ A_WL[41] A_WL[42] A_WL[43] A_WL[44] A_WL[45] A_WL[46] A_WL[47] A_WL[48]
+ A_WL[49] A_WL[50] A_WL[51] A_WL[52] A_WL[53] A_WL[54] A_WL[55] A_WL[56]
+ A_WL[57] A_WL[58] A_WL[59] A_WL[60] A_WL[61] A_WL[62] A_WL[63] A_WL[64]
+ A_WL[65] A_WL[66] A_WL[67] A_WL[68] A_WL[69] A_WL[70] A_WL[71] A_WL[72]
+ A_WL[73] A_WL[74] A_WL[75] A_WL[76] A_WL[77] A_WL[78] A_WL[79] A_WL[80]
+ A_WL[81] A_WL[82] A_WL[83] A_WL[84] A_WL[85] A_WL[86] A_WL[87] A_WL[88]
+ A_WL[89] A_WL[90] A_WL[91] A_WL[92] A_WL[93] A_WL[94] A_WL[95] A_WL[96]
+ A_WL[97] A_WL[98] A_WL[99] A_WL[100] A_WL[101] A_WL[102] A_WL[103] A_WL[104]
+ A_WL[105] A_WL[106] A_WL[107] A_WL[108] A_WL[109] A_WL[110] A_WL[111]
+ A_WL[112] A_WL[113] A_WL[114] A_WL[115] A_WL[116] A_WL[117] A_WL[118]
+ A_WL[119] A_WL[120] A_WL[121] A_WL[122] A_WL[123] A_WL[124] A_WL[125]
+ A_WL[126] A_WL[127] A_WL[128] A_WL[129] A_WL[130] A_WL[131] A_WL[132]
+ A_WL[133] A_WL[134] A_WL[135] A_WL[136] A_WL[137] A_WL[138] A_WL[139]
+ A_WL[140] A_WL[141] A_WL[142] A_WL[143] A_WL[144] A_WL[145] A_WL[146]
+ A_WL[147] A_WL[148] A_WL[149] A_WL[150] A_WL[151] A_WL[152] A_WL[153]
+ A_WL[154] A_WL[155] A_WL[156] A_WL[157] A_WL[158] A_WL[159] A_WL[160]
+ A_WL[161] A_WL[162] A_WL[163] A_WL[164] A_WL[165] A_WL[166] A_WL[167]
+ A_WL[168] A_WL[169] A_WL[170] A_WL[171] A_WL[172] A_WL[173] A_WL[174]
+ A_WL[175] A_WL[176] A_WL[177] A_WL[178] A_WL[179] A_WL[180] A_WL[181]
+ A_WL[182] A_WL[183] A_WL[184] A_WL[185] A_WL[186] A_WL[187] A_WL[188]
+ A_WL[189] A_WL[190] A_WL[191] A_WL[192] A_WL[193] A_WL[194] A_WL[195]
+ A_WL[196] A_WL[197] A_WL[198] A_WL[199] A_WL[200] A_WL[201] A_WL[202]
+ A_WL[203] A_WL[204] A_WL[205] A_WL[206] A_WL[207] A_WL[208] A_WL[209]
+ A_WL[210] A_WL[211] A_WL[212] A_WL[213] A_WL[214] A_WL[215] A_WL[216]
+ A_WL[217] A_WL[218] A_WL[219] A_WL[220] A_WL[221] A_WL[222] A_WL[223]
+ A_WL[224] A_WL[225] A_WL[226] A_WL[227] A_WL[228] A_WL[229] A_WL[230]
+ A_WL[231] A_WL[232] A_WL[233] A_WL[234] A_WL[235] A_WL[236] A_WL[237]
+ A_WL[238] A_WL[239] A_WL[240] A_WL[241] A_WL[242] A_WL[243] A_WL[244]
+ A_WL[245] A_WL[246] A_WL[247] A_WL[248] A_WL[249] A_WL[250] A_WL[251]
+ A_WL[252] A_WL[253] A_WL[254] A_WL[255] B_WL[0] B_WL[1] B_WL[2] B_WL[3]
+ B_WL[4] B_WL[5] B_WL[6] B_WL[7] B_WL[8] B_WL[9] B_WL[10] B_WL[11] B_WL[12]
+ B_WL[13] B_WL[14] B_WL[15] B_WL[16] B_WL[17] B_WL[18] B_WL[19] B_WL[20]
+ B_WL[21] B_WL[22] B_WL[23] B_WL[24] B_WL[25] B_WL[26] B_WL[27] B_WL[28]
+ B_WL[29] B_WL[30] B_WL[31] B_WL[32] B_WL[33] B_WL[34] B_WL[35] B_WL[36]
+ B_WL[37] B_WL[38] B_WL[39] B_WL[40] B_WL[41] B_WL[42] B_WL[43] B_WL[44]
+ B_WL[45] B_WL[46] B_WL[47] B_WL[48] B_WL[49] B_WL[50] B_WL[51] B_WL[52]
+ B_WL[53] B_WL[54] B_WL[55] B_WL[56] B_WL[57] B_WL[58] B_WL[59] B_WL[60]
+ B_WL[61] B_WL[62] B_WL[63] B_WL[64] B_WL[65] B_WL[66] B_WL[67] B_WL[68]
+ B_WL[69] B_WL[70] B_WL[71] B_WL[72] B_WL[73] B_WL[74] B_WL[75] B_WL[76]
+ B_WL[77] B_WL[78] B_WL[79] B_WL[80] B_WL[81] B_WL[82] B_WL[83] B_WL[84]
+ B_WL[85] B_WL[86] B_WL[87] B_WL[88] B_WL[89] B_WL[90] B_WL[91] B_WL[92]
+ B_WL[93] B_WL[94] B_WL[95] B_WL[96] B_WL[97] B_WL[98] B_WL[99] B_WL[100]
+ B_WL[101] B_WL[102] B_WL[103] B_WL[104] B_WL[105] B_WL[106] B_WL[107]
+ B_WL[108] B_WL[109] B_WL[110] B_WL[111] B_WL[112] B_WL[113] B_WL[114]
+ B_WL[115] B_WL[116] B_WL[117] B_WL[118] B_WL[119] B_WL[120] B_WL[121]
+ B_WL[122] B_WL[123] B_WL[124] B_WL[125] B_WL[126] B_WL[127] B_WL[128]
+ B_WL[129] B_WL[130] B_WL[131] B_WL[132] B_WL[133] B_WL[134] B_WL[135]
+ B_WL[136] B_WL[137] B_WL[138] B_WL[139] B_WL[140] B_WL[141] B_WL[142]
+ B_WL[143] B_WL[144] B_WL[145] B_WL[146] B_WL[147] B_WL[148] B_WL[149]
+ B_WL[150] B_WL[151] B_WL[152] B_WL[153] B_WL[154] B_WL[155] B_WL[156]
+ B_WL[157] B_WL[158] B_WL[159] B_WL[160] B_WL[161] B_WL[162] B_WL[163]
+ B_WL[164] B_WL[165] B_WL[166] B_WL[167] B_WL[168] B_WL[169] B_WL[170]
+ B_WL[171] B_WL[172] B_WL[173] B_WL[174] B_WL[175] B_WL[176] B_WL[177]
+ B_WL[178] B_WL[179] B_WL[180] B_WL[181] B_WL[182] B_WL[183] B_WL[184]
+ B_WL[185] B_WL[186] B_WL[187] B_WL[188] B_WL[189] B_WL[190] B_WL[191]
+ B_WL[192] B_WL[193] B_WL[194] B_WL[195] B_WL[196] B_WL[197] B_WL[198]
+ B_WL[199] B_WL[200] B_WL[201] B_WL[202] B_WL[203] B_WL[204] B_WL[205]
+ B_WL[206] B_WL[207] B_WL[208] B_WL[209] B_WL[210] B_WL[211] B_WL[212]
+ B_WL[213] B_WL[214] B_WL[215] B_WL[216] B_WL[217] B_WL[218] B_WL[219]
+ B_WL[220] B_WL[221] B_WL[222] B_WL[223] B_WL[224] B_WL[225] B_WL[226]
+ B_WL[227] B_WL[228] B_WL[229] B_WL[230] B_WL[231] B_WL[232] B_WL[233]
+ B_WL[234] B_WL[235] B_WL[236] B_WL[237] B_WL[238] B_WL[239] B_WL[240]
+ B_WL[241] B_WL[242] B_WL[243] B_WL[244] B_WL[245] B_WL[246] B_WL[247]
+ B_WL[248] B_WL[249] B_WL[250] B_WL[251] B_WL[252] B_WL[253] B_WL[254]
+ B_WL[255] A_RDL[0] A_SMPRS_0[3] A_SMPRS_0[2] A_SMPRS_0[1] A_SMPRS_0[0]
+ A_SOE[0] A_WRTL[0] A_YSEL_0[7] A_YSEL_0[6] A_YSEL_0[5] A_YSEL_0[4]
+ A_YSEL_0[3] A_YSEL_0[2] A_YSEL_0[1] A_YSEL_0[0] B_RDL[0] B_SMPRS_0[3]
+ B_SMPRS_0[2] B_SMPRS_0[1] B_SMPRS_0[0] B_SOE[0] B_WRTL[0] B_YSEL_0[7]
+ B_YSEL_0[6] B_YSEL_0[5] B_YSEL_0[4] B_YSEL_0[3] B_YSEL_0[2] B_YSEL_0[1]
+ B_YSEL_0[0] AWTI BWEBA[29] BWEBMA[29] A_CKD DA[29] A_DLRS DMA[29] A_WENB[3]
+ A_WENB[2] A_WENB[1] A_WENB[0] BISTC BISTT BWEBB[29] BWEBMB[29] B_CKD DB[29]
+ B_DLRS DMB[29] B_WENB[3] B_WENB[2] B_WENB[1] B_WENB[0] QA[29] QB[29]
+  SDL400W20S_NBITSLC
XBIT30 A_WL[0] A_WL[1] A_WL[2] A_WL[3] A_WL[4] A_WL[5] A_WL[6] A_WL[7] A_WL[8]
+ A_WL[9] A_WL[10] A_WL[11] A_WL[12] A_WL[13] A_WL[14] A_WL[15] A_WL[16]
+ A_WL[17] A_WL[18] A_WL[19] A_WL[20] A_WL[21] A_WL[22] A_WL[23] A_WL[24]
+ A_WL[25] A_WL[26] A_WL[27] A_WL[28] A_WL[29] A_WL[30] A_WL[31] A_WL[32]
+ A_WL[33] A_WL[34] A_WL[35] A_WL[36] A_WL[37] A_WL[38] A_WL[39] A_WL[40]
+ A_WL[41] A_WL[42] A_WL[43] A_WL[44] A_WL[45] A_WL[46] A_WL[47] A_WL[48]
+ A_WL[49] A_WL[50] A_WL[51] A_WL[52] A_WL[53] A_WL[54] A_WL[55] A_WL[56]
+ A_WL[57] A_WL[58] A_WL[59] A_WL[60] A_WL[61] A_WL[62] A_WL[63] A_WL[64]
+ A_WL[65] A_WL[66] A_WL[67] A_WL[68] A_WL[69] A_WL[70] A_WL[71] A_WL[72]
+ A_WL[73] A_WL[74] A_WL[75] A_WL[76] A_WL[77] A_WL[78] A_WL[79] A_WL[80]
+ A_WL[81] A_WL[82] A_WL[83] A_WL[84] A_WL[85] A_WL[86] A_WL[87] A_WL[88]
+ A_WL[89] A_WL[90] A_WL[91] A_WL[92] A_WL[93] A_WL[94] A_WL[95] A_WL[96]
+ A_WL[97] A_WL[98] A_WL[99] A_WL[100] A_WL[101] A_WL[102] A_WL[103] A_WL[104]
+ A_WL[105] A_WL[106] A_WL[107] A_WL[108] A_WL[109] A_WL[110] A_WL[111]
+ A_WL[112] A_WL[113] A_WL[114] A_WL[115] A_WL[116] A_WL[117] A_WL[118]
+ A_WL[119] A_WL[120] A_WL[121] A_WL[122] A_WL[123] A_WL[124] A_WL[125]
+ A_WL[126] A_WL[127] A_WL[128] A_WL[129] A_WL[130] A_WL[131] A_WL[132]
+ A_WL[133] A_WL[134] A_WL[135] A_WL[136] A_WL[137] A_WL[138] A_WL[139]
+ A_WL[140] A_WL[141] A_WL[142] A_WL[143] A_WL[144] A_WL[145] A_WL[146]
+ A_WL[147] A_WL[148] A_WL[149] A_WL[150] A_WL[151] A_WL[152] A_WL[153]
+ A_WL[154] A_WL[155] A_WL[156] A_WL[157] A_WL[158] A_WL[159] A_WL[160]
+ A_WL[161] A_WL[162] A_WL[163] A_WL[164] A_WL[165] A_WL[166] A_WL[167]
+ A_WL[168] A_WL[169] A_WL[170] A_WL[171] A_WL[172] A_WL[173] A_WL[174]
+ A_WL[175] A_WL[176] A_WL[177] A_WL[178] A_WL[179] A_WL[180] A_WL[181]
+ A_WL[182] A_WL[183] A_WL[184] A_WL[185] A_WL[186] A_WL[187] A_WL[188]
+ A_WL[189] A_WL[190] A_WL[191] A_WL[192] A_WL[193] A_WL[194] A_WL[195]
+ A_WL[196] A_WL[197] A_WL[198] A_WL[199] A_WL[200] A_WL[201] A_WL[202]
+ A_WL[203] A_WL[204] A_WL[205] A_WL[206] A_WL[207] A_WL[208] A_WL[209]
+ A_WL[210] A_WL[211] A_WL[212] A_WL[213] A_WL[214] A_WL[215] A_WL[216]
+ A_WL[217] A_WL[218] A_WL[219] A_WL[220] A_WL[221] A_WL[222] A_WL[223]
+ A_WL[224] A_WL[225] A_WL[226] A_WL[227] A_WL[228] A_WL[229] A_WL[230]
+ A_WL[231] A_WL[232] A_WL[233] A_WL[234] A_WL[235] A_WL[236] A_WL[237]
+ A_WL[238] A_WL[239] A_WL[240] A_WL[241] A_WL[242] A_WL[243] A_WL[244]
+ A_WL[245] A_WL[246] A_WL[247] A_WL[248] A_WL[249] A_WL[250] A_WL[251]
+ A_WL[252] A_WL[253] A_WL[254] A_WL[255] B_WL[0] B_WL[1] B_WL[2] B_WL[3]
+ B_WL[4] B_WL[5] B_WL[6] B_WL[7] B_WL[8] B_WL[9] B_WL[10] B_WL[11] B_WL[12]
+ B_WL[13] B_WL[14] B_WL[15] B_WL[16] B_WL[17] B_WL[18] B_WL[19] B_WL[20]
+ B_WL[21] B_WL[22] B_WL[23] B_WL[24] B_WL[25] B_WL[26] B_WL[27] B_WL[28]
+ B_WL[29] B_WL[30] B_WL[31] B_WL[32] B_WL[33] B_WL[34] B_WL[35] B_WL[36]
+ B_WL[37] B_WL[38] B_WL[39] B_WL[40] B_WL[41] B_WL[42] B_WL[43] B_WL[44]
+ B_WL[45] B_WL[46] B_WL[47] B_WL[48] B_WL[49] B_WL[50] B_WL[51] B_WL[52]
+ B_WL[53] B_WL[54] B_WL[55] B_WL[56] B_WL[57] B_WL[58] B_WL[59] B_WL[60]
+ B_WL[61] B_WL[62] B_WL[63] B_WL[64] B_WL[65] B_WL[66] B_WL[67] B_WL[68]
+ B_WL[69] B_WL[70] B_WL[71] B_WL[72] B_WL[73] B_WL[74] B_WL[75] B_WL[76]
+ B_WL[77] B_WL[78] B_WL[79] B_WL[80] B_WL[81] B_WL[82] B_WL[83] B_WL[84]
+ B_WL[85] B_WL[86] B_WL[87] B_WL[88] B_WL[89] B_WL[90] B_WL[91] B_WL[92]
+ B_WL[93] B_WL[94] B_WL[95] B_WL[96] B_WL[97] B_WL[98] B_WL[99] B_WL[100]
+ B_WL[101] B_WL[102] B_WL[103] B_WL[104] B_WL[105] B_WL[106] B_WL[107]
+ B_WL[108] B_WL[109] B_WL[110] B_WL[111] B_WL[112] B_WL[113] B_WL[114]
+ B_WL[115] B_WL[116] B_WL[117] B_WL[118] B_WL[119] B_WL[120] B_WL[121]
+ B_WL[122] B_WL[123] B_WL[124] B_WL[125] B_WL[126] B_WL[127] B_WL[128]
+ B_WL[129] B_WL[130] B_WL[131] B_WL[132] B_WL[133] B_WL[134] B_WL[135]
+ B_WL[136] B_WL[137] B_WL[138] B_WL[139] B_WL[140] B_WL[141] B_WL[142]
+ B_WL[143] B_WL[144] B_WL[145] B_WL[146] B_WL[147] B_WL[148] B_WL[149]
+ B_WL[150] B_WL[151] B_WL[152] B_WL[153] B_WL[154] B_WL[155] B_WL[156]
+ B_WL[157] B_WL[158] B_WL[159] B_WL[160] B_WL[161] B_WL[162] B_WL[163]
+ B_WL[164] B_WL[165] B_WL[166] B_WL[167] B_WL[168] B_WL[169] B_WL[170]
+ B_WL[171] B_WL[172] B_WL[173] B_WL[174] B_WL[175] B_WL[176] B_WL[177]
+ B_WL[178] B_WL[179] B_WL[180] B_WL[181] B_WL[182] B_WL[183] B_WL[184]
+ B_WL[185] B_WL[186] B_WL[187] B_WL[188] B_WL[189] B_WL[190] B_WL[191]
+ B_WL[192] B_WL[193] B_WL[194] B_WL[195] B_WL[196] B_WL[197] B_WL[198]
+ B_WL[199] B_WL[200] B_WL[201] B_WL[202] B_WL[203] B_WL[204] B_WL[205]
+ B_WL[206] B_WL[207] B_WL[208] B_WL[209] B_WL[210] B_WL[211] B_WL[212]
+ B_WL[213] B_WL[214] B_WL[215] B_WL[216] B_WL[217] B_WL[218] B_WL[219]
+ B_WL[220] B_WL[221] B_WL[222] B_WL[223] B_WL[224] B_WL[225] B_WL[226]
+ B_WL[227] B_WL[228] B_WL[229] B_WL[230] B_WL[231] B_WL[232] B_WL[233]
+ B_WL[234] B_WL[235] B_WL[236] B_WL[237] B_WL[238] B_WL[239] B_WL[240]
+ B_WL[241] B_WL[242] B_WL[243] B_WL[244] B_WL[245] B_WL[246] B_WL[247]
+ B_WL[248] B_WL[249] B_WL[250] B_WL[251] B_WL[252] B_WL[253] B_WL[254]
+ B_WL[255] A_RDL[0] A_SMPRS_0[3] A_SMPRS_0[2] A_SMPRS_0[1] A_SMPRS_0[0]
+ A_SOE[0] A_WRTL[0] A_YSEL_0[7] A_YSEL_0[6] A_YSEL_0[5] A_YSEL_0[4]
+ A_YSEL_0[3] A_YSEL_0[2] A_YSEL_0[1] A_YSEL_0[0] B_RDL[0] B_SMPRS_0[3]
+ B_SMPRS_0[2] B_SMPRS_0[1] B_SMPRS_0[0] B_SOE[0] B_WRTL[0] B_YSEL_0[7]
+ B_YSEL_0[6] B_YSEL_0[5] B_YSEL_0[4] B_YSEL_0[3] B_YSEL_0[2] B_YSEL_0[1]
+ B_YSEL_0[0] AWTI BWEBA[30] BWEBMA[30] A_CKD DA[30] A_DLRS DMA[30] A_WENB[3]
+ A_WENB[2] A_WENB[1] A_WENB[0] BISTC BISTT BWEBB[30] BWEBMB[30] B_CKD DB[30]
+ B_DLRS DMB[30] B_WENB[3] B_WENB[2] B_WENB[1] B_WENB[0] QA[30] QB[30]
+  SDL400W20S_NBITSLC
XBIT31 A_WL[0] A_WL[1] A_WL[2] A_WL[3] A_WL[4] A_WL[5] A_WL[6] A_WL[7] A_WL[8]
+ A_WL[9] A_WL[10] A_WL[11] A_WL[12] A_WL[13] A_WL[14] A_WL[15] A_WL[16]
+ A_WL[17] A_WL[18] A_WL[19] A_WL[20] A_WL[21] A_WL[22] A_WL[23] A_WL[24]
+ A_WL[25] A_WL[26] A_WL[27] A_WL[28] A_WL[29] A_WL[30] A_WL[31] A_WL[32]
+ A_WL[33] A_WL[34] A_WL[35] A_WL[36] A_WL[37] A_WL[38] A_WL[39] A_WL[40]
+ A_WL[41] A_WL[42] A_WL[43] A_WL[44] A_WL[45] A_WL[46] A_WL[47] A_WL[48]
+ A_WL[49] A_WL[50] A_WL[51] A_WL[52] A_WL[53] A_WL[54] A_WL[55] A_WL[56]
+ A_WL[57] A_WL[58] A_WL[59] A_WL[60] A_WL[61] A_WL[62] A_WL[63] A_WL[64]
+ A_WL[65] A_WL[66] A_WL[67] A_WL[68] A_WL[69] A_WL[70] A_WL[71] A_WL[72]
+ A_WL[73] A_WL[74] A_WL[75] A_WL[76] A_WL[77] A_WL[78] A_WL[79] A_WL[80]
+ A_WL[81] A_WL[82] A_WL[83] A_WL[84] A_WL[85] A_WL[86] A_WL[87] A_WL[88]
+ A_WL[89] A_WL[90] A_WL[91] A_WL[92] A_WL[93] A_WL[94] A_WL[95] A_WL[96]
+ A_WL[97] A_WL[98] A_WL[99] A_WL[100] A_WL[101] A_WL[102] A_WL[103] A_WL[104]
+ A_WL[105] A_WL[106] A_WL[107] A_WL[108] A_WL[109] A_WL[110] A_WL[111]
+ A_WL[112] A_WL[113] A_WL[114] A_WL[115] A_WL[116] A_WL[117] A_WL[118]
+ A_WL[119] A_WL[120] A_WL[121] A_WL[122] A_WL[123] A_WL[124] A_WL[125]
+ A_WL[126] A_WL[127] A_WL[128] A_WL[129] A_WL[130] A_WL[131] A_WL[132]
+ A_WL[133] A_WL[134] A_WL[135] A_WL[136] A_WL[137] A_WL[138] A_WL[139]
+ A_WL[140] A_WL[141] A_WL[142] A_WL[143] A_WL[144] A_WL[145] A_WL[146]
+ A_WL[147] A_WL[148] A_WL[149] A_WL[150] A_WL[151] A_WL[152] A_WL[153]
+ A_WL[154] A_WL[155] A_WL[156] A_WL[157] A_WL[158] A_WL[159] A_WL[160]
+ A_WL[161] A_WL[162] A_WL[163] A_WL[164] A_WL[165] A_WL[166] A_WL[167]
+ A_WL[168] A_WL[169] A_WL[170] A_WL[171] A_WL[172] A_WL[173] A_WL[174]
+ A_WL[175] A_WL[176] A_WL[177] A_WL[178] A_WL[179] A_WL[180] A_WL[181]
+ A_WL[182] A_WL[183] A_WL[184] A_WL[185] A_WL[186] A_WL[187] A_WL[188]
+ A_WL[189] A_WL[190] A_WL[191] A_WL[192] A_WL[193] A_WL[194] A_WL[195]
+ A_WL[196] A_WL[197] A_WL[198] A_WL[199] A_WL[200] A_WL[201] A_WL[202]
+ A_WL[203] A_WL[204] A_WL[205] A_WL[206] A_WL[207] A_WL[208] A_WL[209]
+ A_WL[210] A_WL[211] A_WL[212] A_WL[213] A_WL[214] A_WL[215] A_WL[216]
+ A_WL[217] A_WL[218] A_WL[219] A_WL[220] A_WL[221] A_WL[222] A_WL[223]
+ A_WL[224] A_WL[225] A_WL[226] A_WL[227] A_WL[228] A_WL[229] A_WL[230]
+ A_WL[231] A_WL[232] A_WL[233] A_WL[234] A_WL[235] A_WL[236] A_WL[237]
+ A_WL[238] A_WL[239] A_WL[240] A_WL[241] A_WL[242] A_WL[243] A_WL[244]
+ A_WL[245] A_WL[246] A_WL[247] A_WL[248] A_WL[249] A_WL[250] A_WL[251]
+ A_WL[252] A_WL[253] A_WL[254] A_WL[255] B_WL[0] B_WL[1] B_WL[2] B_WL[3]
+ B_WL[4] B_WL[5] B_WL[6] B_WL[7] B_WL[8] B_WL[9] B_WL[10] B_WL[11] B_WL[12]
+ B_WL[13] B_WL[14] B_WL[15] B_WL[16] B_WL[17] B_WL[18] B_WL[19] B_WL[20]
+ B_WL[21] B_WL[22] B_WL[23] B_WL[24] B_WL[25] B_WL[26] B_WL[27] B_WL[28]
+ B_WL[29] B_WL[30] B_WL[31] B_WL[32] B_WL[33] B_WL[34] B_WL[35] B_WL[36]
+ B_WL[37] B_WL[38] B_WL[39] B_WL[40] B_WL[41] B_WL[42] B_WL[43] B_WL[44]
+ B_WL[45] B_WL[46] B_WL[47] B_WL[48] B_WL[49] B_WL[50] B_WL[51] B_WL[52]
+ B_WL[53] B_WL[54] B_WL[55] B_WL[56] B_WL[57] B_WL[58] B_WL[59] B_WL[60]
+ B_WL[61] B_WL[62] B_WL[63] B_WL[64] B_WL[65] B_WL[66] B_WL[67] B_WL[68]
+ B_WL[69] B_WL[70] B_WL[71] B_WL[72] B_WL[73] B_WL[74] B_WL[75] B_WL[76]
+ B_WL[77] B_WL[78] B_WL[79] B_WL[80] B_WL[81] B_WL[82] B_WL[83] B_WL[84]
+ B_WL[85] B_WL[86] B_WL[87] B_WL[88] B_WL[89] B_WL[90] B_WL[91] B_WL[92]
+ B_WL[93] B_WL[94] B_WL[95] B_WL[96] B_WL[97] B_WL[98] B_WL[99] B_WL[100]
+ B_WL[101] B_WL[102] B_WL[103] B_WL[104] B_WL[105] B_WL[106] B_WL[107]
+ B_WL[108] B_WL[109] B_WL[110] B_WL[111] B_WL[112] B_WL[113] B_WL[114]
+ B_WL[115] B_WL[116] B_WL[117] B_WL[118] B_WL[119] B_WL[120] B_WL[121]
+ B_WL[122] B_WL[123] B_WL[124] B_WL[125] B_WL[126] B_WL[127] B_WL[128]
+ B_WL[129] B_WL[130] B_WL[131] B_WL[132] B_WL[133] B_WL[134] B_WL[135]
+ B_WL[136] B_WL[137] B_WL[138] B_WL[139] B_WL[140] B_WL[141] B_WL[142]
+ B_WL[143] B_WL[144] B_WL[145] B_WL[146] B_WL[147] B_WL[148] B_WL[149]
+ B_WL[150] B_WL[151] B_WL[152] B_WL[153] B_WL[154] B_WL[155] B_WL[156]
+ B_WL[157] B_WL[158] B_WL[159] B_WL[160] B_WL[161] B_WL[162] B_WL[163]
+ B_WL[164] B_WL[165] B_WL[166] B_WL[167] B_WL[168] B_WL[169] B_WL[170]
+ B_WL[171] B_WL[172] B_WL[173] B_WL[174] B_WL[175] B_WL[176] B_WL[177]
+ B_WL[178] B_WL[179] B_WL[180] B_WL[181] B_WL[182] B_WL[183] B_WL[184]
+ B_WL[185] B_WL[186] B_WL[187] B_WL[188] B_WL[189] B_WL[190] B_WL[191]
+ B_WL[192] B_WL[193] B_WL[194] B_WL[195] B_WL[196] B_WL[197] B_WL[198]
+ B_WL[199] B_WL[200] B_WL[201] B_WL[202] B_WL[203] B_WL[204] B_WL[205]
+ B_WL[206] B_WL[207] B_WL[208] B_WL[209] B_WL[210] B_WL[211] B_WL[212]
+ B_WL[213] B_WL[214] B_WL[215] B_WL[216] B_WL[217] B_WL[218] B_WL[219]
+ B_WL[220] B_WL[221] B_WL[222] B_WL[223] B_WL[224] B_WL[225] B_WL[226]
+ B_WL[227] B_WL[228] B_WL[229] B_WL[230] B_WL[231] B_WL[232] B_WL[233]
+ B_WL[234] B_WL[235] B_WL[236] B_WL[237] B_WL[238] B_WL[239] B_WL[240]
+ B_WL[241] B_WL[242] B_WL[243] B_WL[244] B_WL[245] B_WL[246] B_WL[247]
+ B_WL[248] B_WL[249] B_WL[250] B_WL[251] B_WL[252] B_WL[253] B_WL[254]
+ B_WL[255] A_RDL[0] A_SMPRS_0[3] A_SMPRS_0[2] A_SMPRS_0[1] A_SMPRS_0[0]
+ A_SOE[0] A_WRTL[0] A_YSEL_0[7] A_YSEL_0[6] A_YSEL_0[5] A_YSEL_0[4]
+ A_YSEL_0[3] A_YSEL_0[2] A_YSEL_0[1] A_YSEL_0[0] B_RDL[0] B_SMPRS_0[3]
+ B_SMPRS_0[2] B_SMPRS_0[1] B_SMPRS_0[0] B_SOE[0] B_WRTL[0] B_YSEL_0[7]
+ B_YSEL_0[6] B_YSEL_0[5] B_YSEL_0[4] B_YSEL_0[3] B_YSEL_0[2] B_YSEL_0[1]
+ B_YSEL_0[0] AWTI BWEBA[31] BWEBMA[31] A_CKD DA[31] A_DLRS DMA[31] A_WENB[3]
+ A_WENB[2] A_WENB[1] A_WENB[0] BISTC BISTT BWEBB[31] BWEBMB[31] B_CKD DB[31]
+ B_DLRS DMB[31] B_WENB[3] B_WENB[2] B_WENB[1] B_WENB[0] QA[31] QB[31]
+  SDL400W20S_NBITSLC
.ENDS

.SUBCKT TSDN65LPLLA1024X32M4S AA[9] AA[8] AA[7] AA[6] AA[5] AA[4] AA[3] AA[2]
+ AA[1] AA[0] DA[31] DA[30] DA[29] DA[28] DA[27] DA[26] DA[25] DA[24] DA[23]
+ DA[22] DA[21] DA[20] DA[19] DA[18] DA[17] DA[16] DA[15] DA[14] DA[13] DA[12]
+ DA[11] DA[10] DA[9] DA[8] DA[7] DA[6] DA[5] DA[4] DA[3] DA[2] DA[1] DA[0]
+ BWEBA[31] BWEBA[30] BWEBA[29] BWEBA[28] BWEBA[27] BWEBA[26] BWEBA[25]
+ BWEBA[24] BWEBA[23] BWEBA[22] BWEBA[21] BWEBA[20] BWEBA[19] BWEBA[18]
+ BWEBA[17] BWEBA[16] BWEBA[15] BWEBA[14] BWEBA[13] BWEBA[12] BWEBA[11]
+ BWEBA[10] BWEBA[9] BWEBA[8] BWEBA[7] BWEBA[6] BWEBA[5] BWEBA[4] BWEBA[3]
+ BWEBA[2] BWEBA[1] BWEBA[0] WEBA CEBA CLKA AB[9] AB[8] AB[7] AB[6] AB[5] AB[4]
+ AB[3] AB[2] AB[1] AB[0] DB[31] DB[30] DB[29] DB[28] DB[27] DB[26] DB[25]
+ DB[24] DB[23] DB[22] DB[21] DB[20] DB[19] DB[18] DB[17] DB[16] DB[15] DB[14]
+ DB[13] DB[12] DB[11] DB[10] DB[9] DB[8] DB[7] DB[6] DB[5] DB[4] DB[3] DB[2]
+ DB[1] DB[0] BWEBB[31] BWEBB[30] BWEBB[29] BWEBB[28] BWEBB[27] BWEBB[26]
+ BWEBB[25] BWEBB[24] BWEBB[23] BWEBB[22] BWEBB[21] BWEBB[20] BWEBB[19]
+ BWEBB[18] BWEBB[17] BWEBB[16] BWEBB[15] BWEBB[14] BWEBB[13] BWEBB[12]
+ BWEBB[11] BWEBB[10] BWEBB[9] BWEBB[8] BWEBB[7] BWEBB[6] BWEBB[5] BWEBB[4]
+ BWEBB[3] BWEBB[2] BWEBB[1] BWEBB[0] WEBB CEBB CLKB QA[31] QA[30] QA[29]
+ QA[28] QA[27] QA[26] QA[25] QA[24] QA[23] QA[22] QA[21] QA[20] QA[19] QA[18]
+ QA[17] QA[16] QA[15] QA[14] QA[13] QA[12] QA[11] QA[10] QA[9] QA[8] QA[7]
+ QA[6] QA[5] QA[4] QA[3] QA[2] QA[1] QA[0] QB[31] QB[30] QB[29] QB[28] QB[27]
+ QB[26] QB[25] QB[24] QB[23] QB[22] QB[21] QB[20] QB[19] QB[18] QB[17] QB[16]
+ QB[15] QB[14] QB[13] QB[12] QB[11] QB[10] QB[9] QB[8] QB[7] QB[6] QB[5] QB[4]
+ QB[3] QB[2] QB[1] QB[0]
XAINAA0 AA[0] SDL400W20S_NAIN1
XAINAA1 AA[1] SDL400W20S_NAIN1
XAINAA2 AA[2] SDL400W20S_NAIN1
XAINAA3 AA[3] SDL400W20S_NAIN1
XAINAA4 AA[4] SDL400W20S_NAIN1
XAINAA5 AA[5] SDL400W20S_NAIN1
XAINAA6 AA[6] SDL400W20S_NAIN1
XAINAA7 AA[7] SDL400W20S_NAIN1
XAINAA8 AA[8] SDL400W20S_NAIN1
XAINAA9 AA[9] SDL400W20S_NAIN1
XAINDA0 DA[0] SDL400W20S_NAIN1
XAINDA1 DA[1] SDL400W20S_NAIN1
XAINDA2 DA[2] SDL400W20S_NAIN1
XAINDA3 DA[3] SDL400W20S_NAIN1
XAINDA4 DA[4] SDL400W20S_NAIN1
XAINDA5 DA[5] SDL400W20S_NAIN1
XAINDA6 DA[6] SDL400W20S_NAIN1
XAINDA7 DA[7] SDL400W20S_NAIN1
XAINDA8 DA[8] SDL400W20S_NAIN1
XAINDA9 DA[9] SDL400W20S_NAIN1
XAINDA10 DA[10] SDL400W20S_NAIN1
XAINDA11 DA[11] SDL400W20S_NAIN1
XAINDA12 DA[12] SDL400W20S_NAIN1
XAINDA13 DA[13] SDL400W20S_NAIN1
XAINDA14 DA[14] SDL400W20S_NAIN1
XAINDA15 DA[15] SDL400W20S_NAIN1
XAINDA16 DA[16] SDL400W20S_NAIN1
XAINDA17 DA[17] SDL400W20S_NAIN1
XAINDA18 DA[18] SDL400W20S_NAIN1
XAINDA19 DA[19] SDL400W20S_NAIN1
XAINDA20 DA[20] SDL400W20S_NAIN1
XAINDA21 DA[21] SDL400W20S_NAIN1
XAINDA22 DA[22] SDL400W20S_NAIN1
XAINDA23 DA[23] SDL400W20S_NAIN1
XAINDA24 DA[24] SDL400W20S_NAIN1
XAINDA25 DA[25] SDL400W20S_NAIN1
XAINDA26 DA[26] SDL400W20S_NAIN1
XAINDA27 DA[27] SDL400W20S_NAIN1
XAINDA28 DA[28] SDL400W20S_NAIN1
XAINDA29 DA[29] SDL400W20S_NAIN1
XAINDA30 DA[30] SDL400W20S_NAIN1
XAINDA31 DA[31] SDL400W20S_NAIN1
XAINBWEBA0 BWEBA[0] SDL400W20S_NAIN1
XAINBWEBA1 BWEBA[1] SDL400W20S_NAIN1
XAINBWEBA2 BWEBA[2] SDL400W20S_NAIN1
XAINBWEBA3 BWEBA[3] SDL400W20S_NAIN1
XAINBWEBA4 BWEBA[4] SDL400W20S_NAIN1
XAINBWEBA5 BWEBA[5] SDL400W20S_NAIN1
XAINBWEBA6 BWEBA[6] SDL400W20S_NAIN1
XAINBWEBA7 BWEBA[7] SDL400W20S_NAIN1
XAINBWEBA8 BWEBA[8] SDL400W20S_NAIN1
XAINBWEBA9 BWEBA[9] SDL400W20S_NAIN1
XAINBWEBA10 BWEBA[10] SDL400W20S_NAIN1
XAINBWEBA11 BWEBA[11] SDL400W20S_NAIN1
XAINBWEBA12 BWEBA[12] SDL400W20S_NAIN1
XAINBWEBA13 BWEBA[13] SDL400W20S_NAIN1
XAINBWEBA14 BWEBA[14] SDL400W20S_NAIN1
XAINBWEBA15 BWEBA[15] SDL400W20S_NAIN1
XAINBWEBA16 BWEBA[16] SDL400W20S_NAIN1
XAINBWEBA17 BWEBA[17] SDL400W20S_NAIN1
XAINBWEBA18 BWEBA[18] SDL400W20S_NAIN1
XAINBWEBA19 BWEBA[19] SDL400W20S_NAIN1
XAINBWEBA20 BWEBA[20] SDL400W20S_NAIN1
XAINBWEBA21 BWEBA[21] SDL400W20S_NAIN1
XAINBWEBA22 BWEBA[22] SDL400W20S_NAIN1
XAINBWEBA23 BWEBA[23] SDL400W20S_NAIN1
XAINBWEBA24 BWEBA[24] SDL400W20S_NAIN1
XAINBWEBA25 BWEBA[25] SDL400W20S_NAIN1
XAINBWEBA26 BWEBA[26] SDL400W20S_NAIN1
XAINBWEBA27 BWEBA[27] SDL400W20S_NAIN1
XAINBWEBA28 BWEBA[28] SDL400W20S_NAIN1
XAINBWEBA29 BWEBA[29] SDL400W20S_NAIN1
XAINBWEBA30 BWEBA[30] SDL400W20S_NAIN1
XAINBWEBA31 BWEBA[31] SDL400W20S_NAIN1
XAINWEBA WEBA SDL400W20S_NAIN1
XAINCEBA CEBA SDL400W20S_NAIN1
XAINCLKA CLKA SDL400W20S_NAIN1
XAINAB0 AB[0] SDL400W20S_NAIN1
XAINAB1 AB[1] SDL400W20S_NAIN1
XAINAB2 AB[2] SDL400W20S_NAIN1
XAINAB3 AB[3] SDL400W20S_NAIN1
XAINAB4 AB[4] SDL400W20S_NAIN1
XAINAB5 AB[5] SDL400W20S_NAIN1
XAINAB6 AB[6] SDL400W20S_NAIN1
XAINAB7 AB[7] SDL400W20S_NAIN1
XAINAB8 AB[8] SDL400W20S_NAIN1
XAINAB9 AB[9] SDL400W20S_NAIN1
XAINDB0 DB[0] SDL400W20S_NAIN1
XAINDB1 DB[1] SDL400W20S_NAIN1
XAINDB2 DB[2] SDL400W20S_NAIN1
XAINDB3 DB[3] SDL400W20S_NAIN1
XAINDB4 DB[4] SDL400W20S_NAIN1
XAINDB5 DB[5] SDL400W20S_NAIN1
XAINDB6 DB[6] SDL400W20S_NAIN1
XAINDB7 DB[7] SDL400W20S_NAIN1
XAINDB8 DB[8] SDL400W20S_NAIN1
XAINDB9 DB[9] SDL400W20S_NAIN1
XAINDB10 DB[10] SDL400W20S_NAIN1
XAINDB11 DB[11] SDL400W20S_NAIN1
XAINDB12 DB[12] SDL400W20S_NAIN1
XAINDB13 DB[13] SDL400W20S_NAIN1
XAINDB14 DB[14] SDL400W20S_NAIN1
XAINDB15 DB[15] SDL400W20S_NAIN1
XAINDB16 DB[16] SDL400W20S_NAIN1
XAINDB17 DB[17] SDL400W20S_NAIN1
XAINDB18 DB[18] SDL400W20S_NAIN1
XAINDB19 DB[19] SDL400W20S_NAIN1
XAINDB20 DB[20] SDL400W20S_NAIN1
XAINDB21 DB[21] SDL400W20S_NAIN1
XAINDB22 DB[22] SDL400W20S_NAIN1
XAINDB23 DB[23] SDL400W20S_NAIN1
XAINDB24 DB[24] SDL400W20S_NAIN1
XAINDB25 DB[25] SDL400W20S_NAIN1
XAINDB26 DB[26] SDL400W20S_NAIN1
XAINDB27 DB[27] SDL400W20S_NAIN1
XAINDB28 DB[28] SDL400W20S_NAIN1
XAINDB29 DB[29] SDL400W20S_NAIN1
XAINDB30 DB[30] SDL400W20S_NAIN1
XAINDB31 DB[31] SDL400W20S_NAIN1
XAINBWEBB0 BWEBB[0] SDL400W20S_NAIN1
XAINBWEBB1 BWEBB[1] SDL400W20S_NAIN1
XAINBWEBB2 BWEBB[2] SDL400W20S_NAIN1
XAINBWEBB3 BWEBB[3] SDL400W20S_NAIN1
XAINBWEBB4 BWEBB[4] SDL400W20S_NAIN1
XAINBWEBB5 BWEBB[5] SDL400W20S_NAIN1
XAINBWEBB6 BWEBB[6] SDL400W20S_NAIN1
XAINBWEBB7 BWEBB[7] SDL400W20S_NAIN1
XAINBWEBB8 BWEBB[8] SDL400W20S_NAIN1
XAINBWEBB9 BWEBB[9] SDL400W20S_NAIN1
XAINBWEBB10 BWEBB[10] SDL400W20S_NAIN1
XAINBWEBB11 BWEBB[11] SDL400W20S_NAIN1
XAINBWEBB12 BWEBB[12] SDL400W20S_NAIN1
XAINBWEBB13 BWEBB[13] SDL400W20S_NAIN1
XAINBWEBB14 BWEBB[14] SDL400W20S_NAIN1
XAINBWEBB15 BWEBB[15] SDL400W20S_NAIN1
XAINBWEBB16 BWEBB[16] SDL400W20S_NAIN1
XAINBWEBB17 BWEBB[17] SDL400W20S_NAIN1
XAINBWEBB18 BWEBB[18] SDL400W20S_NAIN1
XAINBWEBB19 BWEBB[19] SDL400W20S_NAIN1
XAINBWEBB20 BWEBB[20] SDL400W20S_NAIN1
XAINBWEBB21 BWEBB[21] SDL400W20S_NAIN1
XAINBWEBB22 BWEBB[22] SDL400W20S_NAIN1
XAINBWEBB23 BWEBB[23] SDL400W20S_NAIN1
XAINBWEBB24 BWEBB[24] SDL400W20S_NAIN1
XAINBWEBB25 BWEBB[25] SDL400W20S_NAIN1
XAINBWEBB26 BWEBB[26] SDL400W20S_NAIN1
XAINBWEBB27 BWEBB[27] SDL400W20S_NAIN1
XAINBWEBB28 BWEBB[28] SDL400W20S_NAIN1
XAINBWEBB29 BWEBB[29] SDL400W20S_NAIN1
XAINBWEBB30 BWEBB[30] SDL400W20S_NAIN1
XAINBWEBB31 BWEBB[31] SDL400W20S_NAIN1
XAINWEBB WEBB SDL400W20S_NAIN1
XAINCEBB CEBB SDL400W20S_NAIN1
XAINCLKB CLKB SDL400W20S_NAIN1
XARRAY VLO VLO VLO AA[9] AA[8] AA[7] AA[6] AA[5] AA[4] AA[3] AA[2] VLO VLO VLO
+ AA[1] AA[0] DA[31] DA[30] DA[29] DA[28] DA[27] DA[26] DA[25] DA[24] DA[23]
+ DA[22] DA[21] DA[20] DA[19] DA[18] DA[17] DA[16] DA[15] DA[14] DA[13] DA[12]
+ DA[11] DA[10] DA[9] DA[8] DA[7] DA[6] DA[5] DA[4] DA[3] DA[2] DA[1] DA[0]
+ BWEBA[31] BWEBA[30] BWEBA[29] BWEBA[28] BWEBA[27] BWEBA[26] BWEBA[25]
+ BWEBA[24] BWEBA[23] BWEBA[22] BWEBA[21] BWEBA[20] BWEBA[19] BWEBA[18]
+ BWEBA[17] BWEBA[16] BWEBA[15] BWEBA[14] BWEBA[13] BWEBA[12] BWEBA[11]
+ BWEBA[10] BWEBA[9] BWEBA[8] BWEBA[7] BWEBA[6] BWEBA[5] BWEBA[4] BWEBA[3]
+ BWEBA[2] BWEBA[1] BWEBA[0] WEBA CEBA CLKA VLO VLO VLO AB[9] AB[8] AB[7] AB[6]
+ AB[5] AB[4] AB[3] AB[2] VLO VLO VLO AB[1] AB[0] DB[31] DB[30] DB[29] DB[28]
+ DB[27] DB[26] DB[25] DB[24] DB[23] DB[22] DB[21] DB[20] DB[19] DB[18] DB[17]
+ DB[16] DB[15] DB[14] DB[13] DB[12] DB[11] DB[10] DB[9] DB[8] DB[7] DB[6]
+ DB[5] DB[4] DB[3] DB[2] DB[1] DB[0] BWEBB[31] BWEBB[30] BWEBB[29] BWEBB[28]
+ BWEBB[27] BWEBB[26] BWEBB[25] BWEBB[24] BWEBB[23] BWEBB[22] BWEBB[21]
+ BWEBB[20] BWEBB[19] BWEBB[18] BWEBB[17] BWEBB[16] BWEBB[15] BWEBB[14]
+ BWEBB[13] BWEBB[12] BWEBB[11] BWEBB[10] BWEBB[9] BWEBB[8] BWEBB[7] BWEBB[6]
+ BWEBB[5] BWEBB[4] BWEBB[3] BWEBB[2] BWEBB[1] BWEBB[0] WEBB CEBB CLKB VLO VLO
+ VLO VLO VLO VLO VLO VLO VLO VLO VLO VLO VLO VLO VLO VLO VLO VLO VLO VLO VLO
+ VLO VLO VLO VLO VLO VLO VLO VLO VLO VLO VLO VLO VLO VLO VLO VLO VLO VLO VLO
+ VLO VLO VLO VLO VLO VLO VLO VLO VLO VLO VLO VLO VLO VLO VLO VLO VLO VLO VLO
+ VLO VLO VLO VLO VLO VLO VLO VLO VLO VLO VLO VLO VLO VLO VLO VLO VLO VLO VLO
+ VLO VLO VLO VLO VLO VLO VLO VLO VLO VLO VLO VLO VLO VLO VLO VLO VLO VLO VLO
+ VLO VLO VLO VLO VLO VLO VLO VLO VLO VLO VLO VLO VLO VLO VLO VLO VLO VLO VLO
+ VLO VLO VLO VLO VLO VLO VLO VLO VLO VLO VLO VLO VLO VLO VLO VLO VLO VLO VLO
+ VLO VLO VLO VLO VLO VLO VLO VLO VLO VLO VLO VLO VLO VLO VLO VLO VLO VLO VLO
+ VLO VLO VLO VLO VLO VLO VLO VLO VLO VLO VLO VLO VLO VLO VHI VLO VLO VHI VHI
+ VLO VLO VHI VHI VHI VHI QA[31] QA[30] QA[29] QA[28] QA[27] QA[26] QA[25]
+ QA[24] QA[23] QA[22] QA[21] QA[20] QA[19] QA[18] QA[17] QA[16] QA[15] QA[14]
+ QA[13] QA[12] QA[11] QA[10] QA[9] QA[8] QA[7] QA[6] QA[5] QA[4] QA[3] QA[2]
+ QA[1] QA[0] QB[31] QB[30] QB[29] QB[28] QB[27] QB[26] QB[25] QB[24] QB[23]
+ QB[22] QB[21] QB[20] QB[19] QB[18] QB[17] QB[16] QB[15] QB[14] QB[13] QB[12]
+ QB[11] QB[10] QB[9] QB[8] QB[7] QB[6] QB[5] QB[4] QB[3] QB[2] QB[1] QB[0] VHI
+ VLO SDL400W20S_NARRAY
.ENDS
