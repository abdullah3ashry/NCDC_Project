.SUBCKT rnpolywo PLUS MINUS
.ENDS rnpolywo

.SUBCKT rppolywo PLUS MINUS
.ENDS rppolywo
